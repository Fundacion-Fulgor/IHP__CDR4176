** sch_path: CDR4176-main/schematic/xschem/MUX_4_1/MUX_4_1.sch
**.subckt MUX_4_1 VINA VINB VDD VOUT VS[1],VS[0] VINC VSS VIND VST
*.opin VOUT
*.iopin VDD
*.iopin VSS
*.ipin VINA
*.ipin VINB
*.ipin VINC
*.ipin VIND
*.ipin VS[1],VS[0]
*.ipin VST
x3 VDD VINC net2 VS[1] VIND VSS MUX_2_1
x4 VDD VINA net1 VS[0] VINB VSS MUX_2_1
x5 VDD net1 VOUT VST net2 VSS MUX_2_1
**.ends

* expanding   symbol:  CDR4176-main/schematic/xschem/MUX_2_1/MUX_2_1.sym # of pins=6
** sym_path: CDR4176-main/schematic/xschem/MUX_2_1/MUX_2_1.sym
** sch_path: CDR4176-main/schematic/xschem/MUX_2_1/MUX_2_1.sch
.subckt MUX_2_1 VDD VINA VOUT VS VINB VSS
*.opin VOUT
*.ipin VINA
*.ipin VINB
*.ipin VS
*.iopin VDD
*.iopin VSS
x1 VOUT net1 VS VINA VDD VSS tg_custom
x2 VOUT VS net1 VINB VDD VSS tg_custom
x3 VDD net1 VS VSS inv
.ends

* expanding   symbol:  CDR4176-main/schematic/xschem/tg_custom/tg_custom.sym # of pins=6
** sym_path: CDR4176-main/schematic/xschem/tg_custom/tg_custom.sym
** sch_path: CDR4176-main/schematic/xschem/tg_custom/tg_custom.sch
.subckt tg_custom VOUT VSN VSP VIN VBP VBN
*.iopin VIN
*.iopin VSN
*.iopin VOUT
*.iopin VSP
*.iopin VBN
*.iopin VBP
XM1 VOUT VSN VIN VBN sg13_lv_nmos w=0.15u l=0.13u ng=1 m=1
XM2 VOUT VSP VIN VBP sg13_lv_pmos w=0.15u l=0.13u ng=1 m=2
.ends

* expanding   symbol:  CDR4176-main/schematic/xschem/inv/inv.sym # of pins=4
** sym_path: CDR4176-main/schematic/xschem/inv/inv.sym
** sch_path: CDR4176-main/schematic/xschem/inv/inv.sch
.subckt inv VDD VOUT VIN VSS
*.iopin VDD
*.iopin VSS
*.opin VOUT
*.ipin VIN
XM2 VOUT VIN VDD VDD sg13_lv_pmos w=0.15u l=0.13u ng=1 m=2
XM1 VOUT VIN VSS VSS sg13_lv_nmos w=0.15u l=0.13u ng=1 m=1
.ends

.end

** sch_path: CDR4176-main/schematic/xschem/8xPI_logic/8xPI_logic.sch
**.subckt 8xPI_logic S[4],S[3] VSS STQ[7],STQ[6],STQ[5],STQ[4],STQ[3],STQ[2],STQ[1] ST[7],ST[6],ST[5],ST[4],ST[3],ST[2],ST[1] VDD
*+ SQ[2],SQ[1],SQ[0]
*.ipin S[4],S[3]
*.iopin VSS
*.opin STQ[7],STQ[6],STQ[5],STQ[4],STQ[3],STQ[2],STQ[1]
*.ipin ST[7],ST[6],ST[5],ST[4],ST[3],ST[2],ST[1]
*.iopin VDD
*.opin SQ[2],SQ[1],SQ[0]
x1 VDD net1 Sbuff[4] VSS inv
x2 VDD SQ[1] net1 VSS inv
x3 VDD S[3] VSS SQ[0] S[4] xor_custom
x4 VDD net2 S[3] VSS inv
x5 VDD SQ[2] net2 VSS inv
x6[6] VDD SCb[7] Sbuff[4] VSS inv
x6[5] VDD SCb[6] Sbuff[4] VSS inv
x6[4] VDD SCb[5] Sbuff[4] VSS inv
x6[3] VDD SCb[4] Sbuff[4] VSS inv
x6[2] VDD SCb[3] Sbuff[4] VSS inv
x6[1] VDD SCb[2] Sbuff[4] VSS inv
x6[0] VDD SCb[1] Sbuff[4] VSS inv
x7[6] VDD SC[7] SCb[7] VSS inv
x7[5] VDD SC[6] SCb[6] VSS inv
x7[4] VDD SC[5] SCb[5] VSS inv
x7[3] VDD SC[4] SCb[4] VSS inv
x7[2] VDD SC[3] SCb[3] VSS inv
x7[1] VDD SC[2] SCb[2] VSS inv
x7[0] VDD SC[1] SCb[1] VSS inv
x1[6] VDD ST[7] VSS STQ[7] SC[7] xor_custom
x1[5] VDD ST[6] VSS STQ[6] SC[6] xor_custom
x1[4] VDD ST[5] VSS STQ[5] SC[5] xor_custom
x1[3] VDD ST[4] VSS STQ[4] SC[4] xor_custom
x1[2] VDD ST[3] VSS STQ[3] SC[3] xor_custom
x1[1] VDD ST[2] VSS STQ[2] SC[2] xor_custom
x1[0] VDD ST[1] VSS STQ[1] SC[1] xor_custom
x6 VDD Sbuff[4] S[4] VSS buff_d8
**.ends

* expanding   symbol:  CDR4176-main/schematic/xschem/inv/inv.sym # of pins=4
** sym_path: CDR4176-main/schematic/xschem/inv/inv.sym
** sch_path: CDR4176-main/schematic/xschem/inv/inv.sch
.subckt inv VDD VOUT VIN VSS
*.iopin VDD
*.iopin VSS
*.opin VOUT
*.ipin VIN
XM2 VOUT VIN VDD VDD sg13_lv_pmos w=0.15u l=0.13u ng=1 m=1
XM1 VOUT VIN VSS VSS sg13_lv_nmos w=0.15u l=0.13u ng=1 m=1
.ends

* expanding   symbol:  CDR4176-main/schematic/xschem/xor_custom/xor_custom.sym # of pins=5
** sym_path: CDR4176-main/schematic/xschem/xor_custom/xor_custom.sym
** sch_path: CDR4176-main/schematic/xschem/xor_custom/xor_custom.sch
.subckt xor_custom VDD B VSS VOUT A
*.ipin A
*.ipin B
*.opin VOUT
*.iopin VDD
*.iopin VSS
x1 VDD Bb B VSS inv
x2 B VOUT A Bb inv
x3 A Bb B VOUT net1 net2 tg_custom
.ends

* expanding   symbol:  CDR4176-main/schematic/xschem/buff_d8/buff_d8.sym # of pins=4
** sym_path: CDR4176-main/schematic/xschem/buff_d8/buff_d8.sym
** sch_path: CDR4176-main/schematic/xschem/buff_d8/buff_d8.sch
.subckt buff_d8 VDD VOUT VIN VSS
*.ipin VIN
*.opin VOUT
*.iopin VDD
*.iopin VSS
x7 VDD net1 VIN VSS inv
x8 VDD net2 net1 VSS inv_d2
x9 VDD net3 net2 VSS inv_d4
x10 VDD VOUT net3 VSS inv_d8
.ends

* expanding   symbol:  CDR4176-main/schematic/xschem/tg_custom/tg_custom.sym # of pins=6
** sym_path: CDR4176-main/schematic/xschem/tg_custom/tg_custom.sym
** sch_path: CDR4176-main/schematic/xschem/tg_custom/tg_custom.sch
.subckt tg_custom VOUT VSN VSP VIN VBP VBN
*.iopin VIN
*.iopin VSN
*.iopin VOUT
*.iopin VSP
*.iopin VBN
*.iopin VBP
XM1 VOUT VSN VIN VBN sg13_lv_nmos w=0.15u l=0.13u ng=1 m=1
XM2 VOUT VSP VIN VBP sg13_lv_pmos w=0.3u l=0.13u ng=2 m=1
.ends

* expanding   symbol:  CDR4176-main/schematic/xschem/inv_d2/inv_d2.sym # of pins=4
** sym_path: CDR4176-main/schematic/xschem/inv_d2/inv_d2.sym
** sch_path: CDR4176-main/schematic/xschem/inv_d2/inv_d2.sch
.subckt inv_d2 VDD VOUT VIN VSS
*.ipin VIN
*.opin VOUT
*.iopin VDD
*.iopin VSS
x1[1] VDD VOUT VIN VSS inv
x1[0] VDD VOUT VIN VSS inv
.ends

* expanding   symbol:  CDR4176-main/schematic/xschem/inv_d4/inv_d4.sym # of pins=4
** sym_path: CDR4176-main/schematic/xschem/inv_d4/inv_d4.sym
** sch_path: CDR4176-main/schematic/xschem/inv_d4/inv_d4.sch
.subckt inv_d4 VDD VOUT VIN VSS
*.ipin VIN
*.opin VOUT
*.iopin VDD
*.iopin VSS
x1[1] VDD VOUT VIN VSS inv_d2
x1[0] VDD VOUT VIN VSS inv_d2
.ends

* expanding   symbol:  CDR4176-main/schematic/xschem/inv_d8/inv_d8.sym # of pins=4
** sym_path: CDR4176-main/schematic/xschem/inv_d8/inv_d8.sym
** sch_path: CDR4176-main/schematic/xschem/inv_d8/inv_d8.sch
.subckt inv_d8 VDD VOUT VIN VSS
*.ipin VIN
*.opin VOUT
*.iopin VDD
*.iopin VSS
x1[1] VDD VOUT VIN VSS inv_d4
x1[0] VDD VOUT VIN VSS inv_d4
.ends

.end

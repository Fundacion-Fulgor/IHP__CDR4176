* NGSPICE file created from 6ph_rosc.ext - technology: ihp-sg13g2

.subckt 6ph_rosc_pex CTRL PH0 PH3 PH2 PH5 PH4 PH1 VSS VDD
X0 psdiff_1.VOUTDP psdiff_1.buff_d8_0.inv_d8_0.VIN VDD.t14 VDD.t0 sg13_lv_pmos ad=55.5f pd=0.74u as=0.1005p ps=1.34u w=0.15u l=0.13u
X1 CTRL.t0 PH4.t10 CTRL.t0 VDD.t30 sg13_lv_pmos ad=0.19p pd=1.38u as=0 ps=0 w=1u l=0.13u
X2 VSS.t451 psdiff_0.buff_d8_1.inv_d8_0.VIN psdiff_2.CLKP.t6 VSS.t450 sg13_lv_nmos ad=0.1005p pd=1.34u as=55.5f ps=0.74u w=0.15u l=0.13u
X3 VDD.t2 psdiff_0.buff_d8_0.inv_d2_0.VIN psdiff_0.buff_d8_0.inv_d4_0.VIN VDD.t0 sg13_lv_pmos ad=0.1005p pd=1.34u as=55.5f ps=0.74u w=0.15u l=0.13u
X4 psdiff_2.buff_d8_1.VIN.t16 psdiff_2.CLKP.t8 VSS.t458 VSS.t468 sg13_lv_nmos ad=55.5f pd=0.74u as=55.5f ps=0.74u w=0.15u l=0.13u
X5 VSS.t364 psdiff_0.buff_d8_1.inv_d2_0.VIN psdiff_0.buff_d8_1.inv_d4_0.VIN VSS.t363 sg13_lv_nmos ad=0.1005p pd=1.34u as=55.5f ps=0.74u w=0.15u l=0.13u
X6 VSS.t407 psdiff_2.CLKN psdiff_2.buff_d8_0.VIN.t5 VSS.t373 sg13_lv_nmos ad=55.5f pd=0.74u as=55.5f ps=0.74u w=0.15u l=0.13u
X7 VDD.t156 buff_d8_2.inv_d8_0.VIN PH4.t5 VDD.t149 sg13_lv_pmos ad=0.1005p pd=1.34u as=55.5f ps=0.74u w=0.15u l=0.13u
X8 psdiff_2.VOUTDP psdiff_2.buff_d8_0.inv_d8_0.VIN VSS.t43 VSS.t42 sg13_lv_nmos ad=55.5f pd=0.74u as=0.1005p ps=1.34u w=0.15u l=0.13u
X9 CTRL.t16 PH5.t10 CTRL.t16 VDD.t38 sg13_lv_pmos ad=0.19p pd=1.38u as=0 ps=0 w=1u l=0.13u
X10 psdiff_0.buff_d8_1.inv_d8_0.VIN psdiff_0.buff_d8_1.inv_d4_0.VIN VSS.t372 VSS.t371 sg13_lv_nmos ad=55.5f pd=0.74u as=0.1005p ps=1.34u w=0.15u l=0.13u
X11 psdiff_0.buff_d8_0.VIN.t18 psdiff_1.VOUTDP VSS.t333 VSS.t151 sg13_lv_nmos ad=55.5f pd=0.74u as=55.5f ps=0.74u w=0.15u l=0.13u
X12 VSS.t109 psdiff_1.VOUTDN psdiff_0.buff_d8_1.VIN.t4 VSS.t112 sg13_lv_nmos ad=55.5f pd=0.74u as=55.5f ps=0.74u w=0.15u l=0.13u
X13 CTRL.t11 PH3.t10 CTRL.t11 VDD.t61 sg13_lv_pmos ad=0.19p pd=1.38u as=0 ps=0 w=1u l=0.13u
X14 CTRL.t22 PH2.t10 CTRL.t22 VDD.t41 sg13_lv_pmos ad=0.19p pd=1.38u as=0 ps=0 w=1u l=0.13u
X15 VDD.t74 psdiff_1.buff_d8_1.inv_d4_0.VIN psdiff_1.buff_d8_1.inv_d8_0.VIN VDD.t33 sg13_lv_pmos ad=0.1005p pd=1.34u as=55.5f ps=0.74u w=0.15u l=0.13u
X16 VDD.t286 VSS.t610 psdiff_2.buff_d8_1.VIN.t24 VDD.t169 sg13_lv_pmos ad=55.5f pd=0.74u as=55.5f ps=0.74u w=0.15u l=0.13u
X17 CTRL.t11 PH3.t10 CTRL.t11 VDD.t60 sg13_lv_pmos ad=0.19p pd=1.38u as=0 ps=0 w=1u l=0.13u
X18 psdiff_2.VOUTDN psdiff_2.buff_d8_1.inv_d8_0.VIN VDD.t90 VDD.t33 sg13_lv_pmos ad=55.5f pd=0.74u as=0.1005p ps=1.34u w=0.15u l=0.13u
X19 VDD.t297 VSS.t610 psdiff_2.buff_d8_0.VIN.t24 VDD.t169 sg13_lv_pmos ad=55.5f pd=0.74u as=55.5f ps=0.74u w=0.15u l=0.13u
X20 CTRL.t22 PH2.t10 CTRL.t22 VDD.t55 sg13_lv_pmos ad=0.19p pd=1.38u as=0 ps=0 w=1u l=0.13u
X21 VSS.t427 buff_d8_2.inv_d8_0.VIN PH4.t9 VSS.t426 sg13_lv_nmos ad=0.1005p pd=1.34u as=55.5f ps=0.74u w=0.15u l=0.13u
X22 VDD.t99 buff_d8_1.inv_d8_0.VIN PH5.t5 VDD.t23 sg13_lv_pmos ad=0.1005p pd=1.34u as=55.5f ps=0.74u w=0.15u l=0.13u
X23 VSS.t330 psdiff_1.VOUTDP psdiff_0.buff_d8_0.VIN.t11 VSS.t324 sg13_lv_nmos ad=55.5f pd=0.74u as=55.5f ps=0.74u w=0.15u l=0.13u
X24 psdiff_1.buff_d8_0.VIN.t11 psdiff_2.VOUTDP VSS.t82 VSS.t69 sg13_lv_nmos ad=55.5f pd=0.74u as=55.5f ps=0.74u w=0.15u l=0.13u
X25 VSS.t260 psdiff_2.VOUTDN psdiff_1.buff_d8_1.VIN.t7 VSS.t235 sg13_lv_nmos ad=55.5f pd=0.74u as=55.5f ps=0.74u w=0.15u l=0.13u
X26 VSS.t233 psdiff_2.buff_d8_1.inv_d8_0.VIN psdiff_2.VOUTDN VSS.t232 sg13_lv_nmos ad=0.1005p pd=1.34u as=55.5f ps=0.74u w=0.15u l=0.13u
X27 VDD.t173 a_1214_1266# psdiff_2.buff_d8_1.VIN.t31 VDD.t169 sg13_lv_pmos ad=55.5f pd=0.74u as=55.5f ps=0.74u w=0.15u l=0.13u
X28 psdiff_1.buff_d8_1.VIN.t26 VSS.t611 VDD.t343 VDD.t129 sg13_lv_pmos ad=55.5f pd=0.74u as=55.5f ps=0.74u w=0.15u l=0.13u
X29 VDD.t345 VSS.t611 psdiff_1.buff_d8_0.VIN.t31 VDD.t129 sg13_lv_pmos ad=55.5f pd=0.74u as=55.5f ps=0.74u w=0.15u l=0.13u
X30 psdiff_2.CLKN psdiff_0.buff_d8_0.inv_d8_0.VIN VSS.t505 VSS.t504 sg13_lv_nmos ad=55.5f pd=0.74u as=0.1005p ps=1.34u w=0.15u l=0.13u
X31 psdiff_1.VOUTDP psdiff_1.buff_d8_0.inv_d8_0.VIN VDD.t13 VDD.t0 sg13_lv_pmos ad=55.5f pd=0.74u as=0.1005p ps=1.34u w=0.15u l=0.13u
X32 VSS.t477 psdiff_2.CLKP.t8 psdiff_2.buff_d8_1.VIN.t14 VSS.t464 sg13_lv_nmos ad=55.5f pd=0.74u as=55.5f ps=0.74u w=0.15u l=0.13u
X33 CTRL.t3 PH4.t10 CTRL.t3 VDD.t149 sg13_lv_pmos ad=0.19p pd=1.38u as=0 ps=0 w=1u l=0.13u
X34 buff_d8_5.inv_d8_0.VIN buff_d8_5.inv_d4_0.VIN VSS.t513 VSS.t512 sg13_lv_nmos ad=55.5f pd=0.74u as=0.1005p ps=1.34u w=0.15u l=0.13u
X35 VSS.t75 psdiff_2.VOUTDP psdiff_1.buff_d8_0.VIN.t3 VSS.t44 sg13_lv_nmos ad=55.5f pd=0.74u as=55.5f ps=0.74u w=0.15u l=0.13u
X36 CTRL.t13 PH0.t10 CTRL.t13 VDD.t46 sg13_lv_pmos ad=0.19p pd=1.38u as=0 ps=0 w=1u l=0.13u
X37 CTRL.t7 PH4.t10 CTRL.t3 VDD.t149 sg13_lv_pmos ad=0.34p pd=2.68u as=0 ps=0 w=1u l=0.13u
X38 VDD.t54 psdiff_1.buff_d8_0.VIN.t32 psdiff_1.buff_d8_0.inv_d2_0.VIN VDD.t0 sg13_lv_pmos ad=0.1005p pd=1.34u as=0.1005p ps=1.34u w=0.15u l=0.13u
X39 VDD.t295 VSS.t610 psdiff_2.buff_d8_0.VIN.t26 VDD.t169 sg13_lv_pmos ad=55.5f pd=0.74u as=55.5f ps=0.74u w=0.15u l=0.13u
X40 buff_d8_3.inv_d8_0.VIN buff_d8_3.inv_d4_0.VIN VSS.t541 VSS.t540 sg13_lv_nmos ad=55.5f pd=0.74u as=0.1005p ps=1.34u w=0.15u l=0.13u
X41 psdiff_2.buff_d8_1.VIN.t15 psdiff_2.CLKP.t8 VSS.t470 VSS.t476 sg13_lv_nmos ad=55.5f pd=0.74u as=55.5f ps=0.74u w=0.15u l=0.13u
X42 VDD.t44 PH1.t10 PH4.t0 VDD.t43 sg13_lv_pmos ad=0.1005p pd=1.34u as=55.5f ps=0.74u w=0.15u l=0.13u
X43 VSS.t449 psdiff_0.buff_d8_1.inv_d8_0.VIN psdiff_2.CLKP.t7 VSS.t448 sg13_lv_nmos ad=0.1005p pd=1.34u as=55.5f ps=0.74u w=0.15u l=0.13u
X44 VDD.t296 VSS.t610 psdiff_2.buff_d8_0.VIN.t23 VDD.t169 sg13_lv_pmos ad=55.5f pd=0.74u as=55.5f ps=0.74u w=0.15u l=0.13u
X45 psdiff_0.buff_d8_1.VIN.t23 VSS.t612 VDD.t370 VDD.t108 sg13_lv_pmos ad=55.5f pd=0.74u as=55.5f ps=0.74u w=0.15u l=0.13u
X46 PH1.t9 buff_d8_3.inv_d8_0.VIN VSS.t557 VSS.t556 sg13_lv_nmos ad=55.5f pd=0.74u as=0.1005p ps=1.34u w=0.15u l=0.13u
X47 CTRL.t13 PH0.t10 CTRL.t13 VDD.t46 sg13_lv_pmos ad=0.19p pd=1.38u as=0 ps=0 w=1u l=0.13u
X48 CTRL.t9 PH3.t10 CTRL.t9 VDD.t61 sg13_lv_pmos ad=0.19p pd=1.38u as=0 ps=0 w=1u l=0.13u
X49 VDD.t107 buff_d8_4.inv_d8_0.VIN PH3.t4 VDD.t23 sg13_lv_pmos ad=0.1005p pd=1.34u as=55.5f ps=0.74u w=0.15u l=0.13u
X50 CTRL.t9 PH3.t10 CTRL.t9 VDD.t60 sg13_lv_pmos ad=0.19p pd=1.38u as=0 ps=0 w=1u l=0.13u
X51 VSS.t74 psdiff_2.VOUTDP psdiff_1.buff_d8_0.VIN.t1 VSS.t56 sg13_lv_nmos ad=55.5f pd=0.74u as=55.5f ps=0.74u w=0.15u l=0.13u
X52 VDD.t82 psdiff_1.buff_d8_1.inv_d8_0.VIN psdiff_1.VOUTDN VDD.t33 sg13_lv_pmos ad=0.1005p pd=1.34u as=55.5f ps=0.74u w=0.15u l=0.13u
X53 VSS.t358 psdiff_1.VOUTDP psdiff_0.buff_d8_0.VIN.t13 VSS.t347 sg13_lv_nmos ad=0.1005p pd=1.34u as=55.5f ps=0.74u w=0.15u l=0.13u
X54 psdiff_0.buff_d8_0.VIN.t17 psdiff_1.VOUTDP VSS.t328 VSS.t151 sg13_lv_nmos ad=55.5f pd=0.74u as=55.5f ps=0.74u w=0.15u l=0.13u
X55 psdiff_1.buff_d8_1.VIN.t16 psdiff_2.VOUTDN VSS.t241 VSS.t252 sg13_lv_nmos ad=55.5f pd=0.74u as=55.5f ps=0.74u w=0.15u l=0.13u
X56 VSS.t529 buff_d8_5.inv_d8_0.VIN PH0.t9 VSS.t528 sg13_lv_nmos ad=0.1005p pd=1.34u as=55.5f ps=0.74u w=0.15u l=0.13u
X57 VSS.t110 psdiff_1.VOUTDN psdiff_0.buff_d8_1.VIN.t2 VSS.t112 sg13_lv_nmos ad=55.5f pd=0.74u as=55.5f ps=0.74u w=0.15u l=0.13u
X58 VDD.t116 a_6005_1122# psdiff_0.buff_d8_0.VIN.t6 VDD.t108 sg13_lv_pmos ad=55.5f pd=0.74u as=55.5f ps=0.74u w=0.15u l=0.13u
X59 buff_d8_4.inv_d2_0.VIN psdiff_2.VOUTDP VSS.t79 VSS.t78 sg13_lv_nmos ad=0.1005p pd=1.34u as=0.1005p ps=1.34u w=0.15u l=0.13u
X60 psdiff_2.buff_d8_0.VIN.t16 psdiff_2.CLKN VSS.t378 VSS.t387 sg13_lv_nmos ad=55.5f pd=0.74u as=55.5f ps=0.74u w=0.15u l=0.13u
X61 VSS.t405 psdiff_2.CLKN psdiff_2.buff_d8_0.VIN.t3 VSS.t146 sg13_lv_nmos ad=55.5f pd=0.74u as=55.5f ps=0.74u w=0.15u l=0.13u
X62 psdiff_1.buff_d8_0.VIN.t10 psdiff_2.VOUTDP VSS.t77 VSS.t69 sg13_lv_nmos ad=55.5f pd=0.74u as=55.5f ps=0.74u w=0.15u l=0.13u
X63 buff_d8_5.inv_d4_0.VIN buff_d8_5.inv_d2_0.VIN VSS.t311 VSS.t310 sg13_lv_nmos ad=55.5f pd=0.74u as=0.1005p ps=1.34u w=0.15u l=0.13u
X64 PH4.t8 buff_d8_2.inv_d8_0.VIN VSS.t425 VSS.t424 sg13_lv_nmos ad=55.5f pd=0.74u as=0.1005p ps=1.34u w=0.15u l=0.13u
X65 psdiff_0.buff_d8_0.VIN.t25 VSS.t612 VDD.t371 VDD.t108 sg13_lv_pmos ad=55.5f pd=0.74u as=55.5f ps=0.74u w=0.15u l=0.13u
X66 PH5.t4 buff_d8_1.inv_d8_0.VIN VDD.t98 VDD.t23 sg13_lv_pmos ad=55.5f pd=0.74u as=0.1005p ps=1.34u w=0.15u l=0.13u
X67 CTRL.t2 PH4.t10 CTRL.t2 VDD.t149 sg13_lv_pmos ad=0.19p pd=1.38u as=0 ps=0 w=1u l=0.13u
X68 buff_d8_1.inv_d4_0.VIN buff_d8_1.inv_d2_0.VIN VDD.t124 VDD.t23 sg13_lv_pmos ad=55.5f pd=0.74u as=0.1005p ps=1.34u w=0.15u l=0.13u
X69 psdiff_0.buff_d8_0.VIN.t31 VSS.t612 VDD.t391 VDD.t108 sg13_lv_pmos ad=55.5f pd=0.74u as=0.1005p ps=1.34u w=0.15u l=0.13u
X70 VDD.t131 a_3031_1122# psdiff_1.buff_d8_0.VIN.t19 VDD.t129 sg13_lv_pmos ad=55.5f pd=0.74u as=55.5f ps=0.74u w=0.15u l=0.13u
X71 CTRL.t11 PH0.t10 CTRL.t11 VDD.t46 sg13_lv_pmos ad=0.19p pd=1.38u as=0 ps=0 w=1u l=0.13u
X72 psdiff_0.buff_d8_0.VIN.t23 VSS.t612 VDD.t369 VDD.t108 sg13_lv_pmos ad=55.5f pd=0.74u as=55.5f ps=0.74u w=0.15u l=0.13u
X73 CTRL.t6 PH4.t10 CTRL.t2 VDD.t149 sg13_lv_pmos ad=0.34p pd=2.68u as=0 ps=0 w=1u l=0.13u
X74 VSS.t565 psdiff_2.buff_d8_1.inv_d4_0.VIN psdiff_2.buff_d8_1.inv_d8_0.VIN VSS.t564 sg13_lv_nmos ad=0.1005p pd=1.34u as=55.5f ps=0.74u w=0.15u l=0.13u
X75 VSS.t323 buff_d8_1.inv_d4_0.VIN buff_d8_1.inv_d8_0.VIN VSS.t322 sg13_lv_nmos ad=0.1005p pd=1.34u as=55.5f ps=0.74u w=0.15u l=0.13u
X76 buff_d8_4.inv_d4_0.VIN buff_d8_4.inv_d2_0.VIN VSS.t307 VSS.t306 sg13_lv_nmos ad=55.5f pd=0.74u as=0.1005p ps=1.34u w=0.15u l=0.13u
X77 VSS.t145 PH4.t11 PH1.t1 VSS.t144 sg13_lv_nmos ad=0.1005p pd=1.34u as=55.5f ps=0.74u w=0.15u l=0.13u
X78 psdiff_2.buff_d8_1.VIN.t13 psdiff_2.CLKP.t8 VSS.t465 VSS.t476 sg13_lv_nmos ad=55.5f pd=0.74u as=55.5f ps=0.74u w=0.15u l=0.13u
X79 PH0.t5 buff_d8_5.inv_d8_0.VIN VDD.t200 VDD.t46 sg13_lv_pmos ad=55.5f pd=0.74u as=0.1005p ps=1.34u w=0.15u l=0.13u
X80 VSS.t353 psdiff_1.VOUTDP psdiff_0.buff_d8_0.VIN.t8 VSS.t338 sg13_lv_nmos ad=55.5f pd=0.74u as=55.5f ps=0.74u w=0.15u l=0.13u
X81 VSS.t266 psdiff_2.VOUTDN psdiff_1.buff_d8_1.VIN.t4 VSS.t251 sg13_lv_nmos ad=55.5f pd=0.74u as=55.5f ps=0.74u w=0.15u l=0.13u
X82 psdiff_2.buff_d8_1.VIN.t26 VSS.t610 VDD.t301 VDD.t169 sg13_lv_pmos ad=55.5f pd=0.74u as=55.5f ps=0.74u w=0.15u l=0.13u
X83 psdiff_0.buff_d8_1.VIN.t0 psdiff_1.VOUTDN VSS.t90 VSS.t96 sg13_lv_nmos ad=55.5f pd=0.74u as=55.5f ps=0.74u w=0.15u l=0.13u
X84 CTRL.t11 PH0.t10 CTRL.t11 VDD.t46 sg13_lv_pmos ad=0.19p pd=1.38u as=0 ps=0 w=1u l=0.13u
X85 psdiff_1.buff_d8_1.VIN.t1 CTRL.t24 a_3031_1122# VSS.t153 sg13_lv_nmos ad=0.1005p pd=1.34u as=55.5f ps=0.74u w=0.15u l=0.13u
X86 PH1.t8 buff_d8_3.inv_d8_0.VIN VSS.t555 VSS.t554 sg13_lv_nmos ad=55.5f pd=0.74u as=0.1005p ps=1.34u w=0.15u l=0.13u
X87 VDD.t187 psdiff_0.buff_d8_0.inv_d8_0.VIN psdiff_2.CLKN VDD.t0 sg13_lv_pmos ad=0.1005p pd=1.34u as=55.5f ps=0.74u w=0.15u l=0.13u
X88 psdiff_1.VOUTDP psdiff_1.buff_d8_0.inv_d8_0.VIN VSS.t27 VSS.t26 sg13_lv_nmos ad=55.5f pd=0.74u as=0.1005p ps=1.34u w=0.15u l=0.13u
X89 CTRL.t22 PH5.t10 CTRL.t22 VDD.t36 sg13_lv_pmos ad=0.19p pd=1.38u as=0 ps=0 w=1u l=0.13u
X90 VDD.t230 buff_d8_0.inv_d8_0.VIN PH2.t4 VDD.t41 sg13_lv_pmos ad=0.1005p pd=1.34u as=55.5f ps=0.74u w=0.15u l=0.13u
X91 psdiff_2.buff_d8_0.VIN.t15 psdiff_2.CLKN VSS.t374 VSS.t396 sg13_lv_nmos ad=55.5f pd=0.74u as=55.5f ps=0.74u w=0.15u l=0.13u
X92 PH0.t1 PH3.t11 VSS.t177 VSS.t176 sg13_lv_nmos ad=55.5f pd=0.74u as=0.1005p ps=1.34u w=0.15u l=0.13u
X93 VDD.t106 buff_d8_4.inv_d8_0.VIN PH3.t5 VDD.t23 sg13_lv_pmos ad=0.1005p pd=1.34u as=55.5f ps=0.74u w=0.15u l=0.13u
X94 VDD.t57 PH2.t11 PH5.t0 VDD.t56 sg13_lv_pmos ad=0.1005p pd=1.34u as=55.5f ps=0.74u w=0.15u l=0.13u
X95 CTRL.t22 PH5.t10 CTRL.t22 VDD.t38 sg13_lv_pmos ad=0.19p pd=1.38u as=0 ps=0 w=1u l=0.13u
X96 PH4.t4 buff_d8_2.inv_d8_0.VIN VDD.t155 VDD.t61 sg13_lv_pmos ad=55.5f pd=0.74u as=0.1005p ps=1.34u w=0.15u l=0.13u
X97 psdiff_2.buff_d8_1.inv_d8_0.VIN psdiff_2.buff_d8_1.inv_d4_0.VIN VDD.t218 VDD.t33 sg13_lv_pmos ad=55.5f pd=0.74u as=0.1005p ps=1.34u w=0.15u l=0.13u
X98 VDD.t351 VSS.t611 psdiff_1.buff_d8_1.VIN.t24 VDD.t129 sg13_lv_pmos ad=0.1005p pd=1.34u as=55.5f ps=0.74u w=0.15u l=0.13u
X99 VSS.t355 psdiff_1.VOUTDP psdiff_0.buff_d8_0.VIN.t10 VSS.t347 sg13_lv_nmos ad=0.1005p pd=1.34u as=55.5f ps=0.74u w=0.15u l=0.13u
X100 CTRL.t22 PH5.t10 CTRL.t22 VDD.t41 sg13_lv_pmos ad=0.19p pd=1.38u as=0 ps=0 w=1u l=0.13u
X101 CTRL.t3 PH1.t11 CTRL.t3 VDD.t27 sg13_lv_pmos ad=0.19p pd=1.38u as=0 ps=0 w=1u l=0.13u
X102 CTRL.t1 PH4.t10 CTRL.t1 VDD.t149 sg13_lv_pmos ad=0.19p pd=1.38u as=0 ps=0 w=1u l=0.13u
X103 VDD.t146 psdiff_0.buff_d8_1.inv_d4_0.VIN psdiff_0.buff_d8_1.inv_d8_0.VIN VDD.t33 sg13_lv_pmos ad=0.1005p pd=1.34u as=55.5f ps=0.74u w=0.15u l=0.13u
X104 psdiff_0.buff_d8_1.inv_d2_0.VIN psdiff_0.buff_d8_1.VIN.t32 VDD.t59 VDD.t33 sg13_lv_pmos ad=0.1005p pd=1.34u as=0.1005p ps=1.34u w=0.15u l=0.13u
X105 CTRL.t9 PH0.t10 CTRL.t9 VDD.t46 sg13_lv_pmos ad=0.19p pd=1.38u as=0 ps=0 w=1u l=0.13u
X106 CTRL.t5 PH4.t10 CTRL.t1 VDD.t149 sg13_lv_pmos ad=0.34p pd=2.68u as=0 ps=0 w=1u l=0.13u
X107 psdiff_1.buff_d8_0.VIN.t25 VSS.t611 VDD.t336 VDD.t129 sg13_lv_pmos ad=55.5f pd=0.74u as=55.5f ps=0.74u w=0.15u l=0.13u
X108 CTRL.t3 PH1.t11 CTRL.t3 VDD.t30 sg13_lv_pmos ad=0.19p pd=1.38u as=0 ps=0 w=1u l=0.13u
X109 psdiff_1.buff_d8_1.VIN.t31 a_4188_1266# VDD.t238 VDD.t129 sg13_lv_pmos ad=55.5f pd=0.74u as=55.5f ps=0.74u w=0.15u l=0.13u
X110 VDD.t359 VSS.t612 psdiff_0.buff_d8_1.VIN.t26 VDD.t108 sg13_lv_pmos ad=55.5f pd=0.74u as=55.5f ps=0.74u w=0.15u l=0.13u
X111 psdiff_0.buff_d8_0.VIN.t21 psdiff_1.VOUTDP VSS.t84 VSS.t337 sg13_lv_nmos ad=55.5f pd=0.74u as=55.5f ps=0.74u w=0.15u l=0.13u
X112 VDD.t222 buff_d8_4.inv_d4_0.VIN buff_d8_4.inv_d8_0.VIN VDD.t23 sg13_lv_pmos ad=0.1005p pd=1.34u as=55.5f ps=0.74u w=0.15u l=0.13u
X113 VSS.t115 psdiff_1.VOUTDN psdiff_0.buff_d8_1.VIN.t1 VSS.t95 sg13_lv_nmos ad=55.5f pd=0.74u as=55.5f ps=0.74u w=0.15u l=0.13u
X114 CTRL.t9 PH0.t10 CTRL.t9 VDD.t46 sg13_lv_pmos ad=0.19p pd=1.38u as=0 ps=0 w=1u l=0.13u
X115 VSS.t287 buff_d8_1.inv_d8_0.VIN PH5.t8 VSS.t286 sg13_lv_nmos ad=0.1005p pd=1.34u as=55.5f ps=0.74u w=0.15u l=0.13u
X116 VSS.t503 psdiff_0.buff_d8_0.inv_d8_0.VIN psdiff_2.CLKN VSS.t502 sg13_lv_nmos ad=0.1005p pd=1.34u as=55.5f ps=0.74u w=0.15u l=0.13u
X117 psdiff_1.buff_d8_0.VIN.t14 psdiff_2.VOUTDP VSS.t45 VSS.t63 sg13_lv_nmos ad=55.5f pd=0.74u as=55.5f ps=0.74u w=0.15u l=0.13u
X118 VDD.t322 VSS.t611 psdiff_1.buff_d8_1.VIN.t22 VDD.t129 sg13_lv_pmos ad=55.5f pd=0.74u as=55.5f ps=0.74u w=0.15u l=0.13u
X119 psdiff_2.buff_d8_1.VIN.t29 a_1214_1266# VDD.t178 VDD.t169 sg13_lv_pmos ad=55.5f pd=0.74u as=55.5f ps=0.74u w=0.15u l=0.13u
X120 VDD.t331 VSS.t611 psdiff_1.buff_d8_1.VIN.t23 VDD.t129 sg13_lv_pmos ad=55.5f pd=0.74u as=55.5f ps=0.74u w=0.15u l=0.13u
X121 PH5.t9 buff_d8_1.inv_d8_0.VIN VSS.t285 VSS.t284 sg13_lv_nmos ad=55.5f pd=0.74u as=0.1005p ps=1.34u w=0.15u l=0.13u
X122 psdiff_1.buff_d8_0.inv_d4_0.VIN psdiff_1.buff_d8_0.inv_d2_0.VIN VSS.t533 VSS.t532 sg13_lv_nmos ad=55.5f pd=0.74u as=0.1005p ps=1.34u w=0.15u l=0.13u
X123 VSS.t481 psdiff_2.CLKP.t8 psdiff_2.buff_d8_1.VIN.t16 VSS.t152 sg13_lv_nmos ad=55.5f pd=0.74u as=55.5f ps=0.74u w=0.15u l=0.13u
X124 VDD.t214 buff_d8_3.inv_d8_0.VIN PH1.t5 VDD.t23 sg13_lv_pmos ad=0.1005p pd=1.34u as=55.5f ps=0.74u w=0.15u l=0.13u
X125 psdiff_2.buff_d8_0.VIN.t14 psdiff_2.CLKN VSS.t407 VSS.t396 sg13_lv_nmos ad=55.5f pd=0.74u as=55.5f ps=0.74u w=0.15u l=0.13u
X126 CTRL.t8 PH3.t10 CTRL.t8 VDD.t61 sg13_lv_pmos ad=0.19p pd=1.38u as=0 ps=0 w=1u l=0.13u
X127 CTRL.t8 PH3.t10 CTRL.t8 VDD.t60 sg13_lv_pmos ad=0.19p pd=1.38u as=0 ps=0 w=1u l=0.13u
X128 psdiff_1.buff_d8_0.inv_d4_0.VIN psdiff_1.buff_d8_0.inv_d2_0.VIN VDD.t202 VDD.t0 sg13_lv_pmos ad=55.5f pd=0.74u as=0.1005p ps=1.34u w=0.15u l=0.13u
X129 VSS.t605 psdiff_2.buff_d8_0.inv_d4_0.VIN psdiff_2.buff_d8_0.inv_d8_0.VIN VSS.t604 sg13_lv_nmos ad=0.1005p pd=1.34u as=55.5f ps=0.74u w=0.15u l=0.13u
X130 CTRL.t2 PH1.t11 CTRL.t2 VDD.t27 sg13_lv_pmos ad=0.19p pd=1.38u as=0 ps=0 w=1u l=0.13u
X131 VDD.t362 VSS.t612 psdiff_0.buff_d8_0.VIN.t27 VDD.t108 sg13_lv_pmos ad=55.5f pd=0.74u as=55.5f ps=0.74u w=0.15u l=0.13u
X132 CTRL.t8 PH3.t10 CTRL.t8 VDD.t47 sg13_lv_pmos ad=0.19p pd=1.38u as=0 ps=0 w=1u l=0.13u
X133 CTRL.t2 PH1.t11 CTRL.t2 VDD.t30 sg13_lv_pmos ad=0.19p pd=1.38u as=0 ps=0 w=1u l=0.13u
X134 VDD.t117 a_6005_1122# psdiff_0.buff_d8_0.VIN.t5 VDD.t108 sg13_lv_pmos ad=55.5f pd=0.74u as=55.5f ps=0.74u w=0.15u l=0.13u
X135 CTRL.t20 PH2.t10 CTRL.t20 VDD.t55 sg13_lv_pmos ad=0.19p pd=1.38u as=0 ps=0 w=1u l=0.13u
X136 psdiff_2.buff_d8_0.VIN.t28 a_57_1122# VDD.t251 VDD.t169 sg13_lv_pmos ad=55.5f pd=0.74u as=55.5f ps=0.74u w=0.15u l=0.13u
X137 VSS.t117 psdiff_1.VOUTDN buff_d8_2.inv_d2_0.VIN VSS.t116 sg13_lv_nmos ad=0.1005p pd=1.34u as=0.1005p ps=1.34u w=0.15u l=0.13u
X138 psdiff_2.buff_d8_0.VIN.t31 a_57_1122# VDD.t252 VDD.t169 sg13_lv_pmos ad=55.5f pd=0.74u as=55.5f ps=0.74u w=0.15u l=0.13u
X139 VDD.t265 a_7162_1266# psdiff_0.buff_d8_1.VIN.t27 VDD.t108 sg13_lv_pmos ad=55.5f pd=0.74u as=55.5f ps=0.74u w=0.15u l=0.13u
X140 buff_d8_2.inv_d8_0.VIN buff_d8_2.inv_d4_0.VIN VSS.t129 VSS.t128 sg13_lv_nmos ad=55.5f pd=0.74u as=0.1005p ps=1.34u w=0.15u l=0.13u
X141 VDD.t291 VSS.t610 psdiff_2.buff_d8_1.VIN.t23 VDD.t169 sg13_lv_pmos ad=55.5f pd=0.74u as=55.5f ps=0.74u w=0.15u l=0.13u
X142 PH3.t1 PH0.t11 VSS.t159 VSS.t158 sg13_lv_nmos ad=55.5f pd=0.74u as=0.1005p ps=1.34u w=0.15u l=0.13u
X143 VSS.t589 buff_d8_0.inv_d8_0.VIN PH2.t6 VSS.t588 sg13_lv_nmos ad=0.1005p pd=1.34u as=55.5f ps=0.74u w=0.15u l=0.13u
X144 psdiff_1.buff_d8_1.inv_d8_0.VIN psdiff_1.buff_d8_1.inv_d4_0.VIN VSS.t201 VSS.t200 sg13_lv_nmos ad=55.5f pd=0.74u as=0.1005p ps=1.34u w=0.15u l=0.13u
X145 VSS.t133 psdiff_1.buff_d8_1.inv_d2_0.VIN psdiff_1.buff_d8_1.inv_d4_0.VIN VSS.t132 sg13_lv_nmos ad=0.1005p pd=1.34u as=55.5f ps=0.74u w=0.15u l=0.13u
X146 VDD.t177 a_1214_1266# psdiff_2.buff_d8_1.VIN.t30 VDD.t169 sg13_lv_pmos ad=0.1005p pd=1.34u as=55.5f ps=0.74u w=0.15u l=0.13u
X147 VSS.t283 buff_d8_1.inv_d8_0.VIN PH5.t9 VSS.t282 sg13_lv_nmos ad=0.1005p pd=1.34u as=55.5f ps=0.74u w=0.15u l=0.13u
X148 psdiff_1.buff_d8_0.VIN.t13 psdiff_2.VOUTDP VSS.t75 VSS.t63 sg13_lv_nmos ad=55.5f pd=0.74u as=55.5f ps=0.74u w=0.15u l=0.13u
X149 a_57_1122# CTRL.t25 psdiff_2.buff_d8_1.VIN.t1 VSS.t152 sg13_lv_nmos ad=55.5f pd=0.74u as=0.1005p ps=1.34u w=0.15u l=0.13u
X150 VDD.t120 buff_d8_4.inv_d2_0.VIN buff_d8_4.inv_d4_0.VIN VDD.t23 sg13_lv_pmos ad=0.1005p pd=1.34u as=55.5f ps=0.74u w=0.15u l=0.13u
X151 CTRL.t0 PH4.t10 CTRL.t0 VDD.t30 sg13_lv_pmos ad=0.19p pd=1.38u as=0 ps=0 w=1u l=0.13u
X152 VDD.t12 psdiff_1.buff_d8_0.inv_d8_0.VIN psdiff_1.VOUTDP VDD.t0 sg13_lv_pmos ad=0.1005p pd=1.34u as=55.5f ps=0.74u w=0.15u l=0.13u
X153 CTRL.t1 PH1.t11 CTRL.t1 VDD.t27 sg13_lv_pmos ad=0.19p pd=1.38u as=0 ps=0 w=1u l=0.13u
X154 VSS.t181 psdiff_0.buff_d8_0.VIN.t32 psdiff_0.buff_d8_0.inv_d2_0.VIN VSS.t180 sg13_lv_nmos ad=0.1005p pd=1.34u as=0.1005p ps=1.34u w=0.15u l=0.13u
X155 VDD.t213 buff_d8_3.inv_d8_0.VIN PH1.t4 VDD.t23 sg13_lv_pmos ad=0.1005p pd=1.34u as=55.5f ps=0.74u w=0.15u l=0.13u
X156 PH1.t2 buff_d8_3.inv_d8_0.VIN VDD.t212 VDD.t23 sg13_lv_pmos ad=55.5f pd=0.74u as=0.1005p ps=1.34u w=0.15u l=0.13u
X157 CTRL.t1 PH1.t11 CTRL.t1 VDD.t30 sg13_lv_pmos ad=0.19p pd=1.38u as=0 ps=0 w=1u l=0.13u
X158 psdiff_2.buff_d8_1.VIN.t20 VSS.t610 VDD.t285 VDD.t169 sg13_lv_pmos ad=55.5f pd=0.74u as=55.5f ps=0.74u w=0.15u l=0.13u
X159 psdiff_0.buff_d8_1.VIN.t24 VSS.t612 VDD.t378 VDD.t108 sg13_lv_pmos ad=55.5f pd=0.74u as=55.5f ps=0.74u w=0.15u l=0.13u
X160 psdiff_1.buff_d8_0.VIN.t16 CTRL.t24 a_4188_1266# VSS.t46 sg13_lv_nmos ad=0.1005p pd=1.34u as=55.5f ps=0.74u w=0.15u l=0.13u
X161 VDD.t289 VSS.t610 psdiff_2.buff_d8_0.VIN.t25 VDD.t169 sg13_lv_pmos ad=55.5f pd=0.74u as=55.5f ps=0.74u w=0.15u l=0.13u
X162 psdiff_1.VOUTDP psdiff_1.buff_d8_0.inv_d8_0.VIN VSS.t25 VSS.t24 sg13_lv_nmos ad=55.5f pd=0.74u as=0.1005p ps=1.34u w=0.15u l=0.13u
X163 VSS.t41 psdiff_2.buff_d8_0.inv_d8_0.VIN psdiff_2.VOUTDP VSS.t40 sg13_lv_nmos ad=0.1005p pd=1.34u as=55.5f ps=0.74u w=0.15u l=0.13u
X164 psdiff_0.buff_d8_1.VIN.t30 a_7162_1266# VDD.t266 VDD.t108 sg13_lv_pmos ad=55.5f pd=0.74u as=55.5f ps=0.74u w=0.15u l=0.13u
X165 CTRL.t0 PH4.t10 CTRL.t0 VDD.t149 sg13_lv_pmos ad=0.19p pd=1.38u as=0 ps=0 w=1u l=0.13u
X166 VSS.t406 psdiff_2.CLKN psdiff_2.buff_d8_0.VIN.t16 VSS.t380 sg13_lv_nmos ad=0.1005p pd=1.34u as=55.5f ps=0.74u w=0.15u l=0.13u
X167 CTRL.t18 PH2.t10 CTRL.t18 VDD.t55 sg13_lv_pmos ad=0.19p pd=1.38u as=0 ps=0 w=1u l=0.13u
X168 psdiff_2.buff_d8_0.VIN.t13 psdiff_2.CLKN VSS.t405 VSS.t149 sg13_lv_nmos ad=55.5f pd=0.74u as=55.5f ps=0.74u w=0.15u l=0.13u
X169 CTRL.t8 PH0.t10 CTRL.t8 VDD.t46 sg13_lv_pmos ad=0.19p pd=1.38u as=0 ps=0 w=1u l=0.13u
X170 VSS.t141 buff_d8_0.inv_d4_0.VIN buff_d8_0.inv_d8_0.VIN VSS.t140 sg13_lv_nmos ad=0.1005p pd=1.34u as=55.5f ps=0.74u w=0.15u l=0.13u
X171 PH3.t8 buff_d8_4.inv_d8_0.VIN VSS.t303 VSS.t302 sg13_lv_nmos ad=55.5f pd=0.74u as=0.1005p ps=1.34u w=0.15u l=0.13u
X172 psdiff_1.buff_d8_1.VIN.t17 VSS.t611 VDD.t324 VDD.t129 sg13_lv_pmos ad=55.5f pd=0.74u as=55.5f ps=0.74u w=0.15u l=0.13u
X173 VDD.t191 buff_d8_5.inv_d4_0.VIN buff_d8_5.inv_d8_0.VIN VDD.t60 sg13_lv_pmos ad=0.1005p pd=1.34u as=55.5f ps=0.74u w=0.15u l=0.13u
X174 CTRL.t20 PH5.t10 CTRL.t20 VDD.t36 sg13_lv_pmos ad=0.19p pd=1.38u as=0 ps=0 w=1u l=0.13u
X175 VDD.t11 psdiff_1.buff_d8_0.inv_d8_0.VIN psdiff_1.VOUTDP VDD.t0 sg13_lv_pmos ad=0.1005p pd=1.34u as=55.5f ps=0.74u w=0.15u l=0.13u
X176 VDD.t63 PH3.t12 PH0.t0 VDD.t48 sg13_lv_pmos ad=0.1005p pd=1.34u as=55.5f ps=0.74u w=0.15u l=0.13u
X177 VDD.t199 buff_d8_5.inv_d8_0.VIN PH0.t3 VDD.t192 sg13_lv_pmos ad=0.1005p pd=1.34u as=55.5f ps=0.74u w=0.15u l=0.13u
X178 PH2.t9 buff_d8_0.inv_d8_0.VIN VSS.t587 VSS.t586 sg13_lv_nmos ad=55.5f pd=0.74u as=0.1005p ps=1.34u w=0.15u l=0.13u
X179 VSS.t217 psdiff_1.buff_d8_1.inv_d8_0.VIN psdiff_1.VOUTDN VSS.t216 sg13_lv_nmos ad=0.1005p pd=1.34u as=55.5f ps=0.74u w=0.15u l=0.13u
X180 CTRL.t15 PH0.t10 CTRL.t8 VDD.t46 sg13_lv_pmos ad=0.34p pd=2.68u as=0 ps=0 w=1u l=0.13u
X181 psdiff_1.VOUTDN psdiff_1.buff_d8_1.inv_d8_0.VIN VSS.t215 VSS.t214 sg13_lv_nmos ad=55.5f pd=0.74u as=0.1005p ps=1.34u w=0.15u l=0.13u
X182 VDD.t133 a_3031_1122# psdiff_1.buff_d8_0.VIN.t21 VDD.t129 sg13_lv_pmos ad=55.5f pd=0.74u as=55.5f ps=0.74u w=0.15u l=0.13u
X183 VSS.t480 psdiff_2.CLKP.t8 psdiff_2.buff_d8_1.VIN.t15 VSS.t472 sg13_lv_nmos ad=55.5f pd=0.74u as=55.5f ps=0.74u w=0.15u l=0.13u
X184 VDD.t89 psdiff_2.buff_d8_1.inv_d8_0.VIN psdiff_2.VOUTDN VDD.t33 sg13_lv_pmos ad=0.1005p pd=1.34u as=55.5f ps=0.74u w=0.15u l=0.13u
X185 psdiff_0.buff_d8_0.VIN.t29 VSS.t612 VDD.t376 VDD.t108 sg13_lv_pmos ad=55.5f pd=0.74u as=55.5f ps=0.74u w=0.15u l=0.13u
X186 PH4.t1 PH1.t12 VSS.t157 VSS.t156 sg13_lv_nmos ad=55.5f pd=0.74u as=0.1005p ps=1.34u w=0.15u l=0.13u
X187 psdiff_0.buff_d8_0.inv_d8_0.VIN psdiff_0.buff_d8_0.inv_d4_0.VIN VSS.t11 VSS.t10 sg13_lv_nmos ad=55.5f pd=0.74u as=0.1005p ps=1.34u w=0.15u l=0.13u
X188 VSS.t511 buff_d8_5.inv_d4_0.VIN buff_d8_5.inv_d8_0.VIN VSS.t510 sg13_lv_nmos ad=0.1005p pd=1.34u as=55.5f ps=0.74u w=0.15u l=0.13u
X189 VDD.t272 psdiff_2.CLKP.t9 buff_d8_0.inv_d2_0.VIN VDD.t36 sg13_lv_pmos ad=0.1005p pd=1.34u as=0.1005p ps=1.34u w=0.15u l=0.13u
X190 VSS.t169 psdiff_1.buff_d8_0.VIN.t32 psdiff_1.buff_d8_0.inv_d2_0.VIN VSS.t168 sg13_lv_nmos ad=0.1005p pd=1.34u as=0.1005p ps=1.34u w=0.15u l=0.13u
X191 CTRL.t16 PH2.t10 CTRL.t16 VDD.t55 sg13_lv_pmos ad=0.19p pd=1.38u as=0 ps=0 w=1u l=0.13u
X192 buff_d8_0.inv_d8_0.VIN buff_d8_0.inv_d4_0.VIN VDD.t42 VDD.t41 sg13_lv_pmos ad=55.5f pd=0.74u as=0.1005p ps=1.34u w=0.15u l=0.13u
X193 CTRL.t20 PH5.t10 CTRL.t20 VDD.t38 sg13_lv_pmos ad=0.19p pd=1.38u as=0 ps=0 w=1u l=0.13u
X194 psdiff_1.buff_d8_0.VIN.t24 VSS.t611 VDD.t346 VDD.t129 sg13_lv_pmos ad=55.5f pd=0.74u as=0.1005p ps=1.34u w=0.15u l=0.13u
X195 buff_d8_3.inv_d4_0.VIN buff_d8_3.inv_d2_0.VIN VDD.t160 VDD.t23 sg13_lv_pmos ad=55.5f pd=0.74u as=0.1005p ps=1.34u w=0.15u l=0.13u
X196 psdiff_1.buff_d8_0.VIN.t12 psdiff_2.VOUTDP VSS.t74 VSS.t50 sg13_lv_nmos ad=55.5f pd=0.74u as=55.5f ps=0.74u w=0.15u l=0.13u
X197 PH2.t0 PH5.t11 VDD.t65 VDD.t56 sg13_lv_pmos ad=55.5f pd=0.74u as=0.1005p ps=1.34u w=0.15u l=0.13u
X198 VSS.t263 psdiff_2.VOUTDN psdiff_1.buff_d8_1.VIN.t16 VSS.t150 sg13_lv_nmos ad=55.5f pd=0.74u as=55.5f ps=0.74u w=0.15u l=0.13u
X199 CTRL.t20 PH2.t10 CTRL.t20 VDD.t41 sg13_lv_pmos ad=0.19p pd=1.38u as=0 ps=0 w=1u l=0.13u
X200 psdiff_1.buff_d8_0.VIN.t29 VSS.t611 VDD.t345 VDD.t129 sg13_lv_pmos ad=55.5f pd=0.74u as=55.5f ps=0.74u w=0.15u l=0.13u
X201 psdiff_2.CLKP.t3 psdiff_0.buff_d8_1.inv_d8_0.VIN VDD.t168 VDD.t33 sg13_lv_pmos ad=55.5f pd=0.74u as=0.1005p ps=1.34u w=0.15u l=0.13u
X202 psdiff_0.buff_d8_1.inv_d4_0.VIN psdiff_0.buff_d8_1.inv_d2_0.VIN VDD.t142 VDD.t33 sg13_lv_pmos ad=55.5f pd=0.74u as=0.1005p ps=1.34u w=0.15u l=0.13u
X203 VSS.t431 buff_d8_0.inv_d2_0.VIN buff_d8_0.inv_d4_0.VIN VSS.t430 sg13_lv_nmos ad=0.1005p pd=1.34u as=55.5f ps=0.74u w=0.15u l=0.13u
X204 VSS.t370 psdiff_0.buff_d8_1.inv_d4_0.VIN psdiff_0.buff_d8_1.inv_d8_0.VIN VSS.t369 sg13_lv_nmos ad=0.1005p pd=1.34u as=55.5f ps=0.74u w=0.15u l=0.13u
X205 PH3.t7 buff_d8_4.inv_d8_0.VIN VSS.t301 VSS.t300 sg13_lv_nmos ad=55.5f pd=0.74u as=0.1005p ps=1.34u w=0.15u l=0.13u
X206 VSS.t539 buff_d8_3.inv_d4_0.VIN buff_d8_3.inv_d8_0.VIN VSS.t538 sg13_lv_nmos ad=0.1005p pd=1.34u as=55.5f ps=0.74u w=0.15u l=0.13u
X207 CTRL.t0 PH1.t11 CTRL.t0 VDD.t25 sg13_lv_pmos ad=0.19p pd=1.38u as=0 ps=0 w=1u l=0.13u
X208 psdiff_2.buff_d8_1.inv_d4_0.VIN psdiff_2.buff_d8_1.inv_d2_0.VIN VSS.t167 VSS.t166 sg13_lv_nmos ad=55.5f pd=0.74u as=0.1005p ps=1.34u w=0.15u l=0.13u
X209 CTRL.t18 PH5.t10 CTRL.t18 VDD.t36 sg13_lv_pmos ad=0.19p pd=1.38u as=0 ps=0 w=1u l=0.13u
X210 VSS.t447 psdiff_0.buff_d8_1.inv_d8_0.VIN psdiff_2.CLKP.t5 VSS.t446 sg13_lv_nmos ad=0.1005p pd=1.34u as=55.5f ps=0.74u w=0.15u l=0.13u
X211 CTRL.t13 PH3.t10 CTRL.t13 VDD.t60 sg13_lv_pmos ad=0.19p pd=1.38u as=0 ps=0 w=1u l=0.13u
X212 psdiff_1.VOUTDN psdiff_1.buff_d8_1.inv_d8_0.VIN VSS.t213 VSS.t212 sg13_lv_nmos ad=55.5f pd=0.74u as=0.1005p ps=1.34u w=0.15u l=0.13u
X213 psdiff_0.buff_d8_0.inv_d8_0.VIN psdiff_0.buff_d8_0.inv_d4_0.VIN VDD.t6 VDD.t0 sg13_lv_pmos ad=55.5f pd=0.74u as=0.1005p ps=1.34u w=0.15u l=0.13u
X214 psdiff_2.buff_d8_1.VIN.t14 psdiff_2.CLKP.t8 VSS.t483 VSS.t454 sg13_lv_nmos ad=55.5f pd=0.74u as=0.1005p ps=1.34u w=0.15u l=0.13u
X215 VSS.t185 PH5.t12 PH2.t1 VSS.t184 sg13_lv_nmos ad=0.1005p pd=1.34u as=55.5f ps=0.74u w=0.15u l=0.13u
X216 VSS.t70 psdiff_2.VOUTDN psdiff_1.buff_d8_1.VIN.t15 VSS.t244 sg13_lv_nmos ad=55.5f pd=0.74u as=55.5f ps=0.74u w=0.15u l=0.13u
X217 VSS.t479 psdiff_2.CLKP.t8 psdiff_2.buff_d8_1.VIN.t13 VSS.t472 sg13_lv_nmos ad=55.5f pd=0.74u as=55.5f ps=0.74u w=0.15u l=0.13u
X218 psdiff_1.buff_d8_1.inv_d2_0.VIN psdiff_1.buff_d8_1.VIN.t32 VDD.t51 VDD.t33 sg13_lv_pmos ad=0.1005p pd=1.34u as=0.1005p ps=1.34u w=0.15u l=0.13u
X219 psdiff_0.buff_d8_0.VIN.t20 psdiff_1.VOUTDP VSS.t353 VSS.t331 sg13_lv_nmos ad=55.5f pd=0.74u as=55.5f ps=0.74u w=0.15u l=0.13u
X220 psdiff_1.buff_d8_1.VIN.t14 psdiff_2.VOUTDN VSS.t266 VSS.t242 sg13_lv_nmos ad=55.5f pd=0.74u as=55.5f ps=0.74u w=0.15u l=0.13u
X221 psdiff_0.buff_d8_0.VIN.t2 a_6005_1122# VDD.t116 VDD.t108 sg13_lv_pmos ad=55.5f pd=0.74u as=55.5f ps=0.74u w=0.15u l=0.13u
X222 VDD.t88 psdiff_2.buff_d8_1.inv_d8_0.VIN psdiff_2.VOUTDN VDD.t33 sg13_lv_pmos ad=0.1005p pd=1.34u as=55.5f ps=0.74u w=0.15u l=0.13u
X223 CTRL.t18 PH5.t10 CTRL.t18 VDD.t38 sg13_lv_pmos ad=0.19p pd=1.38u as=0 ps=0 w=1u l=0.13u
X224 VDD.t327 VSS.t611 psdiff_1.buff_d8_0.VIN.t30 VDD.t129 sg13_lv_pmos ad=55.5f pd=0.74u as=55.5f ps=0.74u w=0.15u l=0.13u
X225 VSS.t399 psdiff_2.CLKN psdiff_2.buff_d8_0.VIN.t15 VSS.t391 sg13_lv_nmos ad=55.5f pd=0.74u as=55.5f ps=0.74u w=0.15u l=0.13u
X226 PH5.t1 PH2.t12 VSS.t173 VSS.t172 sg13_lv_nmos ad=55.5f pd=0.74u as=0.1005p ps=1.34u w=0.15u l=0.13u
X227 VDD.t343 VSS.t611 psdiff_1.buff_d8_1.VIN.t19 VDD.t129 sg13_lv_pmos ad=55.5f pd=0.74u as=55.5f ps=0.74u w=0.15u l=0.13u
X228 psdiff_2.buff_d8_1.VIN.t31 a_1214_1266# VDD.t170 VDD.t169 sg13_lv_pmos ad=55.5f pd=0.74u as=55.5f ps=0.74u w=0.15u l=0.13u
X229 CTRL.t0 PH1.t11 CTRL.t0 VDD.t30 sg13_lv_pmos ad=0.19p pd=1.38u as=0 ps=0 w=1u l=0.13u
X230 psdiff_2.buff_d8_1.VIN.t28 a_1214_1266# VDD.t172 VDD.t169 sg13_lv_pmos ad=55.5f pd=0.74u as=55.5f ps=0.74u w=0.15u l=0.13u
X231 CTRL.t13 PH3.t10 CTRL.t13 VDD.t47 sg13_lv_pmos ad=0.19p pd=1.38u as=0 ps=0 w=1u l=0.13u
X232 CTRL.t18 PH2.t10 CTRL.t18 VDD.t41 sg13_lv_pmos ad=0.19p pd=1.38u as=0 ps=0 w=1u l=0.13u
X233 VDD.t326 VSS.t611 psdiff_1.buff_d8_1.VIN.t25 VDD.t129 sg13_lv_pmos ad=55.5f pd=0.74u as=55.5f ps=0.74u w=0.15u l=0.13u
X234 VSS.t527 buff_d8_5.inv_d8_0.VIN PH0.t6 VSS.t526 sg13_lv_nmos ad=0.1005p pd=1.34u as=55.5f ps=0.74u w=0.15u l=0.13u
X235 a_6005_1122# CTRL.t26 psdiff_0.buff_d8_1.VIN.t16 VSS.t89 sg13_lv_nmos ad=55.5f pd=0.74u as=0.1005p ps=1.34u w=0.15u l=0.13u
X236 CTRL.t16 PH5.t10 CTRL.t16 VDD.t36 sg13_lv_pmos ad=0.19p pd=1.38u as=0 ps=0 w=1u l=0.13u
X237 VSS.t553 buff_d8_3.inv_d8_0.VIN PH1.t6 VSS.t552 sg13_lv_nmos ad=0.1005p pd=1.34u as=55.5f ps=0.74u w=0.15u l=0.13u
X238 VSS.t9 psdiff_0.buff_d8_0.inv_d4_0.VIN psdiff_0.buff_d8_0.inv_d8_0.VIN VSS.t8 sg13_lv_nmos ad=0.1005p pd=1.34u as=55.5f ps=0.74u w=0.15u l=0.13u
X239 CTRL.t13 PH0.t10 CTRL.t13 VDD.t47 sg13_lv_pmos ad=0.19p pd=1.38u as=0 ps=0 w=1u l=0.13u
X240 VSS.t435 buff_d8_3.inv_d2_0.VIN buff_d8_3.inv_d4_0.VIN VSS.t434 sg13_lv_nmos ad=0.1005p pd=1.34u as=55.5f ps=0.74u w=0.15u l=0.13u
X241 psdiff_2.VOUTDP psdiff_2.buff_d8_0.inv_d8_0.VIN VSS.t39 VSS.t38 sg13_lv_nmos ad=55.5f pd=0.74u as=0.1005p ps=1.34u w=0.15u l=0.13u
X242 VDD.t276 VSS.t610 psdiff_2.buff_d8_1.VIN.t21 VDD.t169 sg13_lv_pmos ad=55.5f pd=0.74u as=55.5f ps=0.74u w=0.15u l=0.13u
X243 VDD.t367 VSS.t612 psdiff_0.buff_d8_0.VIN.t24 VDD.t108 sg13_lv_pmos ad=55.5f pd=0.74u as=55.5f ps=0.74u w=0.15u l=0.13u
X244 buff_d8_3.inv_d8_0.VIN buff_d8_3.inv_d4_0.VIN VSS.t537 VSS.t536 sg13_lv_nmos ad=55.5f pd=0.74u as=0.1005p ps=1.34u w=0.15u l=0.13u
X245 VDD.t32 buff_d8_2.inv_d4_0.VIN buff_d8_2.inv_d8_0.VIN VDD.t25 sg13_lv_pmos ad=0.1005p pd=1.34u as=55.5f ps=0.74u w=0.15u l=0.13u
X246 psdiff_0.buff_d8_0.VIN.t19 psdiff_1.VOUTDP VSS.t350 VSS.t329 sg13_lv_nmos ad=55.5f pd=0.74u as=55.5f ps=0.74u w=0.15u l=0.13u
X247 VSS.t349 psdiff_1.VOUTDP psdiff_0.buff_d8_0.VIN.t21 VSS.t148 sg13_lv_nmos ad=55.5f pd=0.74u as=55.5f ps=0.74u w=0.15u l=0.13u
X248 CTRL.t11 PH3.t10 CTRL.t11 VDD.t60 sg13_lv_pmos ad=0.19p pd=1.38u as=0 ps=0 w=1u l=0.13u
X249 psdiff_2.buff_d8_0.VIN.t26 VSS.t610 VDD.t304 VDD.t169 sg13_lv_pmos ad=55.5f pd=0.74u as=0.1005p ps=1.34u w=0.15u l=0.13u
X250 VDD.t365 VSS.t612 psdiff_0.buff_d8_0.VIN.t30 VDD.t108 sg13_lv_pmos ad=55.5f pd=0.74u as=55.5f ps=0.74u w=0.15u l=0.13u
X251 psdiff_0.buff_d8_1.VIN.t14 psdiff_1.VOUTDN VSS.t115 VSS.t87 sg13_lv_nmos ad=55.5f pd=0.74u as=55.5f ps=0.74u w=0.15u l=0.13u
X252 VDD.t261 a_7162_1266# psdiff_0.buff_d8_1.VIN.t28 VDD.t108 sg13_lv_pmos ad=55.5f pd=0.74u as=55.5f ps=0.74u w=0.15u l=0.13u
X253 CTRL.t22 PH2.t10 CTRL.t22 VDD.t55 sg13_lv_pmos ad=0.19p pd=1.38u as=0 ps=0 w=1u l=0.13u
X254 VSS.t445 psdiff_0.buff_d8_1.inv_d8_0.VIN psdiff_2.CLKP.t4 VSS.t444 sg13_lv_nmos ad=0.1005p pd=1.34u as=55.5f ps=0.74u w=0.15u l=0.13u
X255 psdiff_2.buff_d8_0.VIN.t30 a_57_1122# VDD.t250 VDD.t169 sg13_lv_pmos ad=55.5f pd=0.74u as=55.5f ps=0.74u w=0.15u l=0.13u
X256 psdiff_2.CLKP.t7 psdiff_0.buff_d8_1.inv_d8_0.VIN VSS.t443 VSS.t442 sg13_lv_nmos ad=55.5f pd=0.74u as=0.1005p ps=1.34u w=0.15u l=0.13u
X257 psdiff_2.VOUTDP psdiff_2.buff_d8_0.inv_d8_0.VIN VSS.t37 VSS.t36 sg13_lv_nmos ad=55.5f pd=0.74u as=0.1005p ps=1.34u w=0.15u l=0.13u
X258 CTRL.t16 PH5.t10 CTRL.t16 VDD.t38 sg13_lv_pmos ad=0.19p pd=1.38u as=0 ps=0 w=1u l=0.13u
X259 psdiff_2.buff_d8_0.VIN.t29 a_57_1122# VDD.t254 VDD.t169 sg13_lv_pmos ad=55.5f pd=0.74u as=55.5f ps=0.74u w=0.15u l=0.13u
X260 VDD.t263 a_7162_1266# psdiff_0.buff_d8_1.VIN.t31 VDD.t108 sg13_lv_pmos ad=55.5f pd=0.74u as=55.5f ps=0.74u w=0.15u l=0.13u
X261 VSS.t68 psdiff_2.VOUTDP psdiff_1.buff_d8_0.VIN.t14 VSS.t58 sg13_lv_nmos ad=55.5f pd=0.74u as=55.5f ps=0.74u w=0.15u l=0.13u
X262 CTRL.t3 PH4.t10 CTRL.t3 VDD.t149 sg13_lv_pmos ad=0.19p pd=1.38u as=0 ps=0 w=1u l=0.13u
X263 CTRL.t16 PH2.t10 CTRL.t16 VDD.t41 sg13_lv_pmos ad=0.19p pd=1.38u as=0 ps=0 w=1u l=0.13u
X264 VDD.t81 psdiff_1.buff_d8_1.inv_d8_0.VIN psdiff_1.VOUTDN VDD.t33 sg13_lv_pmos ad=0.1005p pd=1.34u as=55.5f ps=0.74u w=0.15u l=0.13u
X265 VDD.t314 VSS.t611 psdiff_1.buff_d8_0.VIN.t26 VDD.t129 sg13_lv_pmos ad=55.5f pd=0.74u as=55.5f ps=0.74u w=0.15u l=0.13u
X266 psdiff_2.buff_d8_1.VIN.t9 psdiff_2.CLKP.t8 VSS.t481 VSS.t147 sg13_lv_nmos ad=55.5f pd=0.74u as=55.5f ps=0.74u w=0.15u l=0.13u
X267 psdiff_0.buff_d8_0.VIN.t1 CTRL.t26 a_7162_1266# VSS.t151 sg13_lv_nmos ad=0.1005p pd=1.34u as=55.5f ps=0.74u w=0.15u l=0.13u
X268 CTRL.t3 PH4.t10 CTRL.t3 VDD.t149 sg13_lv_pmos ad=0.19p pd=1.38u as=0 ps=0 w=1u l=0.13u
X269 VSS.t398 psdiff_2.CLKN psdiff_2.buff_d8_0.VIN.t14 VSS.t391 sg13_lv_nmos ad=55.5f pd=0.74u as=55.5f ps=0.74u w=0.15u l=0.13u
X270 psdiff_0.buff_d8_1.VIN.t17 VSS.t612 VDD.t360 VDD.t108 sg13_lv_pmos ad=55.5f pd=0.74u as=55.5f ps=0.74u w=0.15u l=0.13u
X271 VDD.t67 psdiff_2.buff_d8_0.VIN.t32 psdiff_2.buff_d8_0.inv_d2_0.VIN VDD.t0 sg13_lv_pmos ad=0.1005p pd=1.34u as=0.1005p ps=1.34u w=0.15u l=0.13u
X272 CTRL.t11 PH3.t10 CTRL.t11 VDD.t47 sg13_lv_pmos ad=0.19p pd=1.38u as=0 ps=0 w=1u l=0.13u
X273 VDD.t274 VSS.t610 psdiff_2.buff_d8_0.VIN.t20 VDD.t169 sg13_lv_pmos ad=55.5f pd=0.74u as=55.5f ps=0.74u w=0.15u l=0.13u
X274 buff_d8_1.inv_d8_0.VIN buff_d8_1.inv_d4_0.VIN VDD.t128 VDD.t23 sg13_lv_pmos ad=55.5f pd=0.74u as=0.1005p ps=1.34u w=0.15u l=0.13u
X275 CTRL.t23 PH2.t10 CTRL.t22 VDD.t25 sg13_lv_pmos ad=0.34p pd=2.68u as=0 ps=0 w=1u l=0.13u
X276 VDD.t198 buff_d8_5.inv_d8_0.VIN PH0.t2 VDD.t192 sg13_lv_pmos ad=0.1005p pd=1.34u as=55.5f ps=0.74u w=0.15u l=0.13u
X277 VSS.t501 psdiff_0.buff_d8_0.inv_d8_0.VIN psdiff_2.CLKN VSS.t500 sg13_lv_nmos ad=0.1005p pd=1.34u as=55.5f ps=0.74u w=0.15u l=0.13u
X278 CTRL.t11 PH0.t10 CTRL.t11 VDD.t47 sg13_lv_pmos ad=0.19p pd=1.38u as=0 ps=0 w=1u l=0.13u
X279 CTRL.t13 PH0.t10 CTRL.t13 VDD.t46 sg13_lv_pmos ad=0.19p pd=1.38u as=0 ps=0 w=1u l=0.13u
X280 VSS.t265 psdiff_2.VOUTDN buff_d8_5.inv_d2_0.VIN VSS.t264 sg13_lv_nmos ad=0.1005p pd=1.34u as=0.1005p ps=1.34u w=0.15u l=0.13u
X281 buff_d8_4.inv_d8_0.VIN buff_d8_4.inv_d4_0.VIN VSS.t573 VSS.t572 sg13_lv_nmos ad=55.5f pd=0.74u as=0.1005p ps=1.34u w=0.15u l=0.13u
X282 VSS.t551 buff_d8_3.inv_d8_0.VIN PH1.t7 VSS.t550 sg13_lv_nmos ad=0.1005p pd=1.34u as=55.5f ps=0.74u w=0.15u l=0.13u
X283 VDD.t201 psdiff_1.buff_d8_0.inv_d2_0.VIN psdiff_1.buff_d8_0.inv_d4_0.VIN VDD.t0 sg13_lv_pmos ad=0.1005p pd=1.34u as=55.5f ps=0.74u w=0.15u l=0.13u
X284 VSS.t597 psdiff_1.buff_d8_0.inv_d4_0.VIN psdiff_1.buff_d8_0.inv_d8_0.VIN VSS.t596 sg13_lv_nmos ad=0.1005p pd=1.34u as=55.5f ps=0.74u w=0.15u l=0.13u
X285 CTRL.t9 PH3.t10 CTRL.t9 VDD.t60 sg13_lv_pmos ad=0.19p pd=1.38u as=0 ps=0 w=1u l=0.13u
X286 psdiff_0.buff_d8_1.VIN.t25 VSS.t612 VDD.t372 VDD.t108 sg13_lv_pmos ad=55.5f pd=0.74u as=55.5f ps=0.74u w=0.15u l=0.13u
X287 VSS.t321 buff_d8_1.inv_d4_0.VIN buff_d8_1.inv_d8_0.VIN VSS.t320 sg13_lv_nmos ad=0.1005p pd=1.34u as=55.5f ps=0.74u w=0.15u l=0.13u
X288 buff_d8_1.inv_d2_0.VIN psdiff_2.CLKN VSS.t402 VSS.t401 sg13_lv_nmos ad=0.1005p pd=1.34u as=0.1005p ps=1.34u w=0.15u l=0.13u
X289 psdiff_0.buff_d8_1.VIN.t13 psdiff_1.VOUTDN VSS.t114 VSS.t100 sg13_lv_nmos ad=55.5f pd=0.74u as=0.1005p ps=1.34u w=0.15u l=0.13u
X290 PH0.t4 buff_d8_5.inv_d8_0.VIN VDD.t197 VDD.t46 sg13_lv_pmos ad=55.5f pd=0.74u as=0.1005p ps=1.34u w=0.15u l=0.13u
X291 VSS.t161 PH0.t12 PH3.t1 VSS.t160 sg13_lv_nmos ad=0.1005p pd=1.34u as=55.5f ps=0.74u w=0.15u l=0.13u
X292 VDD.t53 psdiff_2.buff_d8_1.inv_d2_0.VIN psdiff_2.buff_d8_1.inv_d4_0.VIN VDD.t33 sg13_lv_pmos ad=0.1005p pd=1.34u as=55.5f ps=0.74u w=0.15u l=0.13u
X293 psdiff_1.buff_d8_1.VIN.t20 VSS.t611 VDD.t319 VDD.t129 sg13_lv_pmos ad=55.5f pd=0.74u as=55.5f ps=0.74u w=0.15u l=0.13u
X294 VSS.t66 psdiff_2.VOUTDP psdiff_1.buff_d8_0.VIN.t13 VSS.t58 sg13_lv_nmos ad=55.5f pd=0.74u as=55.5f ps=0.74u w=0.15u l=0.13u
X295 CTRL.t2 PH4.t10 CTRL.t2 VDD.t149 sg13_lv_pmos ad=0.19p pd=1.38u as=0 ps=0 w=1u l=0.13u
X296 CTRL.t9 PH3.t10 CTRL.t9 VDD.t47 sg13_lv_pmos ad=0.19p pd=1.38u as=0 ps=0 w=1u l=0.13u
X297 PH4.t5 buff_d8_2.inv_d8_0.VIN VDD.t154 VDD.t149 sg13_lv_pmos ad=55.5f pd=0.74u as=0.1005p ps=1.34u w=0.15u l=0.13u
X298 psdiff_1.buff_d8_1.VIN.t21 VSS.t611 VDD.t317 VDD.t129 sg13_lv_pmos ad=55.5f pd=0.74u as=55.5f ps=0.74u w=0.15u l=0.13u
X299 VDD.t381 VSS.t612 psdiff_0.buff_d8_1.VIN.t21 VDD.t108 sg13_lv_pmos ad=0.1005p pd=1.34u as=55.5f ps=0.74u w=0.15u l=0.13u
X300 VDD.t80 psdiff_1.buff_d8_1.inv_d8_0.VIN psdiff_1.VOUTDN VDD.t33 sg13_lv_pmos ad=0.1005p pd=1.34u as=55.5f ps=0.74u w=0.15u l=0.13u
X301 psdiff_2.buff_d8_1.VIN.t12 psdiff_2.CLKP.t8 VSS.t480 VSS.t466 sg13_lv_nmos ad=55.5f pd=0.74u as=55.5f ps=0.74u w=0.15u l=0.13u
X302 CTRL.t2 PH4.t10 CTRL.t2 VDD.t149 sg13_lv_pmos ad=0.19p pd=1.38u as=0 ps=0 w=1u l=0.13u
X303 CTRL.t9 PH0.t10 CTRL.t9 VDD.t47 sg13_lv_pmos ad=0.19p pd=1.38u as=0 ps=0 w=1u l=0.13u
X304 VDD.t248 psdiff_2.buff_d8_0.inv_d4_0.VIN psdiff_2.buff_d8_0.inv_d8_0.VIN VDD.t0 sg13_lv_pmos ad=0.1005p pd=1.34u as=55.5f ps=0.74u w=0.15u l=0.13u
X305 psdiff_1.buff_d8_1.VIN.t30 a_4188_1266# VDD.t236 VDD.t129 sg13_lv_pmos ad=55.5f pd=0.74u as=55.5f ps=0.74u w=0.15u l=0.13u
X306 VSS.t35 psdiff_2.buff_d8_0.inv_d8_0.VIN psdiff_2.VOUTDP VSS.t34 sg13_lv_nmos ad=0.1005p pd=1.34u as=55.5f ps=0.74u w=0.15u l=0.13u
X307 VSS.t423 buff_d8_2.inv_d8_0.VIN PH4.t7 VSS.t422 sg13_lv_nmos ad=0.1005p pd=1.34u as=55.5f ps=0.74u w=0.15u l=0.13u
X308 VDD.t135 a_3031_1122# psdiff_1.buff_d8_0.VIN.t20 VDD.t129 sg13_lv_pmos ad=55.5f pd=0.74u as=55.5f ps=0.74u w=0.15u l=0.13u
X309 psdiff_1.buff_d8_1.inv_d8_0.VIN psdiff_1.buff_d8_1.inv_d4_0.VIN VDD.t73 VDD.t33 sg13_lv_pmos ad=55.5f pd=0.74u as=0.1005p ps=1.34u w=0.15u l=0.13u
X310 CTRL.t11 PH0.t10 CTRL.t11 VDD.t46 sg13_lv_pmos ad=0.19p pd=1.38u as=0 ps=0 w=1u l=0.13u
X311 VSS.t127 buff_d8_2.inv_d4_0.VIN buff_d8_2.inv_d8_0.VIN VSS.t126 sg13_lv_nmos ad=0.1005p pd=1.34u as=55.5f ps=0.74u w=0.15u l=0.13u
X312 psdiff_1.buff_d8_1.VIN.t15 psdiff_2.VOUTDN VSS.t263 VSS.t153 sg13_lv_nmos ad=55.5f pd=0.74u as=55.5f ps=0.74u w=0.15u l=0.13u
X313 PH4.t9 buff_d8_2.inv_d8_0.VIN VSS.t421 VSS.t420 sg13_lv_nmos ad=55.5f pd=0.74u as=0.1005p ps=1.34u w=0.15u l=0.13u
X314 psdiff_2.VOUTDN psdiff_2.buff_d8_1.inv_d8_0.VIN VSS.t231 VSS.t230 sg13_lv_nmos ad=55.5f pd=0.74u as=0.1005p ps=1.34u w=0.15u l=0.13u
X315 PH5.t5 buff_d8_1.inv_d8_0.VIN VDD.t97 VDD.t23 sg13_lv_pmos ad=55.5f pd=0.74u as=0.1005p ps=1.34u w=0.15u l=0.13u
X316 psdiff_2.CLKN psdiff_0.buff_d8_0.inv_d8_0.VIN VSS.t499 VSS.t498 sg13_lv_nmos ad=55.5f pd=0.74u as=0.1005p ps=1.34u w=0.15u l=0.13u
X317 CTRL.t22 PH5.t10 CTRL.t22 VDD.t38 sg13_lv_pmos ad=0.19p pd=1.38u as=0 ps=0 w=1u l=0.13u
X318 psdiff_1.buff_d8_0.VIN.t31 VSS.t611 VDD.t316 VDD.t129 sg13_lv_pmos ad=55.5f pd=0.74u as=55.5f ps=0.74u w=0.15u l=0.13u
X319 VSS.t397 psdiff_2.CLKN psdiff_2.buff_d8_0.VIN.t13 VSS.t373 sg13_lv_nmos ad=55.5f pd=0.74u as=55.5f ps=0.74u w=0.15u l=0.13u
X320 VSS.t281 buff_d8_1.inv_d8_0.VIN PH5.t6 VSS.t280 sg13_lv_nmos ad=0.1005p pd=1.34u as=55.5f ps=0.74u w=0.15u l=0.13u
X321 CTRL.t1 PH4.t10 CTRL.t1 VDD.t149 sg13_lv_pmos ad=0.19p pd=1.38u as=0 ps=0 w=1u l=0.13u
X322 psdiff_0.buff_d8_1.VIN.t12 psdiff_1.VOUTDN VSS.t113 VSS.t100 sg13_lv_nmos ad=55.5f pd=0.74u as=0.1005p ps=1.34u w=0.15u l=0.13u
X323 CTRL.t3 PH1.t11 CTRL.t3 VDD.t27 sg13_lv_pmos ad=0.19p pd=1.38u as=0 ps=0 w=1u l=0.13u
X324 psdiff_1.buff_d8_0.VIN.t28 VSS.t611 VDD.t330 VDD.t129 sg13_lv_pmos ad=55.5f pd=0.74u as=55.5f ps=0.74u w=0.15u l=0.13u
X325 VDD.t206 buff_d8_3.inv_d4_0.VIN buff_d8_3.inv_d8_0.VIN VDD.t23 sg13_lv_pmos ad=0.1005p pd=1.34u as=55.5f ps=0.74u w=0.15u l=0.13u
X326 PH0.t8 buff_d8_5.inv_d8_0.VIN VSS.t525 VSS.t524 sg13_lv_nmos ad=55.5f pd=0.74u as=0.1005p ps=1.34u w=0.15u l=0.13u
X327 buff_d8_3.inv_d2_0.VIN psdiff_1.VOUTDP VDD.t140 VDD.t23 sg13_lv_pmos ad=0.1005p pd=1.34u as=0.1005p ps=1.34u w=0.15u l=0.13u
X328 CTRL.t3 PH1.t11 CTRL.t3 VDD.t27 sg13_lv_pmos ad=0.19p pd=1.38u as=0 ps=0 w=1u l=0.13u
X329 CTRL.t1 PH4.t10 CTRL.t1 VDD.t149 sg13_lv_pmos ad=0.19p pd=1.38u as=0 ps=0 w=1u l=0.13u
X330 VDD.t5 psdiff_0.buff_d8_0.inv_d4_0.VIN psdiff_0.buff_d8_0.inv_d8_0.VIN VDD.t0 sg13_lv_pmos ad=0.1005p pd=1.34u as=55.5f ps=0.74u w=0.15u l=0.13u
X331 psdiff_2.buff_d8_1.VIN.t11 psdiff_2.CLKP.t8 VSS.t479 VSS.t466 sg13_lv_nmos ad=55.5f pd=0.74u as=55.5f ps=0.74u w=0.15u l=0.13u
X332 CTRL.t9 PH0.t10 CTRL.t9 VDD.t46 sg13_lv_pmos ad=0.19p pd=1.38u as=0 ps=0 w=1u l=0.13u
X333 VSS.t350 psdiff_1.VOUTDP psdiff_0.buff_d8_0.VIN.t20 VSS.t324 sg13_lv_nmos ad=55.5f pd=0.74u as=55.5f ps=0.74u w=0.15u l=0.13u
X334 VSS.t250 psdiff_2.VOUTDN psdiff_1.buff_d8_1.VIN.t14 VSS.t235 sg13_lv_nmos ad=55.5f pd=0.74u as=55.5f ps=0.74u w=0.15u l=0.13u
X335 psdiff_1.buff_d8_1.inv_d4_0.VIN psdiff_1.buff_d8_1.inv_d2_0.VIN VDD.t35 VDD.t33 sg13_lv_pmos ad=55.5f pd=0.74u as=0.1005p ps=1.34u w=0.15u l=0.13u
X336 psdiff_2.CLKN psdiff_0.buff_d8_0.inv_d8_0.VIN VDD.t186 VDD.t0 sg13_lv_pmos ad=55.5f pd=0.74u as=0.1005p ps=1.34u w=0.15u l=0.13u
X337 VSS.t609 buff_d8_2.inv_d2_0.VIN buff_d8_2.inv_d4_0.VIN VSS.t608 sg13_lv_nmos ad=0.1005p pd=1.34u as=55.5f ps=0.74u w=0.15u l=0.13u
X338 VSS.t585 buff_d8_0.inv_d8_0.VIN PH2.t7 VSS.t584 sg13_lv_nmos ad=0.1005p pd=1.34u as=55.5f ps=0.74u w=0.15u l=0.13u
X339 psdiff_0.buff_d8_0.VIN.t6 a_6005_1122# VDD.t110 VDD.t108 sg13_lv_pmos ad=55.5f pd=0.74u as=55.5f ps=0.74u w=0.15u l=0.13u
X340 VDD.t284 VSS.t610 psdiff_2.buff_d8_1.VIN.t25 VDD.t169 sg13_lv_pmos ad=55.5f pd=0.74u as=55.5f ps=0.74u w=0.15u l=0.13u
X341 psdiff_0.buff_d8_0.VIN.t4 a_6005_1122# VDD.t114 VDD.t108 sg13_lv_pmos ad=55.5f pd=0.74u as=0.1005p ps=1.34u w=0.15u l=0.13u
X342 psdiff_0.buff_d8_0.VIN.t5 a_6005_1122# VDD.t109 VDD.t108 sg13_lv_pmos ad=55.5f pd=0.74u as=55.5f ps=0.74u w=0.15u l=0.13u
X343 VSS.t64 psdiff_2.VOUTDP psdiff_1.buff_d8_0.VIN.t12 VSS.t44 sg13_lv_nmos ad=55.5f pd=0.74u as=55.5f ps=0.74u w=0.15u l=0.13u
X344 CTRL.t8 PH3.t10 CTRL.t8 VDD.t61 sg13_lv_pmos ad=0.19p pd=1.38u as=0 ps=0 w=1u l=0.13u
X345 buff_d8_2.inv_d8_0.VIN buff_d8_2.inv_d4_0.VIN VSS.t125 VSS.t124 sg13_lv_nmos ad=55.5f pd=0.74u as=0.1005p ps=1.34u w=0.15u l=0.13u
X346 VSS.t199 psdiff_1.buff_d8_1.inv_d4_0.VIN psdiff_1.buff_d8_1.inv_d8_0.VIN VSS.t198 sg13_lv_nmos ad=0.1005p pd=1.34u as=55.5f ps=0.74u w=0.15u l=0.13u
X347 psdiff_2.VOUTDN psdiff_2.buff_d8_1.inv_d8_0.VIN VSS.t229 VSS.t228 sg13_lv_nmos ad=55.5f pd=0.74u as=0.1005p ps=1.34u w=0.15u l=0.13u
X348 VSS.t394 psdiff_2.CLKP.t8 psdiff_2.buff_d8_1.VIN.t3 VSS.t463 sg13_lv_nmos ad=55.5f pd=0.74u as=55.5f ps=0.74u w=0.15u l=0.13u
X349 CTRL.t8 PH3.t10 CTRL.t8 VDD.t60 sg13_lv_pmos ad=0.19p pd=1.38u as=0 ps=0 w=1u l=0.13u
X350 psdiff_2.buff_d8_1.VIN.t27 a_1214_1266# VDD.t171 VDD.t169 sg13_lv_pmos ad=55.5f pd=0.74u as=55.5f ps=0.74u w=0.15u l=0.13u
X351 VSS.t497 psdiff_0.buff_d8_0.inv_d8_0.VIN psdiff_2.CLKN VSS.t496 sg13_lv_nmos ad=0.1005p pd=1.34u as=55.5f ps=0.74u w=0.15u l=0.13u
X352 CTRL.t2 PH1.t11 CTRL.t2 VDD.t27 sg13_lv_pmos ad=0.19p pd=1.38u as=0 ps=0 w=1u l=0.13u
X353 VSS.t279 buff_d8_1.inv_d8_0.VIN PH5.t7 VSS.t278 sg13_lv_nmos ad=0.1005p pd=1.34u as=55.5f ps=0.74u w=0.15u l=0.13u
X354 psdiff_2.buff_d8_0.inv_d4_0.VIN psdiff_2.buff_d8_0.inv_d2_0.VIN VDD.t70 VDD.t0 sg13_lv_pmos ad=55.5f pd=0.74u as=0.1005p ps=1.34u w=0.15u l=0.13u
X355 PH1.t1 PH4.t12 VSS.t143 VSS.t142 sg13_lv_nmos ad=55.5f pd=0.74u as=0.1005p ps=1.34u w=0.15u l=0.13u
X356 CTRL.t20 PH2.t10 CTRL.t20 VDD.t55 sg13_lv_pmos ad=0.19p pd=1.38u as=0 ps=0 w=1u l=0.13u
X357 CTRL.t2 PH1.t11 CTRL.t2 VDD.t27 sg13_lv_pmos ad=0.19p pd=1.38u as=0 ps=0 w=1u l=0.13u
X358 VDD.t229 buff_d8_0.inv_d8_0.VIN PH2.t2 VDD.t25 sg13_lv_pmos ad=0.1005p pd=1.34u as=55.5f ps=0.74u w=0.15u l=0.13u
X359 psdiff_2.VOUTDP psdiff_2.buff_d8_0.inv_d8_0.VIN VDD.t22 VDD.t0 sg13_lv_pmos ad=55.5f pd=0.74u as=0.1005p ps=1.34u w=0.15u l=0.13u
X360 psdiff_0.buff_d8_0.VIN.t14 psdiff_1.VOUTDP VSS.t349 VSS.t151 sg13_lv_nmos ad=55.5f pd=0.74u as=55.5f ps=0.74u w=0.15u l=0.13u
X361 buff_d8_2.inv_d4_0.VIN buff_d8_2.inv_d2_0.VIN VDD.t260 VDD.t25 sg13_lv_pmos ad=55.5f pd=0.74u as=0.1005p ps=1.34u w=0.15u l=0.13u
X362 PH2.t3 buff_d8_0.inv_d8_0.VIN VDD.t228 VDD.t25 sg13_lv_pmos ad=55.5f pd=0.74u as=0.1005p ps=1.34u w=0.15u l=0.13u
X363 VSS.t23 psdiff_1.buff_d8_0.inv_d8_0.VIN psdiff_1.VOUTDP VSS.t22 sg13_lv_nmos ad=0.1005p pd=1.34u as=55.5f ps=0.74u w=0.15u l=0.13u
X364 VSS.t94 psdiff_1.VOUTDN psdiff_0.buff_d8_1.VIN.t14 VSS.t112 sg13_lv_nmos ad=55.5f pd=0.74u as=55.5f ps=0.74u w=0.15u l=0.13u
X365 CTRL.t20 PH2.t10 CTRL.t20 VDD.t55 sg13_lv_pmos ad=0.19p pd=1.38u as=0 ps=0 w=1u l=0.13u
X366 VDD.t301 VSS.t610 psdiff_2.buff_d8_1.VIN.t17 VDD.t169 sg13_lv_pmos ad=55.5f pd=0.74u as=55.5f ps=0.74u w=0.15u l=0.13u
X367 VDD.t373 VSS.t612 psdiff_0.buff_d8_0.VIN.t28 VDD.t108 sg13_lv_pmos ad=55.5f pd=0.74u as=55.5f ps=0.74u w=0.15u l=0.13u
X368 a_3031_1122# CTRL.t24 psdiff_1.buff_d8_1.VIN.t0 VSS.t150 sg13_lv_nmos ad=55.5f pd=0.74u as=0.1005p ps=1.34u w=0.15u l=0.13u
X369 VDD.t283 VSS.t610 psdiff_2.buff_d8_0.VIN.t18 VDD.t169 sg13_lv_pmos ad=55.5f pd=0.74u as=55.5f ps=0.74u w=0.15u l=0.13u
X370 PH3.t5 buff_d8_4.inv_d8_0.VIN VDD.t105 VDD.t23 sg13_lv_pmos ad=55.5f pd=0.74u as=0.1005p ps=1.34u w=0.15u l=0.13u
X371 psdiff_1.buff_d8_0.VIN.t4 psdiff_2.VOUTDP VSS.t70 VSS.t69 sg13_lv_nmos ad=55.5f pd=0.74u as=55.5f ps=0.74u w=0.15u l=0.13u
X372 PH0.t7 buff_d8_5.inv_d8_0.VIN VSS.t523 VSS.t522 sg13_lv_nmos ad=55.5f pd=0.74u as=0.1005p ps=1.34u w=0.15u l=0.13u
X373 VSS.t299 buff_d8_4.inv_d8_0.VIN PH3.t6 VSS.t298 sg13_lv_nmos ad=0.1005p pd=1.34u as=55.5f ps=0.74u w=0.15u l=0.13u
X374 VDD.t266 a_7162_1266# psdiff_0.buff_d8_1.VIN.t29 VDD.t108 sg13_lv_pmos ad=55.5f pd=0.74u as=55.5f ps=0.74u w=0.15u l=0.13u
X375 VSS.t211 psdiff_1.buff_d8_1.inv_d8_0.VIN psdiff_1.VOUTDN VSS.t210 sg13_lv_nmos ad=0.1005p pd=1.34u as=55.5f ps=0.74u w=0.15u l=0.13u
X376 psdiff_1.buff_d8_0.VIN.t9 psdiff_2.VOUTDP VSS.t68 VSS.t54 sg13_lv_nmos ad=55.5f pd=0.74u as=55.5f ps=0.74u w=0.15u l=0.13u
X377 VSS.t61 psdiff_2.VOUTDP psdiff_1.buff_d8_0.VIN.t11 VSS.t53 sg13_lv_nmos ad=55.5f pd=0.74u as=55.5f ps=0.74u w=0.15u l=0.13u
X378 psdiff_1.buff_d8_1.VIN.t13 psdiff_2.VOUTDN VSS.t236 VSS.t249 sg13_lv_nmos ad=55.5f pd=0.74u as=55.5f ps=0.74u w=0.15u l=0.13u
X379 psdiff_2.buff_d8_0.VIN.t12 psdiff_2.CLKN VSS.t399 VSS.t384 sg13_lv_nmos ad=55.5f pd=0.74u as=55.5f ps=0.74u w=0.15u l=0.13u
X380 psdiff_1.VOUTDN psdiff_1.buff_d8_1.inv_d8_0.VIN VDD.t79 VDD.t33 sg13_lv_pmos ad=55.5f pd=0.74u as=0.1005p ps=1.34u w=0.15u l=0.13u
X381 VDD.t336 VSS.t611 psdiff_1.buff_d8_0.VIN.t22 VDD.t129 sg13_lv_pmos ad=55.5f pd=0.74u as=55.5f ps=0.74u w=0.15u l=0.13u
X382 psdiff_0.buff_d8_0.inv_d8_0.VIN psdiff_0.buff_d8_0.inv_d4_0.VIN VDD.t4 VDD.t0 sg13_lv_pmos ad=55.5f pd=0.74u as=0.1005p ps=1.34u w=0.15u l=0.13u
X383 CTRL.t1 PH1.t11 CTRL.t1 VDD.t27 sg13_lv_pmos ad=0.19p pd=1.38u as=0 ps=0 w=1u l=0.13u
X384 VSS.t139 buff_d8_0.inv_d4_0.VIN buff_d8_0.inv_d8_0.VIN VSS.t138 sg13_lv_nmos ad=0.1005p pd=1.34u as=55.5f ps=0.74u w=0.15u l=0.13u
X385 VDD.t281 VSS.t610 psdiff_2.buff_d8_0.VIN.t22 VDD.t169 sg13_lv_pmos ad=55.5f pd=0.74u as=55.5f ps=0.74u w=0.15u l=0.13u
X386 psdiff_2.buff_d8_1.VIN.t10 psdiff_2.CLKP.t8 VSS.t477 VSS.t476 sg13_lv_nmos ad=55.5f pd=0.74u as=55.5f ps=0.74u w=0.15u l=0.13u
X387 CTRL.t1 PH1.t11 CTRL.t1 VDD.t27 sg13_lv_pmos ad=0.19p pd=1.38u as=0 ps=0 w=1u l=0.13u
X388 VDD.t238 a_4188_1266# psdiff_1.buff_d8_1.VIN.t27 VDD.t129 sg13_lv_pmos ad=55.5f pd=0.74u as=55.5f ps=0.74u w=0.15u l=0.13u
X389 VSS.t392 psdiff_2.CLKP.t8 psdiff_2.buff_d8_1.VIN.t2 VSS.t463 sg13_lv_nmos ad=55.5f pd=0.74u as=55.5f ps=0.74u w=0.15u l=0.13u
X390 VDD.t282 VSS.t610 psdiff_2.buff_d8_0.VIN.t17 VDD.t169 sg13_lv_pmos ad=55.5f pd=0.74u as=55.5f ps=0.74u w=0.15u l=0.13u
X391 psdiff_0.buff_d8_1.VIN.t26 VSS.t612 VDD.t354 VDD.t108 sg13_lv_pmos ad=55.5f pd=0.74u as=55.5f ps=0.74u w=0.15u l=0.13u
X392 VDD.t233 a_4188_1266# psdiff_1.buff_d8_1.VIN.t28 VDD.t129 sg13_lv_pmos ad=55.5f pd=0.74u as=55.5f ps=0.74u w=0.15u l=0.13u
X393 buff_d8_4.inv_d8_0.VIN buff_d8_4.inv_d4_0.VIN VDD.t221 VDD.t23 sg13_lv_pmos ad=55.5f pd=0.74u as=0.1005p ps=1.34u w=0.15u l=0.13u
X394 VDD.t21 psdiff_2.buff_d8_0.inv_d8_0.VIN psdiff_2.VOUTDP VDD.t0 sg13_lv_pmos ad=0.1005p pd=1.34u as=55.5f ps=0.74u w=0.15u l=0.13u
X395 CTRL.t18 PH2.t10 CTRL.t18 VDD.t55 sg13_lv_pmos ad=0.19p pd=1.38u as=0 ps=0 w=1u l=0.13u
X396 PH5.t8 buff_d8_1.inv_d8_0.VIN VSS.t277 VSS.t276 sg13_lv_nmos ad=55.5f pd=0.74u as=0.1005p ps=1.34u w=0.15u l=0.13u
X397 buff_d8_1.inv_d4_0.VIN buff_d8_1.inv_d2_0.VIN VSS.t315 VSS.t314 sg13_lv_nmos ad=55.5f pd=0.74u as=0.1005p ps=1.34u w=0.15u l=0.13u
X398 CTRL.t18 PH2.t10 CTRL.t18 VDD.t55 sg13_lv_pmos ad=0.19p pd=1.38u as=0 ps=0 w=1u l=0.13u
X399 CTRL.t0 PH4.t10 CTRL.t0 VDD.t149 sg13_lv_pmos ad=0.19p pd=1.38u as=0 ps=0 w=1u l=0.13u
X400 VSS.t348 psdiff_1.VOUTDP psdiff_0.buff_d8_0.VIN.t19 VSS.t347 sg13_lv_nmos ad=0.1005p pd=1.34u as=55.5f ps=0.74u w=0.15u l=0.13u
X401 PH2.t5 buff_d8_0.inv_d8_0.VIN VDD.t227 VDD.t55 sg13_lv_pmos ad=55.5f pd=0.74u as=0.1005p ps=1.34u w=0.15u l=0.13u
X402 CTRL.t8 PH0.t10 CTRL.t8 VDD.t46 sg13_lv_pmos ad=0.19p pd=1.38u as=0 ps=0 w=1u l=0.13u
X403 CTRL.t4 PH4.t10 CTRL.t0 VDD.t149 sg13_lv_pmos ad=0.34p pd=2.68u as=0 ps=0 w=1u l=0.13u
X404 buff_d8_0.inv_d8_0.VIN buff_d8_0.inv_d4_0.VIN VDD.t40 VDD.t38 sg13_lv_pmos ad=55.5f pd=0.74u as=0.1005p ps=1.34u w=0.15u l=0.13u
X405 VSS.t344 psdiff_1.VOUTDP psdiff_0.buff_d8_0.VIN.t18 VSS.t336 sg13_lv_nmos ad=55.5f pd=0.74u as=55.5f ps=0.74u w=0.15u l=0.13u
X406 psdiff_1.VOUTDP psdiff_1.buff_d8_0.inv_d8_0.VIN VDD.t10 VDD.t0 sg13_lv_pmos ad=55.5f pd=0.74u as=0.1005p ps=1.34u w=0.15u l=0.13u
X407 psdiff_0.buff_d8_1.VIN.t11 psdiff_1.VOUTDN VSS.t109 VSS.t93 sg13_lv_nmos ad=55.5f pd=0.74u as=55.5f ps=0.74u w=0.15u l=0.13u
X408 CTRL.t8 PH0.t10 CTRL.t8 VDD.t46 sg13_lv_pmos ad=0.19p pd=1.38u as=0 ps=0 w=1u l=0.13u
X409 psdiff_0.buff_d8_1.inv_d8_0.VIN psdiff_0.buff_d8_1.inv_d4_0.VIN VDD.t145 VDD.t33 sg13_lv_pmos ad=55.5f pd=0.74u as=0.1005p ps=1.34u w=0.15u l=0.13u
X410 psdiff_1.buff_d8_0.VIN.t8 psdiff_2.VOUTDP VSS.t66 VSS.t54 sg13_lv_nmos ad=55.5f pd=0.74u as=55.5f ps=0.74u w=0.15u l=0.13u
X411 psdiff_2.buff_d8_1.inv_d8_0.VIN psdiff_2.buff_d8_1.inv_d4_0.VIN VSS.t563 VSS.t562 sg13_lv_nmos ad=55.5f pd=0.74u as=0.1005p ps=1.34u w=0.15u l=0.13u
X412 psdiff_1.buff_d8_1.VIN.t18 VSS.t611 VDD.t325 VDD.t129 sg13_lv_pmos ad=55.5f pd=0.74u as=55.5f ps=0.74u w=0.15u l=0.13u
X413 VSS.t297 buff_d8_4.inv_d8_0.VIN PH3.t9 VSS.t296 sg13_lv_nmos ad=0.1005p pd=1.34u as=55.5f ps=0.74u w=0.15u l=0.13u
X414 VSS.t59 psdiff_2.VOUTDP psdiff_1.buff_d8_0.VIN.t10 VSS.t53 sg13_lv_nmos ad=55.5f pd=0.74u as=55.5f ps=0.74u w=0.15u l=0.13u
X415 psdiff_2.buff_d8_0.VIN.t11 psdiff_2.CLKN VSS.t398 VSS.t384 sg13_lv_nmos ad=55.5f pd=0.74u as=55.5f ps=0.74u w=0.15u l=0.13u
X416 psdiff_2.CLKP.t2 psdiff_0.buff_d8_1.inv_d8_0.VIN VDD.t167 VDD.t33 sg13_lv_pmos ad=55.5f pd=0.74u as=0.1005p ps=1.34u w=0.15u l=0.13u
X417 psdiff_1.buff_d8_1.VIN.t12 psdiff_2.VOUTDN VSS.t260 VSS.t249 sg13_lv_nmos ad=55.5f pd=0.74u as=55.5f ps=0.74u w=0.15u l=0.13u
X418 VSS.t368 psdiff_0.buff_d8_1.inv_d4_0.VIN psdiff_0.buff_d8_1.inv_d8_0.VIN VSS.t367 sg13_lv_nmos ad=0.1005p pd=1.34u as=55.5f ps=0.74u w=0.15u l=0.13u
X419 CTRL.t16 PH2.t10 CTRL.t16 VDD.t55 sg13_lv_pmos ad=0.19p pd=1.38u as=0 ps=0 w=1u l=0.13u
X420 psdiff_0.buff_d8_1.inv_d2_0.VIN psdiff_0.buff_d8_1.VIN.t32 VSS.t175 VSS.t174 sg13_lv_nmos ad=0.1005p pd=1.34u as=0.1005p ps=1.34u w=0.15u l=0.13u
X421 CTRL.t16 PH2.t10 CTRL.t16 VDD.t55 sg13_lv_pmos ad=0.19p pd=1.38u as=0 ps=0 w=1u l=0.13u
X422 CTRL.t20 PH5.t10 CTRL.t20 VDD.t38 sg13_lv_pmos ad=0.19p pd=1.38u as=0 ps=0 w=1u l=0.13u
X423 psdiff_2.buff_d8_1.VIN.t19 VSS.t610 VDD.t297 VDD.t169 sg13_lv_pmos ad=55.5f pd=0.74u as=55.5f ps=0.74u w=0.15u l=0.13u
X424 psdiff_2.buff_d8_0.VIN.t10 psdiff_2.CLKN VSS.t397 VSS.t396 sg13_lv_nmos ad=55.5f pd=0.74u as=55.5f ps=0.74u w=0.15u l=0.13u
X425 CTRL.t20 PH5.t10 CTRL.t20 VDD.t41 sg13_lv_pmos ad=0.19p pd=1.38u as=0 ps=0 w=1u l=0.13u
X426 psdiff_2.buff_d8_1.VIN.t30 a_1214_1266# VDD.t173 VDD.t169 sg13_lv_pmos ad=55.5f pd=0.74u as=55.5f ps=0.74u w=0.15u l=0.13u
X427 VSS.t106 psdiff_1.VOUTDN psdiff_0.buff_d8_1.VIN.t13 VSS.t92 sg13_lv_nmos ad=55.5f pd=0.74u as=55.5f ps=0.74u w=0.15u l=0.13u
X428 VDD.t334 VSS.t611 psdiff_1.buff_d8_1.VIN.t26 VDD.t129 sg13_lv_pmos ad=0.1005p pd=1.34u as=55.5f ps=0.74u w=0.15u l=0.13u
X429 VSS.t571 buff_d8_4.inv_d4_0.VIN buff_d8_4.inv_d8_0.VIN VSS.t570 sg13_lv_nmos ad=0.1005p pd=1.34u as=55.5f ps=0.74u w=0.15u l=0.13u
X430 VDD.t87 psdiff_2.buff_d8_1.inv_d8_0.VIN psdiff_2.VOUTDN VDD.t33 sg13_lv_pmos ad=0.1005p pd=1.34u as=55.5f ps=0.74u w=0.15u l=0.13u
X431 PH1.t3 buff_d8_3.inv_d8_0.VIN VDD.t211 VDD.t23 sg13_lv_pmos ad=55.5f pd=0.74u as=0.1005p ps=1.34u w=0.15u l=0.13u
X432 psdiff_1.buff_d8_0.VIN.t30 VSS.t611 VDD.t323 VDD.t129 sg13_lv_pmos ad=55.5f pd=0.74u as=55.5f ps=0.74u w=0.15u l=0.13u
X433 VSS.t343 psdiff_1.VOUTDP psdiff_0.buff_d8_0.VIN.t17 VSS.t336 sg13_lv_nmos ad=55.5f pd=0.74u as=55.5f ps=0.74u w=0.15u l=0.13u
X434 psdiff_0.buff_d8_1.VIN.t10 psdiff_1.VOUTDN VSS.t110 VSS.t93 sg13_lv_nmos ad=55.5f pd=0.74u as=55.5f ps=0.74u w=0.15u l=0.13u
X435 VDD.t378 VSS.t612 psdiff_0.buff_d8_0.VIN.t26 VDD.t108 sg13_lv_pmos ad=55.5f pd=0.74u as=55.5f ps=0.74u w=0.15u l=0.13u
X436 VSS.t471 psdiff_2.CLKP.t8 psdiff_2.buff_d8_1.VIN.t12 VSS.t457 sg13_lv_nmos ad=55.5f pd=0.74u as=55.5f ps=0.74u w=0.15u l=0.13u
X437 VSS.t193 psdiff_2.buff_d8_0.inv_d2_0.VIN psdiff_2.buff_d8_0.inv_d4_0.VIN VSS.t192 sg13_lv_nmos ad=0.1005p pd=1.34u as=55.5f ps=0.74u w=0.15u l=0.13u
X438 psdiff_2.buff_d8_0.VIN.t25 VSS.t610 VDD.t296 VDD.t169 sg13_lv_pmos ad=55.5f pd=0.74u as=55.5f ps=0.74u w=0.15u l=0.13u
X439 VSS.t549 buff_d8_3.inv_d8_0.VIN PH1.t9 VSS.t548 sg13_lv_nmos ad=0.1005p pd=1.34u as=55.5f ps=0.74u w=0.15u l=0.13u
X440 psdiff_2.buff_d8_0.VIN.t19 VSS.t610 VDD.t295 VDD.t169 sg13_lv_pmos ad=55.5f pd=0.74u as=55.5f ps=0.74u w=0.15u l=0.13u
X441 VDD.t358 VSS.t612 psdiff_0.buff_d8_1.VIN.t25 VDD.t108 sg13_lv_pmos ad=55.5f pd=0.74u as=55.5f ps=0.74u w=0.15u l=0.13u
X442 psdiff_1.buff_d8_0.inv_d8_0.VIN psdiff_1.buff_d8_0.inv_d4_0.VIN VDD.t244 VDD.t0 sg13_lv_pmos ad=55.5f pd=0.74u as=0.1005p ps=1.34u w=0.15u l=0.13u
X443 psdiff_2.CLKP.t1 psdiff_0.buff_d8_1.inv_d8_0.VIN VDD.t166 VDD.t33 sg13_lv_pmos ad=55.5f pd=0.74u as=0.1005p ps=1.34u w=0.15u l=0.13u
X444 VDD.t153 buff_d8_2.inv_d8_0.VIN PH4.t3 VDD.t30 sg13_lv_pmos ad=0.1005p pd=1.34u as=55.5f ps=0.74u w=0.15u l=0.13u
X445 psdiff_1.buff_d8_0.VIN.t7 psdiff_2.VOUTDP VSS.t64 VSS.t63 sg13_lv_nmos ad=55.5f pd=0.74u as=55.5f ps=0.74u w=0.15u l=0.13u
X446 VDD.t271 PH4.t11 PH1.t0 VDD.t43 sg13_lv_pmos ad=0.1005p pd=1.34u as=55.5f ps=0.74u w=0.15u l=0.13u
X447 CTRL.t0 PH1.t11 CTRL.t0 VDD.t27 sg13_lv_pmos ad=0.19p pd=1.38u as=0 ps=0 w=1u l=0.13u
X448 CTRL.t18 PH5.t10 CTRL.t18 VDD.t38 sg13_lv_pmos ad=0.19p pd=1.38u as=0 ps=0 w=1u l=0.13u
X449 VDD.t294 VSS.t610 psdiff_2.buff_d8_1.VIN.t22 VDD.t169 sg13_lv_pmos ad=0.1005p pd=1.34u as=55.5f ps=0.74u w=0.15u l=0.13u
X450 PH2.t8 buff_d8_0.inv_d8_0.VIN VSS.t583 VSS.t582 sg13_lv_nmos ad=55.5f pd=0.74u as=0.1005p ps=1.34u w=0.15u l=0.13u
X451 psdiff_0.buff_d8_0.VIN.t3 a_6005_1122# VDD.t111 VDD.t108 sg13_lv_pmos ad=55.5f pd=0.74u as=55.5f ps=0.74u w=0.15u l=0.13u
X452 CTRL.t18 PH5.t10 CTRL.t18 VDD.t41 sg13_lv_pmos ad=0.19p pd=1.38u as=0 ps=0 w=1u l=0.13u
X453 CTRL.t0 PH1.t11 CTRL.t0 VDD.t30 sg13_lv_pmos ad=0.19p pd=1.38u as=0 ps=0 w=1u l=0.13u
X454 buff_d8_5.inv_d8_0.VIN buff_d8_5.inv_d4_0.VIN VDD.t190 VDD.t47 sg13_lv_pmos ad=55.5f pd=0.74u as=0.1005p ps=1.34u w=0.15u l=0.13u
X455 CTRL.t13 PH3.t10 CTRL.t13 VDD.t60 sg13_lv_pmos ad=0.19p pd=1.38u as=0 ps=0 w=1u l=0.13u
X456 VDD.t72 psdiff_1.buff_d8_1.inv_d4_0.VIN psdiff_1.buff_d8_1.inv_d8_0.VIN VDD.t33 sg13_lv_pmos ad=0.1005p pd=1.34u as=55.5f ps=0.74u w=0.15u l=0.13u
X457 PH0.t0 PH3.t11 VDD.t62 VDD.t48 sg13_lv_pmos ad=55.5f pd=0.74u as=0.1005p ps=1.34u w=0.15u l=0.13u
X458 CTRL.t13 PH0.t10 CTRL.t13 VDD.t47 sg13_lv_pmos ad=0.19p pd=1.38u as=0 ps=0 w=1u l=0.13u
X459 VSS.t103 psdiff_1.VOUTDN psdiff_0.buff_d8_1.VIN.t12 VSS.t92 sg13_lv_nmos ad=55.5f pd=0.74u as=55.5f ps=0.74u w=0.15u l=0.13u
X460 VDD.t376 VSS.t612 psdiff_0.buff_d8_0.VIN.t31 VDD.t108 sg13_lv_pmos ad=55.5f pd=0.74u as=55.5f ps=0.74u w=0.15u l=0.13u
X461 psdiff_1.buff_d8_0.VIN.t21 a_3031_1122# VDD.t136 VDD.t129 sg13_lv_pmos ad=55.5f pd=0.74u as=0.1005p ps=1.34u w=0.15u l=0.13u
X462 VDD.t123 buff_d8_1.inv_d2_0.VIN buff_d8_1.inv_d4_0.VIN VDD.t23 sg13_lv_pmos ad=0.1005p pd=1.34u as=55.5f ps=0.74u w=0.15u l=0.13u
X463 VDD.t20 psdiff_2.buff_d8_0.inv_d8_0.VIN psdiff_2.VOUTDP VDD.t0 sg13_lv_pmos ad=0.1005p pd=1.34u as=55.5f ps=0.74u w=0.15u l=0.13u
X464 psdiff_2.VOUTDN psdiff_2.buff_d8_1.inv_d8_0.VIN VDD.t86 VDD.t33 sg13_lv_pmos ad=55.5f pd=0.74u as=0.1005p ps=1.34u w=0.15u l=0.13u
X465 psdiff_1.buff_d8_0.VIN.t17 a_3031_1122# VDD.t135 VDD.t129 sg13_lv_pmos ad=55.5f pd=0.74u as=55.5f ps=0.74u w=0.15u l=0.13u
X466 psdiff_2.CLKN psdiff_0.buff_d8_0.inv_d8_0.VIN VSS.t495 VSS.t494 sg13_lv_nmos ad=55.5f pd=0.74u as=0.1005p ps=1.34u w=0.15u l=0.13u
X467 VSS.t309 buff_d8_5.inv_d2_0.VIN buff_d8_5.inv_d4_0.VIN VSS.t308 sg13_lv_nmos ad=0.1005p pd=1.34u as=55.5f ps=0.74u w=0.15u l=0.13u
X468 VSS.t419 buff_d8_2.inv_d8_0.VIN PH4.t8 VSS.t418 sg13_lv_nmos ad=0.1005p pd=1.34u as=55.5f ps=0.74u w=0.15u l=0.13u
X469 psdiff_0.buff_d8_1.VIN.t19 VSS.t612 VDD.t364 VDD.t108 sg13_lv_pmos ad=55.5f pd=0.74u as=55.5f ps=0.74u w=0.15u l=0.13u
X470 VSS.t305 buff_d8_4.inv_d2_0.VIN buff_d8_4.inv_d4_0.VIN VSS.t304 sg13_lv_nmos ad=0.1005p pd=1.34u as=55.5f ps=0.74u w=0.15u l=0.13u
X471 buff_d8_5.inv_d8_0.VIN buff_d8_5.inv_d4_0.VIN VSS.t509 VSS.t508 sg13_lv_nmos ad=55.5f pd=0.74u as=0.1005p ps=1.34u w=0.15u l=0.13u
X472 buff_d8_1.inv_d8_0.VIN buff_d8_1.inv_d4_0.VIN VDD.t127 VDD.t23 sg13_lv_pmos ad=55.5f pd=0.74u as=0.1005p ps=1.34u w=0.15u l=0.13u
X473 VDD.t196 buff_d8_5.inv_d8_0.VIN PH0.t5 VDD.t46 sg13_lv_pmos ad=0.1005p pd=1.34u as=55.5f ps=0.74u w=0.15u l=0.13u
X474 VSS.t469 psdiff_2.CLKP.t8 psdiff_2.buff_d8_1.VIN.t11 VSS.t457 sg13_lv_nmos ad=55.5f pd=0.74u as=55.5f ps=0.74u w=0.15u l=0.13u
X475 psdiff_1.buff_d8_0.inv_d8_0.VIN psdiff_1.buff_d8_0.inv_d4_0.VIN VSS.t595 VSS.t594 sg13_lv_nmos ad=55.5f pd=0.74u as=0.1005p ps=1.34u w=0.15u l=0.13u
X476 CTRL.t16 PH5.t10 CTRL.t16 VDD.t38 sg13_lv_pmos ad=0.19p pd=1.38u as=0 ps=0 w=1u l=0.13u
X477 psdiff_2.buff_d8_1.inv_d2_0.VIN psdiff_2.buff_d8_1.VIN.t32 VDD.t68 VDD.t33 sg13_lv_pmos ad=0.1005p pd=1.34u as=0.1005p ps=1.34u w=0.15u l=0.13u
X478 VDD.t277 VSS.t610 psdiff_2.buff_d8_1.VIN.t26 VDD.t169 sg13_lv_pmos ad=55.5f pd=0.74u as=55.5f ps=0.74u w=0.15u l=0.13u
X479 VSS.t7 psdiff_0.buff_d8_0.inv_d4_0.VIN psdiff_0.buff_d8_0.inv_d8_0.VIN VSS.t6 sg13_lv_nmos ad=0.1005p pd=1.34u as=55.5f ps=0.74u w=0.15u l=0.13u
X480 VSS.t547 buff_d8_3.inv_d8_0.VIN PH1.t8 VSS.t546 sg13_lv_nmos ad=0.1005p pd=1.34u as=55.5f ps=0.74u w=0.15u l=0.13u
X481 VDD.t185 psdiff_0.buff_d8_0.inv_d8_0.VIN psdiff_2.CLKN VDD.t0 sg13_lv_pmos ad=0.1005p pd=1.34u as=55.5f ps=0.74u w=0.15u l=0.13u
X482 PH1.t7 buff_d8_3.inv_d8_0.VIN VSS.t545 VSS.t544 sg13_lv_nmos ad=55.5f pd=0.74u as=0.1005p ps=1.34u w=0.15u l=0.13u
X483 CTRL.t3 PH4.t10 CTRL.t3 VDD.t149 sg13_lv_pmos ad=0.19p pd=1.38u as=0 ps=0 w=1u l=0.13u
X484 CTRL.t16 PH5.t10 CTRL.t16 VDD.t41 sg13_lv_pmos ad=0.19p pd=1.38u as=0 ps=0 w=1u l=0.13u
X485 VDD.t104 buff_d8_4.inv_d8_0.VIN PH3.t3 VDD.t23 sg13_lv_pmos ad=0.1005p pd=1.34u as=55.5f ps=0.74u w=0.15u l=0.13u
X486 buff_d8_5.inv_d4_0.VIN buff_d8_5.inv_d2_0.VIN VDD.t122 VDD.t61 sg13_lv_pmos ad=55.5f pd=0.74u as=0.1005p ps=1.34u w=0.15u l=0.13u
X487 PH4.t2 buff_d8_2.inv_d8_0.VIN VDD.t152 VDD.t61 sg13_lv_pmos ad=55.5f pd=0.74u as=0.1005p ps=1.34u w=0.15u l=0.13u
X488 VDD.t217 psdiff_2.buff_d8_1.inv_d4_0.VIN psdiff_2.buff_d8_1.inv_d8_0.VIN VDD.t33 sg13_lv_pmos ad=0.1005p pd=1.34u as=55.5f ps=0.74u w=0.15u l=0.13u
X489 VDD.t3 psdiff_0.buff_d8_0.inv_d4_0.VIN psdiff_0.buff_d8_0.inv_d8_0.VIN VDD.t0 sg13_lv_pmos ad=0.1005p pd=1.34u as=55.5f ps=0.74u w=0.15u l=0.13u
X490 buff_d8_0.inv_d4_0.VIN buff_d8_0.inv_d2_0.VIN VSS.t429 VSS.t428 sg13_lv_nmos ad=55.5f pd=0.74u as=0.1005p ps=1.34u w=0.15u l=0.13u
X491 CTRL.t11 PH3.t10 CTRL.t11 VDD.t60 sg13_lv_pmos ad=0.19p pd=1.38u as=0 ps=0 w=1u l=0.13u
X492 VSS.t390 psdiff_2.CLKN psdiff_2.buff_d8_0.VIN.t12 VSS.t377 sg13_lv_nmos ad=55.5f pd=0.74u as=55.5f ps=0.74u w=0.15u l=0.13u
X493 psdiff_2.buff_d8_0.VIN.t9 psdiff_2.CLKN VSS.t394 VSS.t375 sg13_lv_nmos ad=55.5f pd=0.74u as=55.5f ps=0.74u w=0.15u l=0.13u
X494 CTRL.t22 PH2.t10 CTRL.t22 VDD.t55 sg13_lv_pmos ad=0.19p pd=1.38u as=0 ps=0 w=1u l=0.13u
X495 VDD.t315 VSS.t611 psdiff_1.buff_d8_0.VIN.t27 VDD.t129 sg13_lv_pmos ad=55.5f pd=0.74u as=55.5f ps=0.74u w=0.15u l=0.13u
X496 CTRL.t11 PH0.t10 CTRL.t11 VDD.t47 sg13_lv_pmos ad=0.19p pd=1.38u as=0 ps=0 w=1u l=0.13u
X497 VDD.t134 a_3031_1122# psdiff_1.buff_d8_0.VIN.t18 VDD.t129 sg13_lv_pmos ad=55.5f pd=0.74u as=55.5f ps=0.74u w=0.15u l=0.13u
X498 CTRL.t13 PH0.t10 CTRL.t13 VDD.t46 sg13_lv_pmos ad=0.19p pd=1.38u as=0 ps=0 w=1u l=0.13u
X499 psdiff_0.buff_d8_1.VIN.t18 VSS.t612 VDD.t361 VDD.t108 sg13_lv_pmos ad=55.5f pd=0.74u as=55.5f ps=0.74u w=0.15u l=0.13u
X500 VDD.t69 psdiff_2.buff_d8_0.inv_d2_0.VIN psdiff_2.buff_d8_0.inv_d4_0.VIN VDD.t0 sg13_lv_pmos ad=0.1005p pd=1.34u as=55.5f ps=0.74u w=0.15u l=0.13u
X501 VDD.t236 a_4188_1266# psdiff_1.buff_d8_1.VIN.t31 VDD.t129 sg13_lv_pmos ad=55.5f pd=0.74u as=55.5f ps=0.74u w=0.15u l=0.13u
X502 VDD.t275 VSS.t610 psdiff_2.buff_d8_0.VIN.t21 VDD.t169 sg13_lv_pmos ad=55.5f pd=0.74u as=55.5f ps=0.74u w=0.15u l=0.13u
X503 VDD.t231 a_4188_1266# psdiff_1.buff_d8_1.VIN.t29 VDD.t129 sg13_lv_pmos ad=55.5f pd=0.74u as=55.5f ps=0.74u w=0.15u l=0.13u
X504 PH5.t2 buff_d8_1.inv_d8_0.VIN VDD.t96 VDD.t23 sg13_lv_pmos ad=55.5f pd=0.74u as=0.1005p ps=1.34u w=0.15u l=0.13u
X505 psdiff_2.VOUTDN psdiff_2.buff_d8_1.inv_d8_0.VIN VDD.t85 VDD.t33 sg13_lv_pmos ad=55.5f pd=0.74u as=0.1005p ps=1.34u w=0.15u l=0.13u
X506 psdiff_0.buff_d8_0.inv_d4_0.VIN psdiff_0.buff_d8_0.inv_d2_0.VIN VSS.t3 VSS.t2 sg13_lv_nmos ad=55.5f pd=0.74u as=0.1005p ps=1.34u w=0.15u l=0.13u
X507 VSS.t417 buff_d8_2.inv_d8_0.VIN PH4.t6 VSS.t416 sg13_lv_nmos ad=0.1005p pd=1.34u as=55.5f ps=0.74u w=0.15u l=0.13u
X508 VSS.t227 psdiff_2.buff_d8_1.inv_d8_0.VIN psdiff_2.VOUTDN VSS.t226 sg13_lv_nmos ad=0.1005p pd=1.34u as=55.5f ps=0.74u w=0.15u l=0.13u
X509 VSS.t99 psdiff_1.VOUTDN psdiff_0.buff_d8_1.VIN.t11 VSS.t89 sg13_lv_nmos ad=55.5f pd=0.74u as=55.5f ps=0.74u w=0.15u l=0.13u
X510 VDD.t172 a_1214_1266# psdiff_2.buff_d8_1.VIN.t29 VDD.t169 sg13_lv_pmos ad=55.5f pd=0.74u as=55.5f ps=0.74u w=0.15u l=0.13u
X511 psdiff_2.buff_d8_0.inv_d8_0.VIN psdiff_2.buff_d8_0.inv_d4_0.VIN VSS.t603 VSS.t602 sg13_lv_nmos ad=55.5f pd=0.74u as=0.1005p ps=1.34u w=0.15u l=0.13u
X512 psdiff_1.buff_d8_1.VIN.t25 VSS.t611 VDD.t331 VDD.t129 sg13_lv_pmos ad=55.5f pd=0.74u as=55.5f ps=0.74u w=0.15u l=0.13u
X513 PH3.t0 PH0.t11 VDD.t49 VDD.t48 sg13_lv_pmos ad=55.5f pd=0.74u as=0.1005p ps=1.34u w=0.15u l=0.13u
X514 CTRL.t2 PH4.t10 CTRL.t2 VDD.t149 sg13_lv_pmos ad=0.19p pd=1.38u as=0 ps=0 w=1u l=0.13u
X515 VSS.t593 psdiff_1.buff_d8_0.inv_d4_0.VIN psdiff_1.buff_d8_0.inv_d8_0.VIN VSS.t592 sg13_lv_nmos ad=0.1005p pd=1.34u as=55.5f ps=0.74u w=0.15u l=0.13u
X516 psdiff_2.VOUTDP psdiff_2.buff_d8_0.inv_d8_0.VIN VDD.t19 VDD.t0 sg13_lv_pmos ad=55.5f pd=0.74u as=0.1005p ps=1.34u w=0.15u l=0.13u
X517 CTRL.t9 PH3.t10 CTRL.t9 VDD.t60 sg13_lv_pmos ad=0.19p pd=1.38u as=0 ps=0 w=1u l=0.13u
X518 VSS.t62 psdiff_2.VOUTDP psdiff_1.buff_d8_0.VIN.t9 VSS.t48 sg13_lv_nmos ad=0.1005p pd=1.34u as=55.5f ps=0.74u w=0.15u l=0.13u
X519 psdiff_1.buff_d8_0.VIN.t6 psdiff_2.VOUTDP VSS.t61 VSS.t46 sg13_lv_nmos ad=55.5f pd=0.74u as=55.5f ps=0.74u w=0.15u l=0.13u
X520 VDD.t103 buff_d8_4.inv_d8_0.VIN PH3.t2 VDD.t23 sg13_lv_pmos ad=0.1005p pd=1.34u as=55.5f ps=0.74u w=0.15u l=0.13u
X521 buff_d8_3.inv_d4_0.VIN buff_d8_3.inv_d2_0.VIN VSS.t433 VSS.t432 sg13_lv_nmos ad=55.5f pd=0.74u as=0.1005p ps=1.34u w=0.15u l=0.13u
X522 VSS.t255 psdiff_2.VOUTDN psdiff_1.buff_d8_1.VIN.t13 VSS.t240 sg13_lv_nmos ad=55.5f pd=0.74u as=55.5f ps=0.74u w=0.15u l=0.13u
X523 CTRL.t9 PH0.t10 CTRL.t9 VDD.t47 sg13_lv_pmos ad=0.19p pd=1.38u as=0 ps=0 w=1u l=0.13u
X524 psdiff_2.buff_d8_1.inv_d8_0.VIN psdiff_2.buff_d8_1.inv_d4_0.VIN VDD.t216 VDD.t33 sg13_lv_pmos ad=55.5f pd=0.74u as=0.1005p ps=1.34u w=0.15u l=0.13u
X525 psdiff_2.buff_d8_0.VIN.t1 CTRL.t25 a_1214_1266# VSS.t149 sg13_lv_nmos ad=0.1005p pd=1.34u as=55.5f ps=0.74u w=0.15u l=0.13u
X526 VSS.t467 psdiff_2.CLKP.t8 psdiff_2.buff_d8_1.VIN.t10 VSS.t472 sg13_lv_nmos ad=55.5f pd=0.74u as=55.5f ps=0.74u w=0.15u l=0.13u
X527 psdiff_2.CLKP.t6 psdiff_0.buff_d8_1.inv_d8_0.VIN VSS.t441 VSS.t440 sg13_lv_nmos ad=55.5f pd=0.74u as=0.1005p ps=1.34u w=0.15u l=0.13u
X528 VSS.t388 psdiff_2.CLKN psdiff_2.buff_d8_0.VIN.t11 VSS.t377 sg13_lv_nmos ad=55.5f pd=0.74u as=55.5f ps=0.74u w=0.15u l=0.13u
X529 psdiff_2.buff_d8_0.VIN.t8 psdiff_2.CLKN VSS.t392 VSS.t375 sg13_lv_nmos ad=55.5f pd=0.74u as=55.5f ps=0.74u w=0.15u l=0.13u
X530 psdiff_0.buff_d8_1.inv_d4_0.VIN psdiff_0.buff_d8_1.inv_d2_0.VIN VSS.t362 VSS.t361 sg13_lv_nmos ad=55.5f pd=0.74u as=0.1005p ps=1.34u w=0.15u l=0.13u
X531 CTRL.t11 PH0.t10 CTRL.t11 VDD.t46 sg13_lv_pmos ad=0.19p pd=1.38u as=0 ps=0 w=1u l=0.13u
X532 psdiff_0.buff_d8_0.VIN.t30 VSS.t612 VDD.t373 VDD.t108 sg13_lv_pmos ad=55.5f pd=0.74u as=55.5f ps=0.74u w=0.15u l=0.13u
X533 psdiff_2.VOUTDP psdiff_2.buff_d8_0.inv_d8_0.VIN VSS.t33 VSS.t32 sg13_lv_nmos ad=55.5f pd=0.74u as=0.1005p ps=1.34u w=0.15u l=0.13u
X534 psdiff_0.buff_d8_1.VIN.t31 a_7162_1266# VDD.t265 VDD.t108 sg13_lv_pmos ad=55.5f pd=0.74u as=55.5f ps=0.74u w=0.15u l=0.13u
X535 CTRL.t22 PH5.t10 CTRL.t22 VDD.t36 sg13_lv_pmos ad=0.19p pd=1.38u as=0 ps=0 w=1u l=0.13u
X536 VDD.t254 a_57_1122# psdiff_2.buff_d8_0.VIN.t31 VDD.t169 sg13_lv_pmos ad=55.5f pd=0.74u as=55.5f ps=0.74u w=0.15u l=0.13u
X537 psdiff_0.buff_d8_1.VIN.t8 psdiff_1.VOUTDN VSS.t106 VSS.t85 sg13_lv_nmos ad=55.5f pd=0.74u as=55.5f ps=0.74u w=0.15u l=0.13u
X538 psdiff_2.buff_d8_1.VIN.t25 VSS.t610 VDD.t291 VDD.t169 sg13_lv_pmos ad=55.5f pd=0.74u as=55.5f ps=0.74u w=0.15u l=0.13u
X539 psdiff_2.buff_d8_1.VIN.t24 VSS.t610 VDD.t279 VDD.t169 sg13_lv_pmos ad=55.5f pd=0.74u as=55.5f ps=0.74u w=0.15u l=0.13u
X540 VSS.t31 psdiff_2.buff_d8_0.inv_d8_0.VIN psdiff_2.VOUTDP VSS.t30 sg13_lv_nmos ad=0.1005p pd=1.34u as=55.5f ps=0.74u w=0.15u l=0.13u
X541 CTRL.t3 PH1.t11 CTRL.t3 VDD.t25 sg13_lv_pmos ad=0.19p pd=1.38u as=0 ps=0 w=1u l=0.13u
X542 CTRL.t1 PH4.t10 CTRL.t1 VDD.t149 sg13_lv_pmos ad=0.19p pd=1.38u as=0 ps=0 w=1u l=0.13u
X543 a_7162_1266# CTRL.t26 psdiff_0.buff_d8_0.VIN.t0 VSS.t148 sg13_lv_nmos ad=55.5f pd=0.74u as=0.1005p ps=1.34u w=0.15u l=0.13u
X544 VSS.t225 psdiff_2.buff_d8_1.inv_d8_0.VIN psdiff_2.VOUTDN VSS.t224 sg13_lv_nmos ad=0.1005p pd=1.34u as=55.5f ps=0.74u w=0.15u l=0.13u
X545 psdiff_1.buff_d8_1.inv_d2_0.VIN psdiff_1.buff_d8_1.VIN.t32 VSS.t163 VSS.t162 sg13_lv_nmos ad=0.1005p pd=1.34u as=0.1005p ps=1.34u w=0.15u l=0.13u
X546 psdiff_2.buff_d8_1.VIN.t0 CTRL.t25 a_57_1122# VSS.t147 sg13_lv_nmos ad=0.1005p pd=1.34u as=55.5f ps=0.74u w=0.15u l=0.13u
X547 psdiff_0.buff_d8_0.VIN.t16 psdiff_1.VOUTDP VSS.t344 VSS.t326 sg13_lv_nmos ad=55.5f pd=0.74u as=55.5f ps=0.74u w=0.15u l=0.13u
X548 psdiff_1.buff_d8_1.VIN.t11 psdiff_2.VOUTDN VSS.t258 VSS.t237 sg13_lv_nmos ad=55.5f pd=0.74u as=0.1005p ps=1.34u w=0.15u l=0.13u
X549 VDD.t9 psdiff_1.buff_d8_0.inv_d8_0.VIN psdiff_1.VOUTDP VDD.t0 sg13_lv_pmos ad=0.1005p pd=1.34u as=55.5f ps=0.74u w=0.15u l=0.13u
X550 VSS.t97 psdiff_1.VOUTDN psdiff_0.buff_d8_1.VIN.t10 VSS.t89 sg13_lv_nmos ad=55.5f pd=0.74u as=55.5f ps=0.74u w=0.15u l=0.13u
X551 CTRL.t3 PH1.t11 CTRL.t3 VDD.t27 sg13_lv_pmos ad=0.19p pd=1.38u as=0 ps=0 w=1u l=0.13u
X552 psdiff_2.CLKN psdiff_0.buff_d8_0.inv_d8_0.VIN VSS.t493 VSS.t492 sg13_lv_nmos ad=55.5f pd=0.74u as=0.1005p ps=1.34u w=0.15u l=0.13u
X553 CTRL.t22 PH5.t10 CTRL.t22 VDD.t38 sg13_lv_pmos ad=0.19p pd=1.38u as=0 ps=0 w=1u l=0.13u
X554 VSS.t60 psdiff_2.VOUTDP psdiff_1.buff_d8_0.VIN.t8 VSS.t48 sg13_lv_nmos ad=0.1005p pd=1.34u as=55.5f ps=0.74u w=0.15u l=0.13u
X555 psdiff_1.buff_d8_0.VIN.t5 psdiff_2.VOUTDP VSS.t59 VSS.t46 sg13_lv_nmos ad=55.5f pd=0.74u as=55.5f ps=0.74u w=0.15u l=0.13u
X556 VSS.t253 psdiff_2.VOUTDN psdiff_1.buff_d8_1.VIN.t12 VSS.t240 sg13_lv_nmos ad=55.5f pd=0.74u as=55.5f ps=0.74u w=0.15u l=0.13u
X557 CTRL.t9 PH0.t10 CTRL.t9 VDD.t46 sg13_lv_pmos ad=0.19p pd=1.38u as=0 ps=0 w=1u l=0.13u
X558 CTRL.t22 PH2.t10 CTRL.t22 VDD.t41 sg13_lv_pmos ad=0.19p pd=1.38u as=0 ps=0 w=1u l=0.13u
X559 VDD.t26 psdiff_1.VOUTDN buff_d8_2.inv_d2_0.VIN VDD.t25 sg13_lv_pmos ad=0.1005p pd=1.34u as=0.1005p ps=1.34u w=0.15u l=0.13u
X560 VDD.t372 VSS.t612 psdiff_0.buff_d8_1.VIN.t24 VDD.t108 sg13_lv_pmos ad=55.5f pd=0.74u as=55.5f ps=0.74u w=0.15u l=0.13u
X561 buff_d8_2.inv_d8_0.VIN buff_d8_2.inv_d4_0.VIN VDD.t31 VDD.t30 sg13_lv_pmos ad=55.5f pd=0.74u as=0.1005p ps=1.34u w=0.15u l=0.13u
X562 psdiff_2.buff_d8_0.VIN.t24 VSS.t610 VDD.t289 VDD.t169 sg13_lv_pmos ad=55.5f pd=0.74u as=55.5f ps=0.74u w=0.15u l=0.13u
X563 PH3.t4 buff_d8_4.inv_d8_0.VIN VDD.t102 VDD.t23 sg13_lv_pmos ad=55.5f pd=0.74u as=0.1005p ps=1.34u w=0.15u l=0.13u
X564 psdiff_1.VOUTDP psdiff_1.buff_d8_0.inv_d8_0.VIN VSS.t21 VSS.t20 sg13_lv_nmos ad=55.5f pd=0.74u as=0.1005p ps=1.34u w=0.15u l=0.13u
X565 psdiff_1.VOUTDP psdiff_1.buff_d8_0.inv_d8_0.VIN VDD.t8 VDD.t0 sg13_lv_pmos ad=55.5f pd=0.74u as=0.1005p ps=1.34u w=0.15u l=0.13u
X566 PH4.t0 PH1.t12 VDD.t45 VDD.t43 sg13_lv_pmos ad=55.5f pd=0.74u as=0.1005p ps=1.34u w=0.15u l=0.13u
X567 VDD.t226 buff_d8_0.inv_d8_0.VIN PH2.t5 VDD.t55 sg13_lv_pmos ad=0.1005p pd=1.34u as=55.5f ps=0.74u w=0.15u l=0.13u
X568 psdiff_2.buff_d8_0.VIN.t23 VSS.t610 VDD.t278 VDD.t169 sg13_lv_pmos ad=55.5f pd=0.74u as=55.5f ps=0.74u w=0.15u l=0.13u
X569 VDD.t370 VSS.t612 psdiff_0.buff_d8_1.VIN.t20 VDD.t108 sg13_lv_pmos ad=55.5f pd=0.74u as=55.5f ps=0.74u w=0.15u l=0.13u
X570 VDD.t264 a_7162_1266# psdiff_0.buff_d8_1.VIN.t30 VDD.t108 sg13_lv_pmos ad=0.1005p pd=1.34u as=55.5f ps=0.74u w=0.15u l=0.13u
X571 CTRL.t3 PH4.t10 CTRL.t3 VDD.t30 sg13_lv_pmos ad=0.19p pd=1.38u as=0 ps=0 w=1u l=0.13u
X572 VSS.t385 psdiff_2.CLKN psdiff_2.buff_d8_0.VIN.t10 VSS.t391 sg13_lv_nmos ad=55.5f pd=0.74u as=55.5f ps=0.74u w=0.15u l=0.13u
X573 psdiff_1.VOUTDN psdiff_1.buff_d8_1.inv_d8_0.VIN VDD.t78 VDD.t33 sg13_lv_pmos ad=55.5f pd=0.74u as=0.1005p ps=1.34u w=0.15u l=0.13u
X574 VSS.t104 psdiff_1.VOUTDN psdiff_0.buff_d8_1.VIN.t9 VSS.t83 sg13_lv_nmos ad=55.5f pd=0.74u as=55.5f ps=0.74u w=0.15u l=0.13u
X575 psdiff_0.buff_d8_1.VIN.t6 psdiff_1.VOUTDN VSS.t103 VSS.t85 sg13_lv_nmos ad=55.5f pd=0.74u as=55.5f ps=0.74u w=0.15u l=0.13u
X576 PH0.t9 buff_d8_5.inv_d8_0.VIN VSS.t521 VSS.t520 sg13_lv_nmos ad=55.5f pd=0.74u as=0.1005p ps=1.34u w=0.15u l=0.13u
X577 CTRL.t8 PH3.t10 CTRL.t8 VDD.t60 sg13_lv_pmos ad=0.19p pd=1.38u as=0 ps=0 w=1u l=0.13u
X578 CTRL.t2 PH1.t11 CTRL.t2 VDD.t25 sg13_lv_pmos ad=0.19p pd=1.38u as=0 ps=0 w=1u l=0.13u
X579 VSS.t581 buff_d8_0.inv_d8_0.VIN PH2.t9 VSS.t580 sg13_lv_nmos ad=0.1005p pd=1.34u as=55.5f ps=0.74u w=0.15u l=0.13u
X580 VSS.t209 psdiff_1.buff_d8_1.inv_d8_0.VIN psdiff_1.VOUTDN VSS.t208 sg13_lv_nmos ad=0.1005p pd=1.34u as=55.5f ps=0.74u w=0.15u l=0.13u
X581 CTRL.t20 PH2.t10 CTRL.t20 VDD.t41 sg13_lv_pmos ad=0.19p pd=1.38u as=0 ps=0 w=1u l=0.13u
X582 CTRL.t2 PH1.t11 CTRL.t2 VDD.t27 sg13_lv_pmos ad=0.19p pd=1.38u as=0 ps=0 w=1u l=0.13u
X583 psdiff_0.buff_d8_0.VIN.t15 psdiff_1.VOUTDP VSS.t343 VSS.t326 sg13_lv_nmos ad=55.5f pd=0.74u as=55.5f ps=0.74u w=0.15u l=0.13u
X584 psdiff_1.buff_d8_1.VIN.t10 psdiff_2.VOUTDN VSS.t256 VSS.t237 sg13_lv_nmos ad=55.5f pd=0.74u as=0.1005p ps=1.34u w=0.15u l=0.13u
X585 PH4.t7 buff_d8_2.inv_d8_0.VIN VSS.t415 VSS.t414 sg13_lv_nmos ad=55.5f pd=0.74u as=0.1005p ps=1.34u w=0.15u l=0.13u
X586 psdiff_1.buff_d8_0.VIN.t20 a_3031_1122# VDD.t133 VDD.t129 sg13_lv_pmos ad=55.5f pd=0.74u as=55.5f ps=0.74u w=0.15u l=0.13u
X587 VDD.t371 VSS.t612 psdiff_0.buff_d8_0.VIN.t29 VDD.t108 sg13_lv_pmos ad=55.5f pd=0.74u as=55.5f ps=0.74u w=0.15u l=0.13u
X588 VDD.t220 buff_d8_4.inv_d4_0.VIN buff_d8_4.inv_d8_0.VIN VDD.t23 sg13_lv_pmos ad=0.1005p pd=1.34u as=55.5f ps=0.74u w=0.15u l=0.13u
X589 psdiff_2.buff_d8_1.VIN.t8 psdiff_2.CLKP.t8 VSS.t471 VSS.t468 sg13_lv_nmos ad=55.5f pd=0.74u as=55.5f ps=0.74u w=0.15u l=0.13u
X590 VSS.t155 PH1.t10 PH4.t1 VSS.t154 sg13_lv_nmos ad=0.1005p pd=1.34u as=55.5f ps=0.74u w=0.15u l=0.13u
X591 CTRL.t20 PH2.t10 CTRL.t20 VDD.t55 sg13_lv_pmos ad=0.19p pd=1.38u as=0 ps=0 w=1u l=0.13u
X592 psdiff_1.buff_d8_0.VIN.t19 a_3031_1122# VDD.t130 VDD.t129 sg13_lv_pmos ad=55.5f pd=0.74u as=55.5f ps=0.74u w=0.15u l=0.13u
X593 psdiff_2.buff_d8_0.VIN.t22 VSS.t610 VDD.t287 VDD.t169 sg13_lv_pmos ad=55.5f pd=0.74u as=0.1005p ps=1.34u w=0.15u l=0.13u
X594 VDD.t369 VSS.t612 psdiff_0.buff_d8_0.VIN.t22 VDD.t108 sg13_lv_pmos ad=55.5f pd=0.74u as=55.5f ps=0.74u w=0.15u l=0.13u
X595 buff_d8_1.inv_d8_0.VIN buff_d8_1.inv_d4_0.VIN VSS.t319 VSS.t318 sg13_lv_nmos ad=55.5f pd=0.74u as=0.1005p ps=1.34u w=0.15u l=0.13u
X596 VDD.t243 psdiff_1.buff_d8_0.inv_d4_0.VIN psdiff_1.buff_d8_0.inv_d8_0.VIN VDD.t0 sg13_lv_pmos ad=0.1005p pd=1.34u as=55.5f ps=0.74u w=0.15u l=0.13u
X597 CTRL.t8 PH3.t10 CTRL.t8 VDD.t47 sg13_lv_pmos ad=0.19p pd=1.38u as=0 ps=0 w=1u l=0.13u
X598 VDD.t39 buff_d8_0.inv_d4_0.VIN buff_d8_0.inv_d8_0.VIN VDD.t38 sg13_lv_pmos ad=0.1005p pd=1.34u as=55.5f ps=0.74u w=0.15u l=0.13u
X599 VDD.t66 PH5.t12 PH2.t0 VDD.t56 sg13_lv_pmos ad=0.1005p pd=1.34u as=55.5f ps=0.74u w=0.15u l=0.13u
X600 VSS.t55 psdiff_2.VOUTDP psdiff_1.buff_d8_0.VIN.t7 VSS.t58 sg13_lv_nmos ad=55.5f pd=0.74u as=55.5f ps=0.74u w=0.15u l=0.13u
X601 CTRL.t8 PH0.t10 CTRL.t8 VDD.t47 sg13_lv_pmos ad=0.19p pd=1.38u as=0 ps=0 w=1u l=0.13u
X602 CTRL.t2 PH4.t10 CTRL.t2 VDD.t30 sg13_lv_pmos ad=0.19p pd=1.38u as=0 ps=0 w=1u l=0.13u
X603 VSS.t19 psdiff_1.buff_d8_0.inv_d8_0.VIN psdiff_1.VOUTDP VSS.t18 sg13_lv_nmos ad=0.1005p pd=1.34u as=55.5f ps=0.74u w=0.15u l=0.13u
X604 PH2.t4 buff_d8_0.inv_d8_0.VIN VDD.t225 VDD.t55 sg13_lv_pmos ad=55.5f pd=0.74u as=0.1005p ps=1.34u w=0.15u l=0.13u
X605 VDD.t330 VSS.t611 psdiff_1.buff_d8_0.VIN.t29 VDD.t129 sg13_lv_pmos ad=55.5f pd=0.74u as=55.5f ps=0.74u w=0.15u l=0.13u
X606 CTRL.t1 PH1.t11 CTRL.t1 VDD.t25 sg13_lv_pmos ad=0.19p pd=1.38u as=0 ps=0 w=1u l=0.13u
X607 PH5.t0 PH2.t12 VDD.t58 VDD.t56 sg13_lv_pmos ad=55.5f pd=0.74u as=0.1005p ps=1.34u w=0.15u l=0.13u
X608 VDD.t165 psdiff_0.buff_d8_1.inv_d8_0.VIN psdiff_2.CLKP.t3 VDD.t33 sg13_lv_pmos ad=0.1005p pd=1.34u as=55.5f ps=0.74u w=0.15u l=0.13u
X609 psdiff_1.buff_d8_0.inv_d8_0.VIN psdiff_1.buff_d8_0.inv_d4_0.VIN VDD.t242 VDD.t0 sg13_lv_pmos ad=55.5f pd=0.74u as=0.1005p ps=1.34u w=0.15u l=0.13u
X610 VDD.t141 psdiff_0.buff_d8_1.inv_d2_0.VIN psdiff_0.buff_d8_1.inv_d4_0.VIN VDD.t33 sg13_lv_pmos ad=0.1005p pd=1.34u as=55.5f ps=0.74u w=0.15u l=0.13u
X611 CTRL.t1 PH1.t11 CTRL.t1 VDD.t27 sg13_lv_pmos ad=0.19p pd=1.38u as=0 ps=0 w=1u l=0.13u
X612 psdiff_1.buff_d8_1.VIN.t24 VSS.t611 VDD.t318 VDD.t129 sg13_lv_pmos ad=55.5f pd=0.74u as=55.5f ps=0.74u w=0.15u l=0.13u
X613 VSS.t102 psdiff_1.VOUTDN psdiff_0.buff_d8_1.VIN.t7 VSS.t83 sg13_lv_nmos ad=55.5f pd=0.74u as=55.5f ps=0.74u w=0.15u l=0.13u
X614 VSS.t165 psdiff_2.buff_d8_1.inv_d2_0.VIN psdiff_2.buff_d8_1.inv_d4_0.VIN VSS.t164 sg13_lv_nmos ad=0.1005p pd=1.34u as=55.5f ps=0.74u w=0.15u l=0.13u
X615 VDD.t320 VSS.t611 psdiff_1.buff_d8_0.VIN.t23 VDD.t129 sg13_lv_pmos ad=55.5f pd=0.74u as=55.5f ps=0.74u w=0.15u l=0.13u
X616 VSS.t470 psdiff_2.CLKP.t8 psdiff_2.buff_d8_1.VIN.t5 VSS.t464 sg13_lv_nmos ad=55.5f pd=0.74u as=55.5f ps=0.74u w=0.15u l=0.13u
X617 psdiff_0.buff_d8_1.inv_d8_0.VIN psdiff_0.buff_d8_1.inv_d4_0.VIN VDD.t144 VDD.t33 sg13_lv_pmos ad=55.5f pd=0.74u as=0.1005p ps=1.34u w=0.15u l=0.13u
X618 VDD.t189 buff_d8_5.inv_d4_0.VIN buff_d8_5.inv_d8_0.VIN VDD.t61 sg13_lv_pmos ad=0.1005p pd=1.34u as=55.5f ps=0.74u w=0.15u l=0.13u
X619 CTRL.t18 PH2.t10 CTRL.t18 VDD.t41 sg13_lv_pmos ad=0.19p pd=1.38u as=0 ps=0 w=1u l=0.13u
X620 CTRL.t0 PH4.t10 CTRL.t0 VDD.t149 sg13_lv_pmos ad=0.19p pd=1.38u as=0 ps=0 w=1u l=0.13u
X621 VSS.t207 psdiff_1.buff_d8_1.inv_d8_0.VIN psdiff_1.VOUTDN VSS.t206 sg13_lv_nmos ad=0.1005p pd=1.34u as=55.5f ps=0.74u w=0.15u l=0.13u
X622 psdiff_0.buff_d8_1.VIN.t22 VSS.t612 VDD.t355 VDD.t108 sg13_lv_pmos ad=55.5f pd=0.74u as=55.5f ps=0.74u w=0.15u l=0.13u
X623 CTRL.t18 PH2.t10 CTRL.t18 VDD.t55 sg13_lv_pmos ad=0.19p pd=1.38u as=0 ps=0 w=1u l=0.13u
X624 psdiff_2.buff_d8_1.VIN.t7 psdiff_2.CLKP.t8 VSS.t469 VSS.t468 sg13_lv_nmos ad=55.5f pd=0.74u as=55.5f ps=0.74u w=0.15u l=0.13u
X625 CTRL.t0 PH4.t10 CTRL.t0 VDD.t149 sg13_lv_pmos ad=0.19p pd=1.38u as=0 ps=0 w=1u l=0.13u
X626 psdiff_0.buff_d8_1.VIN.t5 psdiff_1.VOUTDN VSS.t101 VSS.t100 sg13_lv_nmos ad=55.5f pd=0.74u as=0.1005p ps=1.34u w=0.15u l=0.13u
X627 CTRL.t1 PH4.t10 CTRL.t1 VDD.t30 sg13_lv_pmos ad=0.19p pd=1.38u as=0 ps=0 w=1u l=0.13u
X628 VDD.t84 psdiff_2.buff_d8_1.inv_d8_0.VIN psdiff_2.VOUTDN VDD.t33 sg13_lv_pmos ad=0.1005p pd=1.34u as=55.5f ps=0.74u w=0.15u l=0.13u
X629 VDD.t18 psdiff_2.buff_d8_0.inv_d8_0.VIN psdiff_2.VOUTDP VDD.t0 sg13_lv_pmos ad=0.1005p pd=1.34u as=55.5f ps=0.74u w=0.15u l=0.13u
X630 psdiff_1.buff_d8_1.inv_d8_0.VIN psdiff_1.buff_d8_1.inv_d4_0.VIN VSS.t197 VSS.t196 sg13_lv_nmos ad=55.5f pd=0.74u as=0.1005p ps=1.34u w=0.15u l=0.13u
X631 VDD.t17 psdiff_2.buff_d8_0.inv_d8_0.VIN psdiff_2.VOUTDP VDD.t0 sg13_lv_pmos ad=0.1005p pd=1.34u as=55.5f ps=0.74u w=0.15u l=0.13u
X632 VSS.t171 PH2.t11 PH5.t1 VSS.t170 sg13_lv_nmos ad=0.1005p pd=1.34u as=55.5f ps=0.74u w=0.15u l=0.13u
X633 psdiff_1.buff_d8_1.VIN.t23 VSS.t611 VDD.t327 VDD.t129 sg13_lv_pmos ad=55.5f pd=0.74u as=55.5f ps=0.74u w=0.15u l=0.13u
X634 VSS.t52 psdiff_2.VOUTDP psdiff_1.buff_d8_0.VIN.t6 VSS.t56 sg13_lv_nmos ad=55.5f pd=0.74u as=55.5f ps=0.74u w=0.15u l=0.13u
X635 VDD.t158 buff_d8_0.inv_d2_0.VIN buff_d8_0.inv_d4_0.VIN VDD.t36 sg13_lv_pmos ad=0.1005p pd=1.34u as=55.5f ps=0.74u w=0.15u l=0.13u
X636 VDD.t171 a_1214_1266# psdiff_2.buff_d8_1.VIN.t28 VDD.t169 sg13_lv_pmos ad=55.5f pd=0.74u as=55.5f ps=0.74u w=0.15u l=0.13u
X637 psdiff_1.buff_d8_1.VIN.t9 psdiff_2.VOUTDN VSS.t255 VSS.t252 sg13_lv_nmos ad=55.5f pd=0.74u as=55.5f ps=0.74u w=0.15u l=0.13u
X638 CTRL.t8 PH0.t10 CTRL.t8 VDD.t46 sg13_lv_pmos ad=0.19p pd=1.38u as=0 ps=0 w=1u l=0.13u
X639 psdiff_1.buff_d8_1.VIN.t22 VSS.t611 VDD.t326 VDD.t129 sg13_lv_pmos ad=55.5f pd=0.74u as=55.5f ps=0.74u w=0.15u l=0.13u
X640 VDD.t178 a_57_1122# psdiff_2.buff_d8_0.VIN.t30 VDD.t169 sg13_lv_pmos ad=55.5f pd=0.74u as=55.5f ps=0.74u w=0.15u l=0.13u
X641 buff_d8_3.inv_d8_0.VIN buff_d8_3.inv_d4_0.VIN VDD.t205 VDD.t23 sg13_lv_pmos ad=55.5f pd=0.74u as=0.1005p ps=1.34u w=0.15u l=0.13u
X642 PH5.t7 buff_d8_1.inv_d8_0.VIN VSS.t275 VSS.t274 sg13_lv_nmos ad=55.5f pd=0.74u as=0.1005p ps=1.34u w=0.15u l=0.13u
X643 psdiff_2.buff_d8_1.VIN.t6 psdiff_2.CLKP.t8 VSS.t467 VSS.t466 sg13_lv_nmos ad=55.5f pd=0.74u as=55.5f ps=0.74u w=0.15u l=0.13u
X644 psdiff_0.buff_d8_1.VIN.t15 CTRL.t26 a_6005_1122# VSS.t96 sg13_lv_nmos ad=0.1005p pd=1.34u as=55.5f ps=0.74u w=0.15u l=0.13u
X645 psdiff_2.buff_d8_0.VIN.t7 psdiff_2.CLKN VSS.t390 VSS.t387 sg13_lv_nmos ad=55.5f pd=0.74u as=55.5f ps=0.74u w=0.15u l=0.13u
X646 PH1.t5 buff_d8_3.inv_d8_0.VIN VDD.t210 VDD.t23 sg13_lv_pmos ad=55.5f pd=0.74u as=0.1005p ps=1.34u w=0.15u l=0.13u
X647 VSS.t382 psdiff_2.CLKN psdiff_2.buff_d8_0.VIN.t9 VSS.t146 sg13_lv_nmos ad=55.5f pd=0.74u as=55.5f ps=0.74u w=0.15u l=0.13u
X648 CTRL.t16 PH2.t10 CTRL.t16 VDD.t41 sg13_lv_pmos ad=0.19p pd=1.38u as=0 ps=0 w=1u l=0.13u
X649 VDD.t164 psdiff_0.buff_d8_1.inv_d8_0.VIN psdiff_2.CLKP.t0 VDD.t33 sg13_lv_pmos ad=0.1005p pd=1.34u as=55.5f ps=0.74u w=0.15u l=0.13u
X650 CTRL.t20 PH5.t10 CTRL.t20 VDD.t36 sg13_lv_pmos ad=0.19p pd=1.38u as=0 ps=0 w=1u l=0.13u
X651 psdiff_2.buff_d8_0.inv_d4_0.VIN psdiff_2.buff_d8_0.inv_d2_0.VIN VSS.t191 VSS.t190 sg13_lv_nmos ad=55.5f pd=0.74u as=0.1005p ps=1.34u w=0.15u l=0.13u
X652 psdiff_0.buff_d8_0.VIN.t28 VSS.t612 VDD.t367 VDD.t108 sg13_lv_pmos ad=55.5f pd=0.74u as=55.5f ps=0.74u w=0.15u l=0.13u
X653 VSS.t535 buff_d8_3.inv_d4_0.VIN buff_d8_3.inv_d8_0.VIN VSS.t534 sg13_lv_nmos ad=0.1005p pd=1.34u as=55.5f ps=0.74u w=0.15u l=0.13u
X654 CTRL.t20 PH5.t10 CTRL.t20 VDD.t38 sg13_lv_pmos ad=0.19p pd=1.38u as=0 ps=0 w=1u l=0.13u
X655 CTRL.t16 PH2.t10 CTRL.t16 VDD.t55 sg13_lv_pmos ad=0.19p pd=1.38u as=0 ps=0 w=1u l=0.13u
X656 psdiff_0.buff_d8_0.VIN.t27 VSS.t612 VDD.t366 VDD.t108 sg13_lv_pmos ad=55.5f pd=0.74u as=0.1005p ps=1.34u w=0.15u l=0.13u
X657 buff_d8_3.inv_d2_0.VIN psdiff_1.VOUTDP VSS.t342 VSS.t341 sg13_lv_nmos ad=0.1005p pd=1.34u as=0.1005p ps=1.34u w=0.15u l=0.13u
X658 VSS.t465 psdiff_2.CLKP.t8 psdiff_2.buff_d8_1.VIN.t4 VSS.t464 sg13_lv_nmos ad=55.5f pd=0.74u as=55.5f ps=0.74u w=0.15u l=0.13u
X659 psdiff_0.buff_d8_0.VIN.t26 VSS.t612 VDD.t365 VDD.t108 sg13_lv_pmos ad=55.5f pd=0.74u as=55.5f ps=0.74u w=0.15u l=0.13u
X660 VDD.t252 a_57_1122# psdiff_2.buff_d8_0.VIN.t27 VDD.t169 sg13_lv_pmos ad=55.5f pd=0.74u as=55.5f ps=0.74u w=0.15u l=0.13u
X661 buff_d8_4.inv_d2_0.VIN psdiff_2.VOUTDP VDD.t24 VDD.t23 sg13_lv_pmos ad=0.1005p pd=1.34u as=0.1005p ps=1.34u w=0.15u l=0.13u
X662 CTRL.t20 PH5.t10 CTRL.t20 VDD.t41 sg13_lv_pmos ad=0.19p pd=1.38u as=0 ps=0 w=1u l=0.13u
X663 VDD.t251 a_57_1122# psdiff_2.buff_d8_0.VIN.t29 VDD.t169 sg13_lv_pmos ad=55.5f pd=0.74u as=55.5f ps=0.74u w=0.15u l=0.13u
X664 psdiff_0.buff_d8_1.VIN.t29 a_7162_1266# VDD.t263 VDD.t108 sg13_lv_pmos ad=55.5f pd=0.74u as=55.5f ps=0.74u w=0.15u l=0.13u
X665 VSS.t335 psdiff_1.VOUTDP psdiff_0.buff_d8_0.VIN.t16 VSS.t338 sg13_lv_nmos ad=55.5f pd=0.74u as=55.5f ps=0.74u w=0.15u l=0.13u
X666 VSS.t246 psdiff_2.VOUTDN psdiff_1.buff_d8_1.VIN.t11 VSS.t251 sg13_lv_nmos ad=55.5f pd=0.74u as=55.5f ps=0.74u w=0.15u l=0.13u
X667 VDD.t195 buff_d8_5.inv_d8_0.VIN PH0.t4 VDD.t47 sg13_lv_pmos ad=0.1005p pd=1.34u as=55.5f ps=0.74u w=0.15u l=0.13u
X668 psdiff_1.buff_d8_1.inv_d4_0.VIN psdiff_1.buff_d8_1.inv_d2_0.VIN VSS.t131 VSS.t130 sg13_lv_nmos ad=55.5f pd=0.74u as=0.1005p ps=1.34u w=0.15u l=0.13u
X669 psdiff_0.buff_d8_1.VIN.t9 psdiff_1.VOUTDN VSS.t99 VSS.t96 sg13_lv_nmos ad=55.5f pd=0.74u as=55.5f ps=0.74u w=0.15u l=0.13u
X670 psdiff_2.buff_d8_1.VIN.t23 VSS.t610 VDD.t286 VDD.t169 sg13_lv_pmos ad=55.5f pd=0.74u as=55.5f ps=0.74u w=0.15u l=0.13u
X671 VDD.t50 PH0.t12 PH3.t0 VDD.t48 sg13_lv_pmos ad=0.1005p pd=1.34u as=55.5f ps=0.74u w=0.15u l=0.13u
X672 VSS.t51 psdiff_2.VOUTDP psdiff_1.buff_d8_0.VIN.t5 VSS.t56 sg13_lv_nmos ad=55.5f pd=0.74u as=55.5f ps=0.74u w=0.15u l=0.13u
X673 VDD.t126 buff_d8_1.inv_d4_0.VIN buff_d8_1.inv_d8_0.VIN VDD.t23 sg13_lv_pmos ad=0.1005p pd=1.34u as=55.5f ps=0.74u w=0.15u l=0.13u
X674 psdiff_1.buff_d8_1.VIN.t8 psdiff_2.VOUTDN VSS.t253 VSS.t252 sg13_lv_nmos ad=55.5f pd=0.74u as=55.5f ps=0.74u w=0.15u l=0.13u
X675 VDD.t215 psdiff_2.buff_d8_1.inv_d4_0.VIN psdiff_2.buff_d8_1.inv_d8_0.VIN VDD.t33 sg13_lv_pmos ad=0.1005p pd=1.34u as=55.5f ps=0.74u w=0.15u l=0.13u
X676 buff_d8_4.inv_d4_0.VIN buff_d8_4.inv_d2_0.VIN VDD.t119 VDD.t23 sg13_lv_pmos ad=55.5f pd=0.74u as=0.1005p ps=1.34u w=0.15u l=0.13u
X677 VSS.t507 buff_d8_5.inv_d4_0.VIN buff_d8_5.inv_d8_0.VIN VSS.t506 sg13_lv_nmos ad=0.1005p pd=1.34u as=55.5f ps=0.74u w=0.15u l=0.13u
X678 psdiff_2.buff_d8_0.VIN.t6 psdiff_2.CLKN VSS.t388 VSS.t387 sg13_lv_nmos ad=55.5f pd=0.74u as=55.5f ps=0.74u w=0.15u l=0.13u
X679 VSS.t379 psdiff_2.CLKN psdiff_2.buff_d8_0.VIN.t8 VSS.t146 sg13_lv_nmos ad=55.5f pd=0.74u as=55.5f ps=0.74u w=0.15u l=0.13u
X680 CTRL.t18 PH5.t10 CTRL.t18 VDD.t36 sg13_lv_pmos ad=0.19p pd=1.38u as=0 ps=0 w=1u l=0.13u
X681 PH1.t4 buff_d8_3.inv_d8_0.VIN VDD.t209 VDD.t23 sg13_lv_pmos ad=55.5f pd=0.74u as=0.1005p ps=1.34u w=0.15u l=0.13u
X682 CTRL.t18 PH5.t10 CTRL.t18 VDD.t38 sg13_lv_pmos ad=0.19p pd=1.38u as=0 ps=0 w=1u l=0.13u
X683 CTRL.t0 PH1.t11 CTRL.t0 VDD.t27 sg13_lv_pmos ad=0.19p pd=1.38u as=0 ps=0 w=1u l=0.13u
X684 VSS.t519 buff_d8_5.inv_d8_0.VIN PH0.t8 VSS.t518 sg13_lv_nmos ad=0.1005p pd=1.34u as=55.5f ps=0.74u w=0.15u l=0.13u
X685 VDD.t285 VSS.t610 psdiff_2.buff_d8_1.VIN.t18 VDD.t169 sg13_lv_pmos ad=55.5f pd=0.74u as=55.5f ps=0.74u w=0.15u l=0.13u
X686 a_4188_1266# CTRL.t24 psdiff_1.buff_d8_0.VIN.t15 VSS.t53 sg13_lv_nmos ad=55.5f pd=0.74u as=0.1005p ps=1.34u w=0.15u l=0.13u
X687 CTRL.t13 PH3.t10 CTRL.t13 VDD.t61 sg13_lv_pmos ad=0.19p pd=1.38u as=0 ps=0 w=1u l=0.13u
X688 VDD.t364 VSS.t612 psdiff_0.buff_d8_1.VIN.t23 VDD.t108 sg13_lv_pmos ad=55.5f pd=0.74u as=55.5f ps=0.74u w=0.15u l=0.13u
X689 psdiff_0.buff_d8_0.VIN.t12 psdiff_1.VOUTDP VSS.t104 VSS.t337 sg13_lv_nmos ad=55.5f pd=0.74u as=55.5f ps=0.74u w=0.15u l=0.13u
X690 CTRL.t0 PH1.t11 CTRL.t0 VDD.t27 sg13_lv_pmos ad=0.19p pd=1.38u as=0 ps=0 w=1u l=0.13u
X691 VSS.t91 psdiff_1.VOUTDN psdiff_0.buff_d8_1.VIN.t8 VSS.t95 sg13_lv_nmos ad=55.5f pd=0.74u as=55.5f ps=0.74u w=0.15u l=0.13u
X692 CTRL.t13 PH3.t10 CTRL.t13 VDD.t60 sg13_lv_pmos ad=0.19p pd=1.38u as=0 ps=0 w=1u l=0.13u
X693 CTRL.t18 PH5.t10 CTRL.t18 VDD.t41 sg13_lv_pmos ad=0.19p pd=1.38u as=0 ps=0 w=1u l=0.13u
X694 VSS.t376 psdiff_2.CLKP.t8 psdiff_2.buff_d8_1.VIN.t9 VSS.t463 sg13_lv_nmos ad=55.5f pd=0.74u as=55.5f ps=0.74u w=0.15u l=0.13u
X695 CTRL.t13 PH3.t10 CTRL.t13 VDD.t47 sg13_lv_pmos ad=0.19p pd=1.38u as=0 ps=0 w=1u l=0.13u
X696 VSS.t462 psdiff_2.CLKP.t9 buff_d8_0.inv_d2_0.VIN VSS.t461 sg13_lv_nmos ad=0.1005p pd=1.34u as=0.1005p ps=1.34u w=0.15u l=0.13u
X697 VSS.t29 psdiff_2.buff_d8_0.inv_d8_0.VIN psdiff_2.VOUTDP VSS.t28 sg13_lv_nmos ad=0.1005p pd=1.34u as=55.5f ps=0.74u w=0.15u l=0.13u
X698 buff_d8_0.inv_d8_0.VIN buff_d8_0.inv_d4_0.VIN VSS.t137 VSS.t136 sg13_lv_nmos ad=55.5f pd=0.74u as=0.1005p ps=1.34u w=0.15u l=0.13u
X699 VDD.t325 VSS.t611 psdiff_1.buff_d8_1.VIN.t21 VDD.t129 sg13_lv_pmos ad=55.5f pd=0.74u as=55.5f ps=0.74u w=0.15u l=0.13u
X700 PH3.t9 buff_d8_4.inv_d8_0.VIN VSS.t295 VSS.t294 sg13_lv_nmos ad=55.5f pd=0.74u as=0.1005p ps=1.34u w=0.15u l=0.13u
X701 VSS.t332 psdiff_1.VOUTDP psdiff_0.buff_d8_0.VIN.t15 VSS.t338 sg13_lv_nmos ad=55.5f pd=0.74u as=55.5f ps=0.74u w=0.15u l=0.13u
X702 VSS.t243 psdiff_2.VOUTDN psdiff_1.buff_d8_1.VIN.t10 VSS.t251 sg13_lv_nmos ad=55.5f pd=0.74u as=55.5f ps=0.74u w=0.15u l=0.13u
X703 VDD.t64 psdiff_0.buff_d8_0.VIN.t32 psdiff_0.buff_d8_0.inv_d2_0.VIN VDD.t0 sg13_lv_pmos ad=0.1005p pd=1.34u as=0.1005p ps=1.34u w=0.15u l=0.13u
X704 psdiff_0.buff_d8_1.VIN.t7 psdiff_1.VOUTDN VSS.t97 VSS.t96 sg13_lv_nmos ad=55.5f pd=0.74u as=55.5f ps=0.74u w=0.15u l=0.13u
X705 VDD.t91 psdiff_2.VOUTDN buff_d8_5.inv_d2_0.VIN VDD.t61 sg13_lv_pmos ad=0.1005p pd=1.34u as=0.1005p ps=1.34u w=0.15u l=0.13u
X706 VDD.t324 VSS.t611 psdiff_1.buff_d8_1.VIN.t20 VDD.t129 sg13_lv_pmos ad=55.5f pd=0.74u as=55.5f ps=0.74u w=0.15u l=0.13u
X707 psdiff_2.CLKN psdiff_0.buff_d8_0.inv_d8_0.VIN VDD.t184 VDD.t0 sg13_lv_pmos ad=55.5f pd=0.74u as=0.1005p ps=1.34u w=0.15u l=0.13u
X708 VSS.t453 psdiff_2.CLKP.t8 psdiff_2.buff_d8_1.VIN.t8 VSS.t152 sg13_lv_nmos ad=55.5f pd=0.74u as=55.5f ps=0.74u w=0.15u l=0.13u
X709 VDD.t234 a_4188_1266# psdiff_1.buff_d8_1.VIN.t30 VDD.t129 sg13_lv_pmos ad=0.1005p pd=1.34u as=55.5f ps=0.74u w=0.15u l=0.13u
X710 psdiff_1.VOUTDN psdiff_1.buff_d8_1.inv_d8_0.VIN VSS.t205 VSS.t204 sg13_lv_nmos ad=55.5f pd=0.74u as=0.1005p ps=1.34u w=0.15u l=0.13u
X711 CTRL.t16 PH5.t10 CTRL.t16 VDD.t36 sg13_lv_pmos ad=0.19p pd=1.38u as=0 ps=0 w=1u l=0.13u
X712 VDD.t357 VSS.t612 psdiff_0.buff_d8_0.VIN.t25 VDD.t108 sg13_lv_pmos ad=55.5f pd=0.74u as=55.5f ps=0.74u w=0.15u l=0.13u
X713 VDD.t95 buff_d8_1.inv_d8_0.VIN PH5.t4 VDD.t23 sg13_lv_pmos ad=0.1005p pd=1.34u as=55.5f ps=0.74u w=0.15u l=0.13u
X714 CTRL.t16 PH5.t10 CTRL.t16 VDD.t38 sg13_lv_pmos ad=0.19p pd=1.38u as=0 ps=0 w=1u l=0.13u
X715 psdiff_1.buff_d8_0.VIN.t18 a_3031_1122# VDD.t131 VDD.t129 sg13_lv_pmos ad=55.5f pd=0.74u as=55.5f ps=0.74u w=0.15u l=0.13u
X716 VDD.t7 psdiff_1.buff_d8_0.inv_d8_0.VIN psdiff_1.VOUTDP VDD.t0 sg13_lv_pmos ad=0.1005p pd=1.34u as=55.5f ps=0.74u w=0.15u l=0.13u
X717 CTRL.t16 PH5.t10 CTRL.t16 VDD.t41 sg13_lv_pmos ad=0.19p pd=1.38u as=0 ps=0 w=1u l=0.13u
X718 PH5.t3 buff_d8_1.inv_d8_0.VIN VDD.t94 VDD.t23 sg13_lv_pmos ad=55.5f pd=0.74u as=0.1005p ps=1.34u w=0.15u l=0.13u
X719 psdiff_2.buff_d8_0.inv_d8_0.VIN psdiff_2.buff_d8_0.inv_d4_0.VIN VDD.t247 VDD.t0 sg13_lv_pmos ad=55.5f pd=0.74u as=0.1005p ps=1.34u w=0.15u l=0.13u
X720 CTRL.t3 PH4.t10 CTRL.t3 VDD.t30 sg13_lv_pmos ad=0.19p pd=1.38u as=0 ps=0 w=1u l=0.13u
X721 buff_d8_4.inv_d8_0.VIN buff_d8_4.inv_d4_0.VIN VSS.t569 VSS.t568 sg13_lv_nmos ad=55.5f pd=0.74u as=0.1005p ps=1.34u w=0.15u l=0.13u
X722 CTRL.t11 PH3.t10 CTRL.t11 VDD.t61 sg13_lv_pmos ad=0.19p pd=1.38u as=0 ps=0 w=1u l=0.13u
X723 psdiff_1.buff_d8_0.VIN.t2 psdiff_2.VOUTDP VSS.t55 VSS.t54 sg13_lv_nmos ad=55.5f pd=0.74u as=55.5f ps=0.74u w=0.15u l=0.13u
X724 CTRL.t22 PH2.t10 CTRL.t22 VDD.t55 sg13_lv_pmos ad=0.19p pd=1.38u as=0 ps=0 w=1u l=0.13u
X725 VSS.t47 psdiff_2.VOUTDP psdiff_1.buff_d8_0.VIN.t4 VSS.t53 sg13_lv_nmos ad=55.5f pd=0.74u as=55.5f ps=0.74u w=0.15u l=0.13u
X726 psdiff_2.buff_d8_0.VIN.t4 psdiff_2.CLKN VSS.t385 VSS.t384 sg13_lv_nmos ad=55.5f pd=0.74u as=55.5f ps=0.74u w=0.15u l=0.13u
X727 psdiff_0.buff_d8_0.VIN.t9 psdiff_1.VOUTDP VSS.t102 VSS.t337 sg13_lv_nmos ad=55.5f pd=0.74u as=55.5f ps=0.74u w=0.15u l=0.13u
X728 psdiff_1.buff_d8_1.VIN.t6 psdiff_2.VOUTDN VSS.t250 VSS.t249 sg13_lv_nmos ad=55.5f pd=0.74u as=55.5f ps=0.74u w=0.15u l=0.13u
X729 CTRL.t11 PH3.t10 CTRL.t11 VDD.t60 sg13_lv_pmos ad=0.19p pd=1.38u as=0 ps=0 w=1u l=0.13u
X730 VDD.t323 VSS.t611 psdiff_1.buff_d8_0.VIN.t28 VDD.t129 sg13_lv_pmos ad=55.5f pd=0.74u as=55.5f ps=0.74u w=0.15u l=0.13u
X731 psdiff_1.buff_d8_0.inv_d8_0.VIN psdiff_1.buff_d8_0.inv_d4_0.VIN VSS.t591 VSS.t590 sg13_lv_nmos ad=55.5f pd=0.74u as=0.1005p ps=1.34u w=0.15u l=0.13u
X732 VSS.t88 psdiff_1.VOUTDN psdiff_0.buff_d8_1.VIN.t6 VSS.t95 sg13_lv_nmos ad=55.5f pd=0.74u as=55.5f ps=0.74u w=0.15u l=0.13u
X733 CTRL.t22 PH2.t10 CTRL.t22 VDD.t55 sg13_lv_pmos ad=0.19p pd=1.38u as=0 ps=0 w=1u l=0.13u
X734 VSS.t187 psdiff_2.buff_d8_0.VIN.t32 psdiff_2.buff_d8_0.inv_d2_0.VIN VSS.t186 sg13_lv_nmos ad=0.1005p pd=1.34u as=0.1005p ps=1.34u w=0.15u l=0.13u
X735 CTRL.t11 PH3.t10 CTRL.t11 VDD.t47 sg13_lv_pmos ad=0.19p pd=1.38u as=0 ps=0 w=1u l=0.13u
X736 VSS.t179 PH3.t12 PH0.t1 VSS.t178 sg13_lv_nmos ad=0.1005p pd=1.34u as=55.5f ps=0.74u w=0.15u l=0.13u
X737 VDD.t151 buff_d8_2.inv_d8_0.VIN PH4.t4 VDD.t61 sg13_lv_pmos ad=0.1005p pd=1.34u as=55.5f ps=0.74u w=0.15u l=0.13u
X738 psdiff_2.CLKN psdiff_0.buff_d8_0.inv_d8_0.VIN VDD.t183 VDD.t0 sg13_lv_pmos ad=55.5f pd=0.74u as=0.1005p ps=1.34u w=0.15u l=0.13u
X739 CTRL.t3 PH4.t10 CTRL.t3 VDD.t149 sg13_lv_pmos ad=0.19p pd=1.38u as=0 ps=0 w=1u l=0.13u
X740 VDD.t29 buff_d8_2.inv_d4_0.VIN buff_d8_2.inv_d8_0.VIN VDD.t27 sg13_lv_pmos ad=0.1005p pd=1.34u as=55.5f ps=0.74u w=0.15u l=0.13u
X741 psdiff_0.buff_d8_1.inv_d8_0.VIN psdiff_0.buff_d8_1.inv_d4_0.VIN VSS.t366 VSS.t365 sg13_lv_nmos ad=55.5f pd=0.74u as=0.1005p ps=1.34u w=0.15u l=0.13u
X742 CTRL.t13 PH0.t10 CTRL.t13 VDD.t46 sg13_lv_pmos ad=0.19p pd=1.38u as=0 ps=0 w=1u l=0.13u
X743 PH4.t3 buff_d8_2.inv_d8_0.VIN VDD.t150 VDD.t149 sg13_lv_pmos ad=55.5f pd=0.74u as=0.1005p ps=1.34u w=0.15u l=0.13u
X744 VSS.t452 psdiff_2.CLKP.t8 psdiff_2.buff_d8_1.VIN.t7 VSS.t152 sg13_lv_nmos ad=55.5f pd=0.74u as=55.5f ps=0.74u w=0.15u l=0.13u
X745 PH1.t0 PH4.t12 VDD.t273 VDD.t43 sg13_lv_pmos ad=55.5f pd=0.74u as=0.1005p ps=1.34u w=0.15u l=0.13u
X746 psdiff_2.CLKP.t5 psdiff_0.buff_d8_1.inv_d8_0.VIN VSS.t439 VSS.t438 sg13_lv_nmos ad=55.5f pd=0.74u as=0.1005p ps=1.34u w=0.15u l=0.13u
X747 psdiff_2.buff_d8_1.VIN.t22 VSS.t610 VDD.t284 VDD.t169 sg13_lv_pmos ad=55.5f pd=0.74u as=55.5f ps=0.74u w=0.15u l=0.13u
X748 VDD.t111 a_6005_1122# psdiff_0.buff_d8_0.VIN.t4 VDD.t108 sg13_lv_pmos ad=55.5f pd=0.74u as=55.5f ps=0.74u w=0.15u l=0.13u
X749 PH2.t1 PH5.t11 VSS.t183 VSS.t182 sg13_lv_nmos ad=55.5f pd=0.74u as=0.1005p ps=1.34u w=0.15u l=0.13u
X750 CTRL.t9 PH3.t10 CTRL.t9 VDD.t61 sg13_lv_pmos ad=0.19p pd=1.38u as=0 ps=0 w=1u l=0.13u
X751 VDD.t93 buff_d8_1.inv_d8_0.VIN PH5.t3 VDD.t23 sg13_lv_pmos ad=0.1005p pd=1.34u as=55.5f ps=0.74u w=0.15u l=0.13u
X752 CTRL.t14 PH0.t10 CTRL.t13 VDD.t46 sg13_lv_pmos ad=0.34p pd=2.68u as=0 ps=0 w=1u l=0.13u
X753 VDD.t34 psdiff_1.buff_d8_1.inv_d2_0.VIN psdiff_1.buff_d8_1.inv_d4_0.VIN VDD.t33 sg13_lv_pmos ad=0.1005p pd=1.34u as=55.5f ps=0.74u w=0.15u l=0.13u
X754 psdiff_1.buff_d8_1.inv_d8_0.VIN psdiff_1.buff_d8_1.inv_d4_0.VIN VDD.t71 VDD.t33 sg13_lv_pmos ad=55.5f pd=0.74u as=0.1005p ps=1.34u w=0.15u l=0.13u
X755 VSS.t327 psdiff_1.VOUTDP psdiff_0.buff_d8_0.VIN.t14 VSS.t336 sg13_lv_nmos ad=55.5f pd=0.74u as=55.5f ps=0.74u w=0.15u l=0.13u
X756 CTRL.t2 PH4.t10 CTRL.t2 VDD.t30 sg13_lv_pmos ad=0.19p pd=1.38u as=0 ps=0 w=1u l=0.13u
X757 CTRL.t9 PH3.t10 CTRL.t9 VDD.t60 sg13_lv_pmos ad=0.19p pd=1.38u as=0 ps=0 w=1u l=0.13u
X758 PH0.t3 buff_d8_5.inv_d8_0.VIN VDD.t194 VDD.t192 sg13_lv_pmos ad=55.5f pd=0.74u as=0.1005p ps=1.34u w=0.15u l=0.13u
X759 psdiff_0.buff_d8_1.VIN.t3 psdiff_1.VOUTDN VSS.t94 VSS.t93 sg13_lv_nmos ad=55.5f pd=0.74u as=55.5f ps=0.74u w=0.15u l=0.13u
X760 VSS.t123 buff_d8_2.inv_d4_0.VIN buff_d8_2.inv_d8_0.VIN VSS.t122 sg13_lv_nmos ad=0.1005p pd=1.34u as=55.5f ps=0.74u w=0.15u l=0.13u
X761 VSS.t383 psdiff_2.CLKN psdiff_2.buff_d8_0.VIN.t7 VSS.t380 sg13_lv_nmos ad=0.1005p pd=1.34u as=55.5f ps=0.74u w=0.15u l=0.13u
X762 psdiff_2.buff_d8_0.VIN.t2 psdiff_2.CLKN VSS.t382 VSS.t149 sg13_lv_nmos ad=55.5f pd=0.74u as=55.5f ps=0.74u w=0.15u l=0.13u
X763 CTRL.t9 PH3.t10 CTRL.t9 VDD.t47 sg13_lv_pmos ad=0.19p pd=1.38u as=0 ps=0 w=1u l=0.13u
X764 VDD.t170 a_1214_1266# psdiff_2.buff_d8_1.VIN.t27 VDD.t169 sg13_lv_pmos ad=55.5f pd=0.74u as=55.5f ps=0.74u w=0.15u l=0.13u
X765 VSS.t491 psdiff_0.buff_d8_0.inv_d8_0.VIN psdiff_2.CLKN VSS.t490 sg13_lv_nmos ad=0.1005p pd=1.34u as=55.5f ps=0.74u w=0.15u l=0.13u
X766 psdiff_1.buff_d8_1.VIN.t19 VSS.t611 VDD.t322 VDD.t129 sg13_lv_pmos ad=55.5f pd=0.74u as=55.5f ps=0.74u w=0.15u l=0.13u
X767 VDD.t241 psdiff_1.buff_d8_0.inv_d4_0.VIN psdiff_1.buff_d8_0.inv_d8_0.VIN VDD.t0 sg13_lv_pmos ad=0.1005p pd=1.34u as=55.5f ps=0.74u w=0.15u l=0.13u
X768 VSS.t223 psdiff_2.buff_d8_1.inv_d8_0.VIN psdiff_2.VOUTDN VSS.t222 sg13_lv_nmos ad=0.1005p pd=1.34u as=55.5f ps=0.74u w=0.15u l=0.13u
X769 PH1.t6 buff_d8_3.inv_d8_0.VIN VSS.t543 VSS.t542 sg13_lv_nmos ad=55.5f pd=0.74u as=0.1005p ps=1.34u w=0.15u l=0.13u
X770 psdiff_2.buff_d8_0.inv_d8_0.VIN psdiff_2.buff_d8_0.inv_d4_0.VIN VSS.t601 VSS.t600 sg13_lv_nmos ad=55.5f pd=0.74u as=0.1005p ps=1.34u w=0.15u l=0.13u
X771 VDD.t259 buff_d8_2.inv_d2_0.VIN buff_d8_2.inv_d4_0.VIN VDD.t25 sg13_lv_pmos ad=0.1005p pd=1.34u as=55.5f ps=0.74u w=0.15u l=0.13u
X772 VDD.t224 buff_d8_0.inv_d8_0.VIN PH2.t3 VDD.t25 sg13_lv_pmos ad=0.1005p pd=1.34u as=55.5f ps=0.74u w=0.15u l=0.13u
X773 CTRL.t2 PH4.t10 CTRL.t2 VDD.t149 sg13_lv_pmos ad=0.19p pd=1.38u as=0 ps=0 w=1u l=0.13u
X774 psdiff_2.buff_d8_1.VIN.t21 VSS.t610 VDD.t283 VDD.t169 sg13_lv_pmos ad=55.5f pd=0.74u as=55.5f ps=0.74u w=0.15u l=0.13u
X775 CTRL.t11 PH0.t10 CTRL.t11 VDD.t46 sg13_lv_pmos ad=0.19p pd=1.38u as=0 ps=0 w=1u l=0.13u
X776 psdiff_0.buff_d8_0.VIN.t24 VSS.t612 VDD.t362 VDD.t108 sg13_lv_pmos ad=55.5f pd=0.74u as=55.5f ps=0.74u w=0.15u l=0.13u
X777 VSS.t517 buff_d8_5.inv_d8_0.VIN PH0.t7 VSS.t516 sg13_lv_nmos ad=0.1005p pd=1.34u as=55.5f ps=0.74u w=0.15u l=0.13u
X778 buff_d8_2.inv_d8_0.VIN buff_d8_2.inv_d4_0.VIN VDD.t28 VDD.t27 sg13_lv_pmos ad=55.5f pd=0.74u as=0.1005p ps=1.34u w=0.15u l=0.13u
X779 PH3.t3 buff_d8_4.inv_d8_0.VIN VDD.t101 VDD.t23 sg13_lv_pmos ad=55.5f pd=0.74u as=0.1005p ps=1.34u w=0.15u l=0.13u
X780 VSS.t599 psdiff_2.buff_d8_0.inv_d4_0.VIN psdiff_2.buff_d8_0.inv_d8_0.VIN VSS.t598 sg13_lv_nmos ad=0.1005p pd=1.34u as=55.5f ps=0.74u w=0.15u l=0.13u
X781 CTRL.t1 PH4.t10 CTRL.t1 VDD.t30 sg13_lv_pmos ad=0.19p pd=1.38u as=0 ps=0 w=1u l=0.13u
X782 VSS.t86 psdiff_1.VOUTDN psdiff_0.buff_d8_1.VIN.t5 VSS.t92 sg13_lv_nmos ad=55.5f pd=0.74u as=55.5f ps=0.74u w=0.15u l=0.13u
X783 psdiff_0.buff_d8_1.VIN.t28 a_7162_1266# VDD.t117 VDD.t108 sg13_lv_pmos ad=55.5f pd=0.74u as=55.5f ps=0.74u w=0.15u l=0.13u
X784 CTRL.t3 PH1.t11 CTRL.t3 VDD.t25 sg13_lv_pmos ad=0.19p pd=1.38u as=0 ps=0 w=1u l=0.13u
X785 psdiff_2.CLKP.t4 psdiff_0.buff_d8_1.inv_d8_0.VIN VSS.t437 VSS.t436 sg13_lv_nmos ad=55.5f pd=0.74u as=0.1005p ps=1.34u w=0.15u l=0.13u
X786 VDD.t250 a_57_1122# psdiff_2.buff_d8_0.VIN.t28 VDD.t169 sg13_lv_pmos ad=55.5f pd=0.74u as=55.5f ps=0.74u w=0.15u l=0.13u
X787 CTRL.t12 PH0.t10 CTRL.t11 VDD.t46 sg13_lv_pmos ad=0.34p pd=2.68u as=0 ps=0 w=1u l=0.13u
X788 psdiff_1.buff_d8_0.VIN.t0 psdiff_2.VOUTDP VSS.t52 VSS.t50 sg13_lv_nmos ad=55.5f pd=0.74u as=55.5f ps=0.74u w=0.15u l=0.13u
X789 VDD.t77 psdiff_1.buff_d8_1.inv_d8_0.VIN psdiff_1.VOUTDN VDD.t33 sg13_lv_pmos ad=0.1005p pd=1.34u as=55.5f ps=0.74u w=0.15u l=0.13u
X790 psdiff_1.buff_d8_0.VIN.t27 VSS.t611 VDD.t321 VDD.t129 sg13_lv_pmos ad=55.5f pd=0.74u as=0.1005p ps=1.34u w=0.15u l=0.13u
X791 VSS.t239 psdiff_2.VOUTDN psdiff_1.buff_d8_1.VIN.t9 VSS.t150 sg13_lv_nmos ad=55.5f pd=0.74u as=55.5f ps=0.74u w=0.15u l=0.13u
X792 psdiff_1.VOUTDN psdiff_1.buff_d8_1.inv_d8_0.VIN VDD.t76 VDD.t33 sg13_lv_pmos ad=55.5f pd=0.74u as=0.1005p ps=1.34u w=0.15u l=0.13u
X793 CTRL.t22 PH5.t10 CTRL.t22 VDD.t38 sg13_lv_pmos ad=0.19p pd=1.38u as=0 ps=0 w=1u l=0.13u
X794 psdiff_1.buff_d8_0.VIN.t26 VSS.t611 VDD.t320 VDD.t129 sg13_lv_pmos ad=55.5f pd=0.74u as=55.5f ps=0.74u w=0.15u l=0.13u
X795 PH0.t6 buff_d8_5.inv_d8_0.VIN VSS.t515 VSS.t514 sg13_lv_nmos ad=55.5f pd=0.74u as=0.1005p ps=1.34u w=0.15u l=0.13u
X796 VDD.t361 VSS.t612 psdiff_0.buff_d8_0.VIN.t23 VDD.t108 sg13_lv_pmos ad=55.5f pd=0.74u as=55.5f ps=0.74u w=0.15u l=0.13u
X797 VSS.t381 psdiff_2.CLKN psdiff_2.buff_d8_0.VIN.t6 VSS.t380 sg13_lv_nmos ad=0.1005p pd=1.34u as=55.5f ps=0.74u w=0.15u l=0.13u
X798 VSS.t458 psdiff_2.CLKP.t8 psdiff_2.buff_d8_1.VIN.t6 VSS.t457 sg13_lv_nmos ad=55.5f pd=0.74u as=55.5f ps=0.74u w=0.15u l=0.13u
X799 VSS.t195 psdiff_1.buff_d8_1.inv_d4_0.VIN psdiff_1.buff_d8_1.inv_d8_0.VIN VSS.t194 sg13_lv_nmos ad=0.1005p pd=1.34u as=55.5f ps=0.74u w=0.15u l=0.13u
X800 psdiff_2.buff_d8_0.VIN.t5 psdiff_2.CLKN VSS.t379 VSS.t149 sg13_lv_nmos ad=55.5f pd=0.74u as=55.5f ps=0.74u w=0.15u l=0.13u
X801 CTRL.t22 PH5.t10 CTRL.t22 VDD.t41 sg13_lv_pmos ad=0.19p pd=1.38u as=0 ps=0 w=1u l=0.13u
X802 psdiff_2.buff_d8_0.VIN.t21 VSS.t610 VDD.t282 VDD.t169 sg13_lv_pmos ad=55.5f pd=0.74u as=55.5f ps=0.74u w=0.15u l=0.13u
X803 psdiff_1.buff_d8_1.VIN.t29 a_4188_1266# VDD.t233 VDD.t129 sg13_lv_pmos ad=55.5f pd=0.74u as=55.5f ps=0.74u w=0.15u l=0.13u
X804 CTRL.t1 PH4.t10 CTRL.t1 VDD.t149 sg13_lv_pmos ad=0.19p pd=1.38u as=0 ps=0 w=1u l=0.13u
X805 psdiff_2.buff_d8_0.VIN.t20 VSS.t610 VDD.t281 VDD.t169 sg13_lv_pmos ad=55.5f pd=0.74u as=55.5f ps=0.74u w=0.15u l=0.13u
X806 VDD.t360 VSS.t612 psdiff_0.buff_d8_1.VIN.t22 VDD.t108 sg13_lv_pmos ad=55.5f pd=0.74u as=55.5f ps=0.74u w=0.15u l=0.13u
X807 PH0.t2 buff_d8_5.inv_d8_0.VIN VDD.t193 VDD.t192 sg13_lv_pmos ad=55.5f pd=0.74u as=0.1005p ps=1.34u w=0.15u l=0.13u
X808 CTRL.t9 PH0.t10 CTRL.t9 VDD.t46 sg13_lv_pmos ad=0.19p pd=1.38u as=0 ps=0 w=1u l=0.13u
X809 PH4.t6 buff_d8_2.inv_d8_0.VIN VSS.t413 VSS.t412 sg13_lv_nmos ad=55.5f pd=0.74u as=0.1005p ps=1.34u w=0.15u l=0.13u
X810 CTRL.t3 PH1.t11 CTRL.t3 VDD.t30 sg13_lv_pmos ad=0.19p pd=1.38u as=0 ps=0 w=1u l=0.13u
X811 psdiff_2.VOUTDN psdiff_2.buff_d8_1.inv_d8_0.VIN VSS.t221 VSS.t220 sg13_lv_nmos ad=55.5f pd=0.74u as=0.1005p ps=1.34u w=0.15u l=0.13u
X812 VSS.t313 buff_d8_1.inv_d2_0.VIN buff_d8_1.inv_d4_0.VIN VSS.t312 sg13_lv_nmos ad=0.1005p pd=1.34u as=55.5f ps=0.74u w=0.15u l=0.13u
X813 VSS.t1 psdiff_0.buff_d8_0.inv_d2_0.VIN psdiff_0.buff_d8_0.inv_d4_0.VIN VSS.t0 sg13_lv_nmos ad=0.1005p pd=1.34u as=55.5f ps=0.74u w=0.15u l=0.13u
X814 VDD.t280 VSS.t610 psdiff_2.buff_d8_1.VIN.t20 VDD.t169 sg13_lv_pmos ad=0.1005p pd=1.34u as=55.5f ps=0.74u w=0.15u l=0.13u
X815 VSS.t17 psdiff_1.buff_d8_0.inv_d8_0.VIN psdiff_1.VOUTDP VSS.t16 sg13_lv_nmos ad=0.1005p pd=1.34u as=55.5f ps=0.74u w=0.15u l=0.13u
X816 psdiff_2.buff_d8_1.VIN.t5 psdiff_2.CLKP.t8 VSS.t456 VSS.t454 sg13_lv_nmos ad=55.5f pd=0.74u as=0.1005p ps=1.34u w=0.15u l=0.13u
X817 VDD.t37 buff_d8_0.inv_d4_0.VIN buff_d8_0.inv_d8_0.VIN VDD.t36 sg13_lv_pmos ad=0.1005p pd=1.34u as=55.5f ps=0.74u w=0.15u l=0.13u
X818 buff_d8_1.inv_d8_0.VIN buff_d8_1.inv_d4_0.VIN VSS.t317 VSS.t316 sg13_lv_nmos ad=55.5f pd=0.74u as=0.1005p ps=1.34u w=0.15u l=0.13u
X819 CTRL.t10 PH0.t10 CTRL.t9 VDD.t46 sg13_lv_pmos ad=0.34p pd=2.68u as=0 ps=0 w=1u l=0.13u
X820 psdiff_0.buff_d8_0.VIN.t7 psdiff_1.VOUTDP VSS.t335 VSS.t331 sg13_lv_nmos ad=55.5f pd=0.74u as=55.5f ps=0.74u w=0.15u l=0.13u
X821 VSS.t82 psdiff_2.VOUTDN psdiff_1.buff_d8_1.VIN.t5 VSS.t244 sg13_lv_nmos ad=55.5f pd=0.74u as=55.5f ps=0.74u w=0.15u l=0.13u
X822 psdiff_1.buff_d8_1.VIN.t3 psdiff_2.VOUTDN VSS.t246 VSS.t242 sg13_lv_nmos ad=55.5f pd=0.74u as=55.5f ps=0.74u w=0.15u l=0.13u
X823 CTRL.t2 PH1.t11 CTRL.t2 VDD.t25 sg13_lv_pmos ad=0.19p pd=1.38u as=0 ps=0 w=1u l=0.13u
X824 psdiff_2.buff_d8_1.inv_d2_0.VIN psdiff_2.buff_d8_1.VIN.t32 VSS.t189 VSS.t188 sg13_lv_nmos ad=0.1005p pd=1.34u as=0.1005p ps=1.34u w=0.15u l=0.13u
X825 PH3.t2 buff_d8_4.inv_d8_0.VIN VDD.t100 VDD.t23 sg13_lv_pmos ad=55.5f pd=0.74u as=0.1005p ps=1.34u w=0.15u l=0.13u
X826 VDD.t204 buff_d8_3.inv_d4_0.VIN buff_d8_3.inv_d8_0.VIN VDD.t23 sg13_lv_pmos ad=0.1005p pd=1.34u as=55.5f ps=0.74u w=0.15u l=0.13u
X827 psdiff_1.VOUTDP psdiff_1.buff_d8_0.inv_d8_0.VIN VSS.t15 VSS.t14 sg13_lv_nmos ad=55.5f pd=0.74u as=0.1005p ps=1.34u w=0.15u l=0.13u
X828 VDD.t143 psdiff_0.buff_d8_1.inv_d4_0.VIN psdiff_0.buff_d8_1.inv_d8_0.VIN VDD.t33 sg13_lv_pmos ad=0.1005p pd=1.34u as=55.5f ps=0.74u w=0.15u l=0.13u
X829 psdiff_2.buff_d8_1.inv_d4_0.VIN psdiff_2.buff_d8_1.inv_d2_0.VIN VDD.t52 VDD.t33 sg13_lv_pmos ad=55.5f pd=0.74u as=0.1005p ps=1.34u w=0.15u l=0.13u
X830 VDD.t319 VSS.t611 psdiff_1.buff_d8_0.VIN.t25 VDD.t129 sg13_lv_pmos ad=55.5f pd=0.74u as=55.5f ps=0.74u w=0.15u l=0.13u
X831 a_1214_1266# CTRL.t25 psdiff_2.buff_d8_0.VIN.t0 VSS.t146 sg13_lv_nmos ad=55.5f pd=0.74u as=0.1005p ps=1.34u w=0.15u l=0.13u
X832 VSS.t561 psdiff_2.buff_d8_1.inv_d4_0.VIN psdiff_2.buff_d8_1.inv_d8_0.VIN VSS.t560 sg13_lv_nmos ad=0.1005p pd=1.34u as=55.5f ps=0.74u w=0.15u l=0.13u
X833 VDD.t318 VSS.t611 psdiff_1.buff_d8_1.VIN.t18 VDD.t129 sg13_lv_pmos ad=55.5f pd=0.74u as=55.5f ps=0.74u w=0.15u l=0.13u
X834 VSS.t293 buff_d8_4.inv_d8_0.VIN PH3.t8 VSS.t292 sg13_lv_nmos ad=0.1005p pd=1.34u as=55.5f ps=0.74u w=0.15u l=0.13u
X835 psdiff_1.buff_d8_0.VIN.t3 psdiff_2.VOUTDP VSS.t51 VSS.t50 sg13_lv_nmos ad=55.5f pd=0.74u as=55.5f ps=0.74u w=0.15u l=0.13u
X836 CTRL.t20 PH2.t10 CTRL.t20 VDD.t55 sg13_lv_pmos ad=0.19p pd=1.38u as=0 ps=0 w=1u l=0.13u
X837 VDD.t163 psdiff_0.buff_d8_1.inv_d8_0.VIN psdiff_2.CLKP.t2 VDD.t33 sg13_lv_pmos ad=0.1005p pd=1.34u as=55.5f ps=0.74u w=0.15u l=0.13u
X838 VDD.t317 VSS.t611 psdiff_1.buff_d8_1.VIN.t17 VDD.t129 sg13_lv_pmos ad=55.5f pd=0.74u as=55.5f ps=0.74u w=0.15u l=0.13u
X839 VSS.t234 psdiff_2.VOUTDN psdiff_1.buff_d8_1.VIN.t8 VSS.t150 sg13_lv_nmos ad=55.5f pd=0.74u as=55.5f ps=0.74u w=0.15u l=0.13u
X840 psdiff_0.buff_d8_1.VIN.t21 VSS.t612 VDD.t359 VDD.t108 sg13_lv_pmos ad=55.5f pd=0.74u as=55.5f ps=0.74u w=0.15u l=0.13u
X841 psdiff_1.VOUTDN psdiff_1.buff_d8_1.inv_d8_0.VIN VDD.t75 VDD.t33 sg13_lv_pmos ad=55.5f pd=0.74u as=0.1005p ps=1.34u w=0.15u l=0.13u
X842 psdiff_0.buff_d8_0.inv_d4_0.VIN psdiff_0.buff_d8_0.inv_d2_0.VIN VDD.t1 VDD.t0 sg13_lv_pmos ad=55.5f pd=0.74u as=0.1005p ps=1.34u w=0.15u l=0.13u
X843 CTRL.t8 PH3.t10 CTRL.t8 VDD.t60 sg13_lv_pmos ad=0.19p pd=1.38u as=0 ps=0 w=1u l=0.13u
X844 VDD.t246 psdiff_2.buff_d8_0.inv_d4_0.VIN psdiff_2.buff_d8_0.inv_d8_0.VIN VDD.t0 sg13_lv_pmos ad=0.1005p pd=1.34u as=55.5f ps=0.74u w=0.15u l=0.13u
X845 CTRL.t8 PH0.t10 CTRL.t8 VDD.t47 sg13_lv_pmos ad=0.19p pd=1.38u as=0 ps=0 w=1u l=0.13u
X846 VDD.t279 VSS.t610 psdiff_2.buff_d8_1.VIN.t19 VDD.t169 sg13_lv_pmos ad=55.5f pd=0.74u as=55.5f ps=0.74u w=0.15u l=0.13u
X847 CTRL.t2 PH1.t11 CTRL.t2 VDD.t30 sg13_lv_pmos ad=0.19p pd=1.38u as=0 ps=0 w=1u l=0.13u
X848 psdiff_0.buff_d8_0.VIN.t13 psdiff_1.VOUTDP VSS.t325 VSS.t329 sg13_lv_nmos ad=55.5f pd=0.74u as=55.5f ps=0.74u w=0.15u l=0.13u
X849 psdiff_2.VOUTDN psdiff_2.buff_d8_1.inv_d8_0.VIN VSS.t219 VSS.t218 sg13_lv_nmos ad=55.5f pd=0.74u as=0.1005p ps=1.34u w=0.15u l=0.13u
X850 PH5.t6 buff_d8_1.inv_d8_0.VIN VSS.t273 VSS.t272 sg13_lv_nmos ad=55.5f pd=0.74u as=0.1005p ps=1.34u w=0.15u l=0.13u
X851 VSS.t333 psdiff_1.VOUTDP psdiff_0.buff_d8_0.VIN.t12 VSS.t148 sg13_lv_nmos ad=55.5f pd=0.74u as=55.5f ps=0.74u w=0.15u l=0.13u
X852 psdiff_0.buff_d8_1.VIN.t4 psdiff_1.VOUTDN VSS.t91 VSS.t87 sg13_lv_nmos ad=55.5f pd=0.74u as=55.5f ps=0.74u w=0.15u l=0.13u
X853 CTRL.t21 PH2.t10 CTRL.t20 VDD.t25 sg13_lv_pmos ad=0.34p pd=2.68u as=0 ps=0 w=1u l=0.13u
X854 CTRL.t1 PH1.t11 CTRL.t1 VDD.t25 sg13_lv_pmos ad=0.19p pd=1.38u as=0 ps=0 w=1u l=0.13u
X855 VDD.t208 buff_d8_3.inv_d8_0.VIN PH1.t3 VDD.t23 sg13_lv_pmos ad=0.1005p pd=1.34u as=55.5f ps=0.74u w=0.15u l=0.13u
X856 VSS.t531 psdiff_1.buff_d8_0.inv_d2_0.VIN psdiff_1.buff_d8_0.inv_d4_0.VIN VSS.t530 sg13_lv_nmos ad=0.1005p pd=1.34u as=55.5f ps=0.74u w=0.15u l=0.13u
X857 VSS.t378 psdiff_2.CLKN psdiff_2.buff_d8_0.VIN.t4 VSS.t377 sg13_lv_nmos ad=55.5f pd=0.74u as=55.5f ps=0.74u w=0.15u l=0.13u
X858 VDD.t159 buff_d8_3.inv_d2_0.VIN buff_d8_3.inv_d4_0.VIN VDD.t23 sg13_lv_pmos ad=0.1005p pd=1.34u as=55.5f ps=0.74u w=0.15u l=0.13u
X859 psdiff_2.buff_d8_0.VIN.t3 psdiff_2.CLKN VSS.t376 VSS.t375 sg13_lv_nmos ad=55.5f pd=0.74u as=55.5f ps=0.74u w=0.15u l=0.13u
X860 psdiff_2.buff_d8_1.VIN.t4 psdiff_2.CLKP.t8 VSS.t455 VSS.t454 sg13_lv_nmos ad=55.5f pd=0.74u as=0.1005p ps=1.34u w=0.15u l=0.13u
X861 VDD.t316 VSS.t611 psdiff_1.buff_d8_0.VIN.t24 VDD.t129 sg13_lv_pmos ad=55.5f pd=0.74u as=55.5f ps=0.74u w=0.15u l=0.13u
X862 VSS.t77 psdiff_2.VOUTDN psdiff_1.buff_d8_1.VIN.t2 VSS.t244 sg13_lv_nmos ad=55.5f pd=0.74u as=55.5f ps=0.74u w=0.15u l=0.13u
X863 psdiff_0.buff_d8_0.VIN.t11 psdiff_1.VOUTDP VSS.t332 VSS.t331 sg13_lv_nmos ad=55.5f pd=0.74u as=55.5f ps=0.74u w=0.15u l=0.13u
X864 psdiff_1.buff_d8_1.VIN.t7 psdiff_2.VOUTDN VSS.t243 VSS.t242 sg13_lv_nmos ad=55.5f pd=0.74u as=55.5f ps=0.74u w=0.15u l=0.13u
X865 buff_d8_3.inv_d8_0.VIN buff_d8_3.inv_d4_0.VIN VDD.t203 VDD.t23 sg13_lv_pmos ad=55.5f pd=0.74u as=0.1005p ps=1.34u w=0.15u l=0.13u
X866 psdiff_2.buff_d8_1.VIN.t3 psdiff_2.CLKP.t8 VSS.t453 VSS.t147 sg13_lv_nmos ad=55.5f pd=0.74u as=55.5f ps=0.74u w=0.15u l=0.13u
X867 VDD.t182 psdiff_0.buff_d8_0.inv_d8_0.VIN psdiff_2.CLKN VDD.t0 sg13_lv_pmos ad=0.1005p pd=1.34u as=55.5f ps=0.74u w=0.15u l=0.13u
X868 CTRL.t0 PH4.t10 CTRL.t0 VDD.t149 sg13_lv_pmos ad=0.19p pd=1.38u as=0 ps=0 w=1u l=0.13u
X869 CTRL.t18 PH2.t10 CTRL.t18 VDD.t55 sg13_lv_pmos ad=0.19p pd=1.38u as=0 ps=0 w=1u l=0.13u
X870 VDD.t278 VSS.t610 psdiff_2.buff_d8_0.VIN.t19 VDD.t169 sg13_lv_pmos ad=55.5f pd=0.74u as=55.5f ps=0.74u w=0.15u l=0.13u
X871 psdiff_0.buff_d8_1.VIN.t20 VSS.t612 VDD.t358 VDD.t108 sg13_lv_pmos ad=55.5f pd=0.74u as=55.5f ps=0.74u w=0.15u l=0.13u
X872 VSS.t291 buff_d8_4.inv_d8_0.VIN PH3.t7 VSS.t290 sg13_lv_nmos ad=0.1005p pd=1.34u as=55.5f ps=0.74u w=0.15u l=0.13u
X873 psdiff_2.buff_d8_1.inv_d8_0.VIN psdiff_2.buff_d8_1.inv_d4_0.VIN VSS.t559 VSS.t558 sg13_lv_nmos ad=55.5f pd=0.74u as=0.1005p ps=1.34u w=0.15u l=0.13u
X874 VDD.t162 psdiff_0.buff_d8_1.inv_d8_0.VIN psdiff_2.CLKP.t1 VDD.t33 sg13_lv_pmos ad=0.1005p pd=1.34u as=55.5f ps=0.74u w=0.15u l=0.13u
X875 psdiff_2.CLKP.t0 psdiff_0.buff_d8_1.inv_d8_0.VIN VDD.t161 VDD.t33 sg13_lv_pmos ad=55.5f pd=0.74u as=0.1005p ps=1.34u w=0.15u l=0.13u
X876 CTRL.t1 PH1.t11 CTRL.t1 VDD.t30 sg13_lv_pmos ad=0.19p pd=1.38u as=0 ps=0 w=1u l=0.13u
X877 VSS.t90 psdiff_1.VOUTDN psdiff_0.buff_d8_1.VIN.t3 VSS.t89 sg13_lv_nmos ad=55.5f pd=0.74u as=55.5f ps=0.74u w=0.15u l=0.13u
X878 VSS.t579 buff_d8_0.inv_d8_0.VIN PH2.t8 VSS.t578 sg13_lv_nmos ad=0.1005p pd=1.34u as=55.5f ps=0.74u w=0.15u l=0.13u
X879 psdiff_2.CLKN psdiff_0.buff_d8_0.inv_d8_0.VIN VDD.t181 VDD.t0 sg13_lv_pmos ad=55.5f pd=0.74u as=0.1005p ps=1.34u w=0.15u l=0.13u
X880 VDD.t110 a_6005_1122# psdiff_0.buff_d8_0.VIN.t3 VDD.t108 sg13_lv_pmos ad=55.5f pd=0.74u as=55.5f ps=0.74u w=0.15u l=0.13u
X881 CTRL.t8 PH0.t10 CTRL.t8 VDD.t46 sg13_lv_pmos ad=0.19p pd=1.38u as=0 ps=0 w=1u l=0.13u
X882 buff_d8_2.inv_d4_0.VIN buff_d8_2.inv_d2_0.VIN VSS.t607 VSS.t606 sg13_lv_nmos ad=55.5f pd=0.74u as=0.1005p ps=1.34u w=0.15u l=0.13u
X883 PH2.t7 buff_d8_0.inv_d8_0.VIN VSS.t577 VSS.t576 sg13_lv_nmos ad=55.5f pd=0.74u as=0.1005p ps=1.34u w=0.15u l=0.13u
X884 VSS.t49 psdiff_2.VOUTDP psdiff_1.buff_d8_0.VIN.t2 VSS.t48 sg13_lv_nmos ad=0.1005p pd=1.34u as=55.5f ps=0.74u w=0.15u l=0.13u
X885 psdiff_2.buff_d8_0.VIN.t27 a_57_1122# VDD.t249 VDD.t169 sg13_lv_pmos ad=55.5f pd=0.74u as=0.1005p ps=1.34u w=0.15u l=0.13u
X886 psdiff_1.buff_d8_0.VIN.t1 psdiff_2.VOUTDP VSS.t47 VSS.t46 sg13_lv_nmos ad=55.5f pd=0.74u as=55.5f ps=0.74u w=0.15u l=0.13u
X887 VDD.t109 a_6005_1122# psdiff_0.buff_d8_0.VIN.t2 VDD.t108 sg13_lv_pmos ad=55.5f pd=0.74u as=55.5f ps=0.74u w=0.15u l=0.13u
X888 CTRL.t19 PH2.t10 CTRL.t18 VDD.t25 sg13_lv_pmos ad=0.34p pd=2.68u as=0 ps=0 w=1u l=0.13u
X889 psdiff_0.buff_d8_0.VIN.t10 psdiff_1.VOUTDP VSS.t330 VSS.t329 sg13_lv_nmos ad=55.5f pd=0.74u as=55.5f ps=0.74u w=0.15u l=0.13u
X890 VSS.t328 psdiff_1.VOUTDP psdiff_0.buff_d8_0.VIN.t9 VSS.t148 sg13_lv_nmos ad=55.5f pd=0.74u as=55.5f ps=0.74u w=0.15u l=0.13u
X891 VSS.t241 psdiff_2.VOUTDN psdiff_1.buff_d8_1.VIN.t6 VSS.t240 sg13_lv_nmos ad=55.5f pd=0.74u as=55.5f ps=0.74u w=0.15u l=0.13u
X892 psdiff_0.buff_d8_1.VIN.t2 psdiff_1.VOUTDN VSS.t88 VSS.t87 sg13_lv_nmos ad=55.5f pd=0.74u as=55.5f ps=0.74u w=0.15u l=0.13u
X893 buff_d8_4.inv_d8_0.VIN buff_d8_4.inv_d4_0.VIN VDD.t219 VDD.t23 sg13_lv_pmos ad=55.5f pd=0.74u as=0.1005p ps=1.34u w=0.15u l=0.13u
X894 VDD.t207 buff_d8_3.inv_d8_0.VIN PH1.t2 VDD.t23 sg13_lv_pmos ad=0.1005p pd=1.34u as=55.5f ps=0.74u w=0.15u l=0.13u
X895 psdiff_0.buff_d8_0.inv_d8_0.VIN psdiff_0.buff_d8_0.inv_d4_0.VIN VSS.t5 VSS.t4 sg13_lv_nmos ad=55.5f pd=0.74u as=0.1005p ps=1.34u w=0.15u l=0.13u
X896 VDD.t180 psdiff_0.buff_d8_0.inv_d8_0.VIN psdiff_2.CLKN VDD.t0 sg13_lv_pmos ad=0.1005p pd=1.34u as=55.5f ps=0.74u w=0.15u l=0.13u
X897 psdiff_2.buff_d8_0.inv_d8_0.VIN psdiff_2.buff_d8_0.inv_d4_0.VIN VDD.t245 VDD.t0 sg13_lv_pmos ad=55.5f pd=0.74u as=0.1005p ps=1.34u w=0.15u l=0.13u
X898 CTRL.t16 PH2.t10 CTRL.t16 VDD.t55 sg13_lv_pmos ad=0.19p pd=1.38u as=0 ps=0 w=1u l=0.13u
X899 VDD.t130 a_3031_1122# psdiff_1.buff_d8_0.VIN.t17 VDD.t129 sg13_lv_pmos ad=55.5f pd=0.74u as=55.5f ps=0.74u w=0.15u l=0.13u
X900 CTRL.t20 PH5.t10 CTRL.t20 VDD.t38 sg13_lv_pmos ad=0.19p pd=1.38u as=0 ps=0 w=1u l=0.13u
X901 psdiff_0.buff_d8_0.VIN.t22 VSS.t612 VDD.t357 VDD.t108 sg13_lv_pmos ad=55.5f pd=0.74u as=55.5f ps=0.74u w=0.15u l=0.13u
X902 VDD.t356 VSS.t612 psdiff_0.buff_d8_1.VIN.t19 VDD.t108 sg13_lv_pmos ad=0.1005p pd=1.34u as=55.5f ps=0.74u w=0.15u l=0.13u
X903 VDD.t125 buff_d8_1.inv_d4_0.VIN buff_d8_1.inv_d8_0.VIN VDD.t23 sg13_lv_pmos ad=0.1005p pd=1.34u as=55.5f ps=0.74u w=0.15u l=0.13u
X904 buff_d8_1.inv_d2_0.VIN psdiff_2.CLKN VDD.t147 VDD.t23 sg13_lv_pmos ad=0.1005p pd=1.34u as=0.1005p ps=1.34u w=0.15u l=0.13u
X905 PH2.t2 buff_d8_0.inv_d8_0.VIN VDD.t223 VDD.t25 sg13_lv_pmos ad=55.5f pd=0.74u as=0.1005p ps=1.34u w=0.15u l=0.13u
X906 psdiff_2.buff_d8_1.VIN.t2 psdiff_2.CLKP.t8 VSS.t452 VSS.t147 sg13_lv_nmos ad=55.5f pd=0.74u as=55.5f ps=0.74u w=0.15u l=0.13u
X907 psdiff_2.buff_d8_1.VIN.t18 VSS.t610 VDD.t277 VDD.t169 sg13_lv_pmos ad=55.5f pd=0.74u as=55.5f ps=0.74u w=0.15u l=0.13u
X908 VSS.t13 psdiff_1.buff_d8_0.inv_d8_0.VIN psdiff_1.VOUTDP VSS.t12 sg13_lv_nmos ad=0.1005p pd=1.34u as=55.5f ps=0.74u w=0.15u l=0.13u
X909 psdiff_2.VOUTDP psdiff_2.buff_d8_0.inv_d8_0.VIN VDD.t16 VDD.t0 sg13_lv_pmos ad=55.5f pd=0.74u as=0.1005p ps=1.34u w=0.15u l=0.13u
X910 psdiff_0.buff_d8_1.VIN.t1 psdiff_1.VOUTDN VSS.t86 VSS.t85 sg13_lv_nmos ad=55.5f pd=0.74u as=55.5f ps=0.74u w=0.15u l=0.13u
X911 psdiff_2.buff_d8_1.VIN.t17 VSS.t610 VDD.t276 VDD.t169 sg13_lv_pmos ad=55.5f pd=0.74u as=55.5f ps=0.74u w=0.15u l=0.13u
X912 PH3.t6 buff_d8_4.inv_d8_0.VIN VSS.t289 VSS.t288 sg13_lv_nmos ad=55.5f pd=0.74u as=0.1005p ps=1.34u w=0.15u l=0.13u
X913 psdiff_1.buff_d8_1.VIN.t5 psdiff_2.VOUTDN VSS.t239 VSS.t153 sg13_lv_nmos ad=55.5f pd=0.74u as=55.5f ps=0.74u w=0.15u l=0.13u
X914 psdiff_0.buff_d8_0.VIN.t8 psdiff_1.VOUTDP VSS.t327 VSS.t326 sg13_lv_nmos ad=55.5f pd=0.74u as=55.5f ps=0.74u w=0.15u l=0.13u
X915 psdiff_1.buff_d8_1.VIN.t4 psdiff_2.VOUTDN VSS.t238 VSS.t237 sg13_lv_nmos ad=55.5f pd=0.74u as=0.1005p ps=1.34u w=0.15u l=0.13u
X916 psdiff_0.buff_d8_1.VIN.t27 a_7162_1266# VDD.t261 VDD.t108 sg13_lv_pmos ad=55.5f pd=0.74u as=55.5f ps=0.74u w=0.15u l=0.13u
X917 CTRL.t17 PH2.t10 CTRL.t16 VDD.t25 sg13_lv_pmos ad=0.34p pd=2.68u as=0 ps=0 w=1u l=0.13u
X918 psdiff_2.VOUTDP psdiff_2.buff_d8_0.inv_d8_0.VIN VDD.t15 VDD.t0 sg13_lv_pmos ad=55.5f pd=0.74u as=0.1005p ps=1.34u w=0.15u l=0.13u
X919 PH2.t6 buff_d8_0.inv_d8_0.VIN VSS.t575 VSS.t574 sg13_lv_nmos ad=55.5f pd=0.74u as=0.1005p ps=1.34u w=0.15u l=0.13u
X920 psdiff_1.buff_d8_0.VIN.t23 VSS.t611 VDD.t315 VDD.t129 sg13_lv_pmos ad=55.5f pd=0.74u as=55.5f ps=0.74u w=0.15u l=0.13u
X921 VDD.t121 buff_d8_5.inv_d2_0.VIN buff_d8_5.inv_d4_0.VIN VDD.t61 sg13_lv_pmos ad=0.1005p pd=1.34u as=55.5f ps=0.74u w=0.15u l=0.13u
X922 VDD.t148 buff_d8_2.inv_d8_0.VIN PH4.t2 VDD.t61 sg13_lv_pmos ad=0.1005p pd=1.34u as=55.5f ps=0.74u w=0.15u l=0.13u
X923 psdiff_1.VOUTDN psdiff_1.buff_d8_1.inv_d8_0.VIN VSS.t203 VSS.t202 sg13_lv_nmos ad=55.5f pd=0.74u as=0.1005p ps=1.34u w=0.15u l=0.13u
X924 VSS.t374 psdiff_2.CLKN psdiff_2.buff_d8_0.VIN.t2 VSS.t373 sg13_lv_nmos ad=55.5f pd=0.74u as=55.5f ps=0.74u w=0.15u l=0.13u
X925 buff_d8_5.inv_d8_0.VIN buff_d8_5.inv_d4_0.VIN VDD.t188 VDD.t60 sg13_lv_pmos ad=55.5f pd=0.74u as=0.1005p ps=1.34u w=0.15u l=0.13u
X926 buff_d8_0.inv_d8_0.VIN buff_d8_0.inv_d4_0.VIN VSS.t135 VSS.t134 sg13_lv_nmos ad=55.5f pd=0.74u as=0.1005p ps=1.34u w=0.15u l=0.13u
X927 psdiff_1.buff_d8_0.VIN.t22 VSS.t611 VDD.t314 VDD.t129 sg13_lv_pmos ad=55.5f pd=0.74u as=55.5f ps=0.74u w=0.15u l=0.13u
X928 psdiff_1.buff_d8_1.VIN.t28 a_4188_1266# VDD.t134 VDD.t129 sg13_lv_pmos ad=55.5f pd=0.74u as=55.5f ps=0.74u w=0.15u l=0.13u
X929 VDD.t355 VSS.t612 psdiff_0.buff_d8_1.VIN.t18 VDD.t108 sg13_lv_pmos ad=55.5f pd=0.74u as=55.5f ps=0.74u w=0.15u l=0.13u
X930 psdiff_2.buff_d8_0.VIN.t18 VSS.t610 VDD.t275 VDD.t169 sg13_lv_pmos ad=55.5f pd=0.74u as=55.5f ps=0.74u w=0.15u l=0.13u
X931 CTRL.t0 PH1.t11 CTRL.t0 VDD.t25 sg13_lv_pmos ad=0.19p pd=1.38u as=0 ps=0 w=1u l=0.13u
X932 VDD.t354 VSS.t612 psdiff_0.buff_d8_1.VIN.t17 VDD.t108 sg13_lv_pmos ad=55.5f pd=0.74u as=55.5f ps=0.74u w=0.15u l=0.13u
X933 psdiff_1.buff_d8_1.VIN.t27 a_4188_1266# VDD.t231 VDD.t129 sg13_lv_pmos ad=55.5f pd=0.74u as=55.5f ps=0.74u w=0.15u l=0.13u
X934 CTRL.t18 PH5.t10 CTRL.t18 VDD.t38 sg13_lv_pmos ad=0.19p pd=1.38u as=0 ps=0 w=1u l=0.13u
X935 psdiff_2.buff_d8_0.VIN.t17 VSS.t610 VDD.t274 VDD.t169 sg13_lv_pmos ad=55.5f pd=0.74u as=55.5f ps=0.74u w=0.15u l=0.13u
X936 CTRL.t13 PH3.t10 CTRL.t13 VDD.t61 sg13_lv_pmos ad=0.19p pd=1.38u as=0 ps=0 w=1u l=0.13u
X937 psdiff_2.VOUTDN psdiff_2.buff_d8_1.inv_d8_0.VIN VDD.t83 VDD.t33 sg13_lv_pmos ad=55.5f pd=0.74u as=0.1005p ps=1.34u w=0.15u l=0.13u
X938 CTRL.t0 PH1.t11 CTRL.t0 VDD.t27 sg13_lv_pmos ad=0.19p pd=1.38u as=0 ps=0 w=1u l=0.13u
X939 CTRL.t13 PH3.t10 CTRL.t13 VDD.t60 sg13_lv_pmos ad=0.19p pd=1.38u as=0 ps=0 w=1u l=0.13u
X940 VSS.t567 buff_d8_4.inv_d4_0.VIN buff_d8_4.inv_d8_0.VIN VSS.t566 sg13_lv_nmos ad=0.1005p pd=1.34u as=55.5f ps=0.74u w=0.15u l=0.13u
X941 VDD.t92 buff_d8_1.inv_d8_0.VIN PH5.t2 VDD.t23 sg13_lv_pmos ad=0.1005p pd=1.34u as=55.5f ps=0.74u w=0.15u l=0.13u
X942 VSS.t325 psdiff_1.VOUTDP psdiff_0.buff_d8_0.VIN.t7 VSS.t324 sg13_lv_nmos ad=55.5f pd=0.74u as=55.5f ps=0.74u w=0.15u l=0.13u
X943 VSS.t236 psdiff_2.VOUTDN psdiff_1.buff_d8_1.VIN.t3 VSS.t235 sg13_lv_nmos ad=55.5f pd=0.74u as=55.5f ps=0.74u w=0.15u l=0.13u
X944 buff_d8_0.inv_d4_0.VIN buff_d8_0.inv_d2_0.VIN VDD.t157 VDD.t36 sg13_lv_pmos ad=55.5f pd=0.74u as=0.1005p ps=1.34u w=0.15u l=0.13u
X945 VSS.t84 psdiff_1.VOUTDN psdiff_0.buff_d8_1.VIN.t0 VSS.t83 sg13_lv_nmos ad=55.5f pd=0.74u as=55.5f ps=0.74u w=0.15u l=0.13u
X946 VSS.t45 psdiff_2.VOUTDP psdiff_1.buff_d8_0.VIN.t0 VSS.t44 sg13_lv_nmos ad=55.5f pd=0.74u as=55.5f ps=0.74u w=0.15u l=0.13u
X947 psdiff_1.buff_d8_1.VIN.t2 psdiff_2.VOUTDN VSS.t234 VSS.t153 sg13_lv_nmos ad=55.5f pd=0.74u as=55.5f ps=0.74u w=0.15u l=0.13u
R0 VDD.n358 VDD.t177 17.6227
R1 VDD.n355 VDD.t173 17.6227
R2 VDD.n351 VDD.t170 17.6227
R3 VDD.n338 VDD.t171 17.6227
R4 VDD.n334 VDD.t172 17.6227
R5 VDD.n330 VDD.t178 17.6227
R6 VDD.n305 VDD.t250 17.6227
R7 VDD.n308 VDD.t251 17.6227
R8 VDD.n325 VDD.t254 17.6227
R9 VDD.n314 VDD.t252 17.6227
R10 VDD.n311 VDD.t249 17.6227
R11 VDD.n478 VDD.t264 17.6227
R12 VDD.n475 VDD.t266 17.6227
R13 VDD.n471 VDD.t263 17.6227
R14 VDD.n466 VDD.t265 17.6227
R15 VDD.n462 VDD.t261 17.6227
R16 VDD.n458 VDD.t117 17.6227
R17 VDD.n122 VDD.t109 17.6227
R18 VDD.n125 VDD.t116 17.6227
R19 VDD.n453 VDD.t110 17.6227
R20 VDD.n131 VDD.t111 17.6227
R21 VDD.n128 VDD.t114 17.6227
R22 VDD.n409 VDD.t234 17.6227
R23 VDD.n406 VDD.t236 17.6227
R24 VDD.n402 VDD.t238 17.6227
R25 VDD.n242 VDD.t231 17.6227
R26 VDD.n244 VDD.t233 17.6227
R27 VDD.n398 VDD.t134 17.6227
R28 VDD.n269 VDD.t131 17.6227
R29 VDD.n265 VDD.t130 17.6227
R30 VDD.n262 VDD.t135 17.6227
R31 VDD.n251 VDD.t133 17.6227
R32 VDD.n248 VDD.t136 17.6227
R33 VDD.n505 VDD.t272 17.3167
R34 VDD.n507 VDD.t158 17.3167
R35 VDD.n55 VDD.t157 17.3167
R36 VDD.n0 VDD.t37 17.3167
R37 VDD.n1 VDD.t40 17.3167
R38 VDD.n53 VDD.t39 17.3167
R39 VDD.n52 VDD.t42 17.3167
R40 VDD.n2 VDD.t230 17.3167
R41 VDD.n3 VDD.t225 17.3167
R42 VDD.n50 VDD.t226 17.3167
R43 VDD.n49 VDD.t227 17.3167
R44 VDD.n4 VDD.t229 17.3167
R45 VDD.n5 VDD.t223 17.3167
R46 VDD.n47 VDD.t224 17.3167
R47 VDD.n46 VDD.t228 17.3167
R48 VDD.n45 VDD.t26 17.3167
R49 VDD.n7 VDD.t259 17.3167
R50 VDD.n9 VDD.t260 17.3167
R51 VDD.n44 VDD.t32 17.3167
R52 VDD.n43 VDD.t28 17.3167
R53 VDD.n42 VDD.t29 17.3167
R54 VDD.n11 VDD.t31 17.3167
R55 VDD.n41 VDD.t153 17.3167
R56 VDD.n40 VDD.t150 17.3167
R57 VDD.n39 VDD.t156 17.3167
R58 VDD.n13 VDD.t154 17.3167
R59 VDD.n38 VDD.t151 17.3167
R60 VDD.n37 VDD.t155 17.3167
R61 VDD.n36 VDD.t148 17.3167
R62 VDD.n15 VDD.t152 17.3167
R63 VDD.n34 VDD.t91 17.3167
R64 VDD.n33 VDD.t121 17.3167
R65 VDD.n31 VDD.t122 17.3167
R66 VDD.n16 VDD.t189 17.3167
R67 VDD.n17 VDD.t188 17.3167
R68 VDD.n29 VDD.t191 17.3167
R69 VDD.n28 VDD.t190 17.3167
R70 VDD.n18 VDD.t195 17.3167
R71 VDD.n19 VDD.t197 17.3167
R72 VDD.n26 VDD.t196 17.3167
R73 VDD.n25 VDD.t200 17.3167
R74 VDD.n20 VDD.t198 17.3167
R75 VDD.n21 VDD.t193 17.3167
R76 VDD.n23 VDD.t199 17.3167
R77 VDD.n22 VDD.t194 17.3167
R78 VDD.n433 VDD.t99 17.3167
R79 VDD.n432 VDD.t97 17.3167
R80 VDD.n431 VDD.t93 17.3167
R81 VDD.n192 VDD.t94 17.3167
R82 VDD.n430 VDD.t92 17.3167
R83 VDD.n436 VDD.t96 17.3167
R84 VDD.n193 VDD.t95 17.3167
R85 VDD.n195 VDD.t98 17.3167
R86 VDD.n428 VDD.t125 17.3167
R87 VDD.n426 VDD.t127 17.3167
R88 VDD.n425 VDD.t126 17.3167
R89 VDD.n197 VDD.t128 17.3167
R90 VDD.n424 VDD.t123 17.3167
R91 VDD.n423 VDD.t124 17.3167
R92 VDD.n199 VDD.t147 17.3167
R93 VDD.n200 VDD.t213 17.3167
R94 VDD.n202 VDD.t209 17.3167
R95 VDD.n421 VDD.t207 17.3167
R96 VDD.n420 VDD.t212 17.3167
R97 VDD.n203 VDD.t214 17.3167
R98 VDD.n204 VDD.t210 17.3167
R99 VDD.n237 VDD.t208 17.3167
R100 VDD.n236 VDD.t211 17.3167
R101 VDD.n235 VDD.t206 17.3167
R102 VDD.n206 VDD.t203 17.3167
R103 VDD.n233 VDD.t204 17.3167
R104 VDD.n232 VDD.t205 17.3167
R105 VDD.n207 VDD.t159 17.3167
R106 VDD.n208 VDD.t160 17.3167
R107 VDD.n230 VDD.t140 17.3167
R108 VDD.n229 VDD.t103 17.3167
R109 VDD.n227 VDD.t100 17.3167
R110 VDD.n226 VDD.t106 17.3167
R111 VDD.n210 VDD.t105 17.3167
R112 VDD.n225 VDD.t104 17.3167
R113 VDD.n224 VDD.t101 17.3167
R114 VDD.n223 VDD.t107 17.3167
R115 VDD.n212 VDD.t102 17.3167
R116 VDD.n221 VDD.t222 17.3167
R117 VDD.n220 VDD.t221 17.3167
R118 VDD.n219 VDD.t220 17.3167
R119 VDD.n214 VDD.t219 17.3167
R120 VDD.n218 VDD.t120 17.3167
R121 VDD.n217 VDD.t119 17.3167
R122 VDD.n215 VDD.t24 17.3167
R123 VDD.n443 VDD.t64 17.3167
R124 VDD.n442 VDD.t2 17.3167
R125 VDD.n440 VDD.t1 17.3167
R126 VDD.n136 VDD.t5 17.3167
R127 VDD.n137 VDD.t6 17.3167
R128 VDD.n189 VDD.t3 17.3167
R129 VDD.n188 VDD.t4 17.3167
R130 VDD.n138 VDD.t182 17.3167
R131 VDD.n139 VDD.t184 17.3167
R132 VDD.n185 VDD.t187 17.3167
R133 VDD.n184 VDD.t181 17.3167
R134 VDD.n140 VDD.t185 17.3167
R135 VDD.n446 VDD.t186 17.3167
R136 VDD.n182 VDD.t180 17.3167
R137 VDD.n181 VDD.t183 17.3167
R138 VDD.n180 VDD.t54 17.3167
R139 VDD.n142 VDD.t201 17.3167
R140 VDD.n144 VDD.t202 17.3167
R141 VDD.n179 VDD.t243 17.3167
R142 VDD.n178 VDD.t244 17.3167
R143 VDD.n177 VDD.t241 17.3167
R144 VDD.n146 VDD.t242 17.3167
R145 VDD.n176 VDD.t12 17.3167
R146 VDD.n175 VDD.t14 17.3167
R147 VDD.n174 VDD.t9 17.3167
R148 VDD.n148 VDD.t10 17.3167
R149 VDD.n173 VDD.t7 17.3167
R150 VDD.n172 VDD.t8 17.3167
R151 VDD.n171 VDD.t11 17.3167
R152 VDD.n150 VDD.t13 17.3167
R153 VDD.n169 VDD.t67 17.3167
R154 VDD.n168 VDD.t69 17.3167
R155 VDD.n166 VDD.t70 17.3167
R156 VDD.n151 VDD.t246 17.3167
R157 VDD.n152 VDD.t247 17.3167
R158 VDD.n164 VDD.t248 17.3167
R159 VDD.n163 VDD.t245 17.3167
R160 VDD.n153 VDD.t21 17.3167
R161 VDD.n154 VDD.t16 17.3167
R162 VDD.n161 VDD.t20 17.3167
R163 VDD.n160 VDD.t22 17.3167
R164 VDD.n155 VDD.t18 17.3167
R165 VDD.n156 VDD.t19 17.3167
R166 VDD.n158 VDD.t17 17.3167
R167 VDD.n157 VDD.t15 17.3167
R168 VDD.n492 VDD.t162 17.3167
R169 VDD.n491 VDD.t166 17.3167
R170 VDD.n490 VDD.t164 17.3167
R171 VDD.n62 VDD.t161 17.3167
R172 VDD.n489 VDD.t163 17.3167
R173 VDD.n495 VDD.t167 17.3167
R174 VDD.n63 VDD.t165 17.3167
R175 VDD.n65 VDD.t168 17.3167
R176 VDD.n487 VDD.t146 17.3167
R177 VDD.n118 VDD.t144 17.3167
R178 VDD.n117 VDD.t143 17.3167
R179 VDD.n67 VDD.t145 17.3167
R180 VDD.n115 VDD.t141 17.3167
R181 VDD.n114 VDD.t142 17.3167
R182 VDD.n69 VDD.t59 17.3167
R183 VDD.n70 VDD.t80 17.3167
R184 VDD.n72 VDD.t75 17.3167
R185 VDD.n112 VDD.t77 17.3167
R186 VDD.n111 VDD.t79 17.3167
R187 VDD.n73 VDD.t81 17.3167
R188 VDD.n74 VDD.t76 17.3167
R189 VDD.n109 VDD.t82 17.3167
R190 VDD.n108 VDD.t78 17.3167
R191 VDD.n107 VDD.t72 17.3167
R192 VDD.n76 VDD.t71 17.3167
R193 VDD.n105 VDD.t74 17.3167
R194 VDD.n104 VDD.t73 17.3167
R195 VDD.n103 VDD.t34 17.3167
R196 VDD.n78 VDD.t35 17.3167
R197 VDD.n101 VDD.t51 17.3167
R198 VDD.n100 VDD.t87 17.3167
R199 VDD.n98 VDD.t90 17.3167
R200 VDD.n97 VDD.t88 17.3167
R201 VDD.n80 VDD.t85 17.3167
R202 VDD.n96 VDD.t84 17.3167
R203 VDD.n95 VDD.t83 17.3167
R204 VDD.n94 VDD.t89 17.3167
R205 VDD.n82 VDD.t86 17.3167
R206 VDD.n92 VDD.t215 17.3167
R207 VDD.n91 VDD.t216 17.3167
R208 VDD.n90 VDD.t217 17.3167
R209 VDD.n84 VDD.t218 17.3167
R210 VDD.n88 VDD.t53 17.3167
R211 VDD.n87 VDD.t52 17.3167
R212 VDD.n85 VDD.t68 17.3167
R213 VDD.n300 VDD.t49 17.3167
R214 VDD.n279 VDD.t50 17.3167
R215 VDD.n280 VDD.t62 17.3167
R216 VDD.n297 VDD.t63 17.3167
R217 VDD.n293 VDD.t44 17.3167
R218 VDD.n283 VDD.t45 17.3167
R219 VDD.n282 VDD.t271 17.3167
R220 VDD.n296 VDD.t273 17.3167
R221 VDD.n289 VDD.t66 17.3167
R222 VDD.n288 VDD.t65 17.3167
R223 VDD.n287 VDD.t57 17.3167
R224 VDD.n292 VDD.t58 17.3167
R225 VDD.n358 VDD.t294 17.0005
R226 VDD.n359 VDD.t280 17.0005
R227 VDD.n355 VDD.t284 17.0005
R228 VDD.n356 VDD.t285 17.0005
R229 VDD.n351 VDD.t291 17.0005
R230 VDD.n352 VDD.t277 17.0005
R231 VDD.n338 VDD.t286 17.0005
R232 VDD.n339 VDD.t301 17.0005
R233 VDD.n334 VDD.t279 17.0005
R234 VDD.n335 VDD.t276 17.0005
R235 VDD.n330 VDD.t297 17.0005
R236 VDD.n331 VDD.t283 17.0005
R237 VDD.n305 VDD.t289 17.0005
R238 VDD.n306 VDD.t275 17.0005
R239 VDD.n308 VDD.t296 17.0005
R240 VDD.n309 VDD.t282 17.0005
R241 VDD.n325 VDD.t278 17.0005
R242 VDD.n326 VDD.t274 17.0005
R243 VDD.n314 VDD.t295 17.0005
R244 VDD.n315 VDD.t281 17.0005
R245 VDD.n311 VDD.t304 17.0005
R246 VDD.n312 VDD.t287 17.0005
R247 VDD.n362 VDD.n361 17.0005
R248 VDD.n478 VDD.t356 17.0005
R249 VDD.n479 VDD.t381 17.0005
R250 VDD.n475 VDD.t364 17.0005
R251 VDD.n476 VDD.t359 17.0005
R252 VDD.n471 VDD.t370 17.0005
R253 VDD.n472 VDD.t354 17.0005
R254 VDD.n466 VDD.t358 17.0005
R255 VDD.n467 VDD.t360 17.0005
R256 VDD.n462 VDD.t372 17.0005
R257 VDD.n463 VDD.t355 17.0005
R258 VDD.n458 VDD.t378 17.0005
R259 VDD.n459 VDD.t361 17.0005
R260 VDD.n122 VDD.t365 17.0005
R261 VDD.n123 VDD.t369 17.0005
R262 VDD.n125 VDD.t373 17.0005
R263 VDD.n126 VDD.t357 17.0005
R264 VDD.n453 VDD.t367 17.0005
R265 VDD.n454 VDD.t371 17.0005
R266 VDD.n131 VDD.t362 17.0005
R267 VDD.n132 VDD.t376 17.0005
R268 VDD.n128 VDD.t366 17.0005
R269 VDD.n129 VDD.t391 17.0005
R270 VDD.n482 VDD.n481 17.0005
R271 VDD.n292 VDD.n291 17.0005
R272 VDD.n291 VDD.n288 17.0005
R273 VDD.n296 VDD.n295 17.0005
R274 VDD.n295 VDD.n283 17.0005
R275 VDD.n299 VDD.n280 17.0005
R276 VDD.n300 VDD.n299 17.0005
R277 VDD.n409 VDD.t351 17.0005
R278 VDD.n410 VDD.t334 17.0005
R279 VDD.n406 VDD.t318 17.0005
R280 VDD.n407 VDD.t343 17.0005
R281 VDD.n402 VDD.t325 17.0005
R282 VDD.n403 VDD.t322 17.0005
R283 VDD.n242 VDD.t317 17.0005
R284 VDD.n243 VDD.t326 17.0005
R285 VDD.n244 VDD.t324 17.0005
R286 VDD.n245 VDD.t331 17.0005
R287 VDD.n398 VDD.t319 17.0005
R288 VDD.n399 VDD.t327 17.0005
R289 VDD.n269 VDD.t336 17.0005
R290 VDD.n270 VDD.t323 17.0005
R291 VDD.n265 VDD.t314 17.0005
R292 VDD.n266 VDD.t330 17.0005
R293 VDD.n262 VDD.t320 17.0005
R294 VDD.n263 VDD.t345 17.0005
R295 VDD.n251 VDD.t315 17.0005
R296 VDD.n252 VDD.t316 17.0005
R297 VDD.n248 VDD.t321 17.0005
R298 VDD.n249 VDD.t346 17.0005
R299 VDD.n412 VDD.n247 17.0005
R300 VDD.n494 VDD.n87 17.0005
R301 VDD.n494 VDD.n84 17.0005
R302 VDD.n494 VDD.n91 17.0005
R303 VDD.n494 VDD.n82 17.0005
R304 VDD.n494 VDD.n95 17.0005
R305 VDD.n494 VDD 17.0005
R306 VDD.n494 VDD.n96 17.0005
R307 VDD.n494 VDD.n80 17.0005
R308 VDD.n494 VDD.n98 17.0005
R309 VDD.n494 VDD.n78 17.0005
R310 VDD.n494 VDD.n104 17.0005
R311 VDD.n494 VDD.n76 17.0005
R312 VDD.n494 VDD.n108 17.0005
R313 VDD.n494 VDD.n74 17.0005
R314 VDD.n494 VDD 17.0005
R315 VDD.n494 VDD.n73 17.0005
R316 VDD.n494 VDD.n111 17.0005
R317 VDD.n494 VDD.n72 17.0005
R318 VDD.n494 VDD.n114 17.0005
R319 VDD.n494 VDD.n67 17.0005
R320 VDD.n494 VDD.n118 17.0005
R321 VDD.n494 VDD.n65 17.0005
R322 VDD.n495 VDD.n494 17.0005
R323 VDD.n494 VDD 17.0005
R324 VDD.n494 VDD.n489 17.0005
R325 VDD.n494 VDD.n62 17.0005
R326 VDD.n494 VDD.n491 17.0005
R327 VDD.n445 VDD.n157 17.0005
R328 VDD.n445 VDD.n156 17.0005
R329 VDD.n445 VDD 17.0005
R330 VDD.n445 VDD.n155 17.0005
R331 VDD.n445 VDD.n160 17.0005
R332 VDD.n445 VDD.n154 17.0005
R333 VDD.n445 VDD 17.0005
R334 VDD.n445 VDD.n153 17.0005
R335 VDD.n445 VDD.n163 17.0005
R336 VDD.n445 VDD.n152 17.0005
R337 VDD.n445 VDD 17.0005
R338 VDD.n445 VDD.n151 17.0005
R339 VDD.n445 VDD.n166 17.0005
R340 VDD.n445 VDD.n150 17.0005
R341 VDD.n445 VDD.n172 17.0005
R342 VDD.n445 VDD 17.0005
R343 VDD.n445 VDD.n173 17.0005
R344 VDD.n445 VDD.n148 17.0005
R345 VDD.n445 VDD.n175 17.0005
R346 VDD.n445 VDD 17.0005
R347 VDD.n445 VDD.n176 17.0005
R348 VDD.n445 VDD.n146 17.0005
R349 VDD.n445 VDD.n178 17.0005
R350 VDD.n445 VDD 17.0005
R351 VDD.n445 VDD.n179 17.0005
R352 VDD.n445 VDD.n144 17.0005
R353 VDD.n445 VDD.n181 17.0005
R354 VDD.n446 VDD.n445 17.0005
R355 VDD.n445 VDD 17.0005
R356 VDD.n445 VDD.n140 17.0005
R357 VDD.n445 VDD.n184 17.0005
R358 VDD.n445 VDD.n139 17.0005
R359 VDD.n445 VDD 17.0005
R360 VDD.n445 VDD.n138 17.0005
R361 VDD.n445 VDD.n188 17.0005
R362 VDD.n445 VDD.n137 17.0005
R363 VDD.n445 VDD 17.0005
R364 VDD.n445 VDD.n136 17.0005
R365 VDD.n445 VDD.n440 17.0005
R366 VDD.n435 VDD.n217 17.0005
R367 VDD.n435 VDD 17.0005
R368 VDD.n435 VDD.n218 17.0005
R369 VDD.n435 VDD.n214 17.0005
R370 VDD.n435 VDD.n220 17.0005
R371 VDD.n435 VDD.n212 17.0005
R372 VDD.n435 VDD.n224 17.0005
R373 VDD.n435 VDD 17.0005
R374 VDD.n435 VDD.n225 17.0005
R375 VDD.n435 VDD.n210 17.0005
R376 VDD.n435 VDD.n227 17.0005
R377 VDD.n435 VDD.n208 17.0005
R378 VDD.n435 VDD 17.0005
R379 VDD.n435 VDD.n207 17.0005
R380 VDD.n435 VDD.n232 17.0005
R381 VDD.n435 VDD.n206 17.0005
R382 VDD.n435 VDD.n236 17.0005
R383 VDD.n435 VDD.n204 17.0005
R384 VDD.n435 VDD 17.0005
R385 VDD.n435 VDD.n203 17.0005
R386 VDD.n435 VDD.n420 17.0005
R387 VDD.n435 VDD.n202 17.0005
R388 VDD.n435 VDD.n423 17.0005
R389 VDD.n435 VDD 17.0005
R390 VDD.n435 VDD.n424 17.0005
R391 VDD.n435 VDD.n197 17.0005
R392 VDD.n435 VDD.n426 17.0005
R393 VDD.n435 VDD.n195 17.0005
R394 VDD.n436 VDD.n435 17.0005
R395 VDD.n435 VDD 17.0005
R396 VDD.n435 VDD.n430 17.0005
R397 VDD.n435 VDD.n192 17.0005
R398 VDD.n435 VDD.n432 17.0005
R399 VDD.n504 VDD.n22 17.0005
R400 VDD.n504 VDD.n21 17.0005
R401 VDD.n504 VDD 17.0005
R402 VDD.n504 VDD.n20 17.0005
R403 VDD.n504 VDD.n25 17.0005
R404 VDD.n504 VDD.n19 17.0005
R405 VDD.n504 VDD 17.0005
R406 VDD.n504 VDD.n18 17.0005
R407 VDD.n504 VDD.n28 17.0005
R408 VDD.n504 VDD.n17 17.0005
R409 VDD.n504 VDD 17.0005
R410 VDD.n504 VDD.n16 17.0005
R411 VDD.n504 VDD.n31 17.0005
R412 VDD.n504 VDD.n15 17.0005
R413 VDD.n504 VDD.n37 17.0005
R414 VDD.n504 VDD 17.0005
R415 VDD.n504 VDD.n38 17.0005
R416 VDD.n504 VDD.n13 17.0005
R417 VDD.n504 VDD.n40 17.0005
R418 VDD.n504 VDD 17.0005
R419 VDD.n504 VDD.n41 17.0005
R420 VDD.n504 VDD.n11 17.0005
R421 VDD.n504 VDD.n43 17.0005
R422 VDD.n504 VDD 17.0005
R423 VDD.n504 VDD.n44 17.0005
R424 VDD.n504 VDD.n9 17.0005
R425 VDD.n504 VDD.n46 17.0005
R426 VDD.n504 VDD.n5 17.0005
R427 VDD.n504 VDD 17.0005
R428 VDD.n504 VDD.n4 17.0005
R429 VDD.n504 VDD.n49 17.0005
R430 VDD.n504 VDD.n3 17.0005
R431 VDD.n504 VDD 17.0005
R432 VDD.n504 VDD.n2 17.0005
R433 VDD.n504 VDD.n52 17.0005
R434 VDD.n504 VDD.n1 17.0005
R435 VDD.n504 VDD 17.0005
R436 VDD.n504 VDD.n0 17.0005
R437 VDD.n504 VDD.n55 17.0005
R438 VDD.n500 VDD.n499 10.0248
R439 VDD.n381 VDD.n380 9.77364
R440 VDD.n342 VDD.n273 9.77364
R441 VDD.n285 VDD.n284 9.44616
R442 VDD.n369 VDD.n301 9.44616
R443 VDD.n386 VDD.n271 9.44616
R444 VDD.n134 VDD.n133 9.44553
R445 VDD.n254 VDD.n253 9.44553
R446 VDD.n317 VDD.n316 9.44553
R447 VDD.n438 VDD.n437 9.4405
R448 VDD.n427 VDD.n121 9.4405
R449 VDD.n419 VDD.n418 9.4405
R450 VDD.n448 VDD.n135 9.4405
R451 VDD.n257 VDD.n255 9.4405
R452 VDD.n347 VDD.n345 9.4405
R453 VDD.n304 VDD.n302 9.4405
R454 VDD.n320 VDD.n318 9.4405
R455 VDD.n393 VDD.n391 9.43987
R456 VDD.n499 VDD.n498 9.00364
R457 VDD.n120 VDD.n119 9.00301
R458 VDD.n380 VDD.n379 9.00301
R459 VDD.n342 VDD.n341 9.00301
R460 VDD.n368 VDD.n367 9.00301
R461 VDD.n388 VDD.n387 9.00301
R462 VDD.n349 VDD.n348 9.0005
R463 VDD.n469 VDD.n60 9.0005
R464 VDD.n450 VDD.n449 9.0005
R465 VDD.n484 VDD.n483 9.0005
R466 VDD.n284 VDD.n59 9.0005
R467 VDD.n259 VDD.n258 9.0005
R468 VDD.n416 VDD.n415 9.0005
R469 VDD.n344 VDD.n343 9.0005
R470 VDD.n254 VDD 9.0005
R471 VDD.n240 VDD.n239 9.0005
R472 VDD.n134 VDD 9.0005
R473 VDD.n486 VDD.n485 9.0005
R474 VDD.n497 VDD.n496 9.0005
R475 VDD.n366 VDD.n365 9.0005
R476 VDD.n370 VDD.n369 9.0005
R477 VDD.n364 VDD.n363 9.0005
R478 VDD.n304 VDD.n303 9.0005
R479 VDD.n347 VDD.n346 9.0005
R480 VDD.n257 VDD.n256 9.0005
R481 VDD.n418 VDD.n417 9.0005
R482 VDD.n448 VDD.n447 9.0005
R483 VDD.n187 VDD.n121 9.0005
R484 VDD.n439 VDD.n438 9.0005
R485 VDD.n393 VDD.n392 9.0005
R486 VDD.n390 VDD.n389 9.0005
R487 VDD.n386 VDD.n385 9.0005
R488 VDD.n395 VDD.n394 9.0005
R489 VDD.n320 VDD.n319 9.0005
R490 VDD.n317 VDD 9.0005
R491 VDD.n322 VDD.n321 9.0005
R492 VDD.n361 VDD.n313 8.47207
R493 VDD.n361 VDD.n328 8.47207
R494 VDD.n361 VDD.n333 8.47207
R495 VDD.n361 VDD.n337 8.47207
R496 VDD.n361 VDD.n350 8.47207
R497 VDD.n361 VDD.n354 8.47207
R498 VDD.n361 VDD.n360 8.47207
R499 VDD.n481 VDD.n130 8.47207
R500 VDD.n481 VDD.n456 8.47207
R501 VDD.n481 VDD.n461 8.47207
R502 VDD.n481 VDD.n465 8.47207
R503 VDD.n481 VDD.n470 8.47207
R504 VDD.n481 VDD.n474 8.47207
R505 VDD.n481 VDD.n480 8.47207
R506 VDD.n291 VDD.n286 8.47207
R507 VDD.n291 VDD.n290 8.47207
R508 VDD.n295 VDD.n281 8.47207
R509 VDD.n295 VDD.n294 8.47207
R510 VDD.n299 VDD.n298 8.47207
R511 VDD.n299 VDD.n278 8.47207
R512 VDD.n412 VDD.n250 8.47207
R513 VDD.n412 VDD.n268 8.47207
R514 VDD.n412 VDD.n401 8.47207
R515 VDD.n413 VDD.n412 8.47207
R516 VDD.n412 VDD.n241 8.47207
R517 VDD.n412 VDD.n405 8.47207
R518 VDD.n412 VDD.n411 8.47207
R519 VDD.n494 VDD.n86 8.47207
R520 VDD.n494 VDD.n89 8.47207
R521 VDD.n494 VDD.n83 8.47207
R522 VDD.n494 VDD.n93 8.47207
R523 VDD.n494 VDD.n81 8.47207
R524 VDD.n494 VDD.n79 8.47207
R525 VDD.n494 VDD.n99 8.47207
R526 VDD.n494 VDD.n102 8.47207
R527 VDD.n494 VDD.n77 8.47207
R528 VDD.n494 VDD.n106 8.47207
R529 VDD.n494 VDD.n75 8.47207
R530 VDD.n494 VDD.n110 8.47207
R531 VDD.n494 VDD.n113 8.47207
R532 VDD.n494 VDD.n71 8.47207
R533 VDD.n494 VDD.n68 8.47207
R534 VDD.n494 VDD.n116 8.47207
R535 VDD.n494 VDD.n66 8.47207
R536 VDD.n494 VDD.n488 8.47207
R537 VDD.n494 VDD.n64 8.47207
R538 VDD.n494 VDD.n61 8.47207
R539 VDD.n494 VDD.n493 8.47207
R540 VDD.n445 VDD.n159 8.47207
R541 VDD.n445 VDD.n162 8.47207
R542 VDD.n445 VDD.n165 8.47207
R543 VDD.n445 VDD.n167 8.47207
R544 VDD.n445 VDD.n170 8.47207
R545 VDD.n445 VDD.n149 8.47207
R546 VDD.n445 VDD.n147 8.47207
R547 VDD.n445 VDD.n145 8.47207
R548 VDD.n445 VDD.n143 8.47207
R549 VDD.n445 VDD.n141 8.47207
R550 VDD.n445 VDD.n183 8.47207
R551 VDD.n445 VDD.n186 8.47207
R552 VDD.n445 VDD.n190 8.47207
R553 VDD.n445 VDD.n441 8.47207
R554 VDD.n445 VDD.n444 8.47207
R555 VDD.n435 VDD.n216 8.47207
R556 VDD.n435 VDD.n213 8.47207
R557 VDD.n435 VDD.n222 8.47207
R558 VDD.n435 VDD.n211 8.47207
R559 VDD.n435 VDD.n209 8.47207
R560 VDD.n435 VDD.n228 8.47207
R561 VDD.n435 VDD.n231 8.47207
R562 VDD.n435 VDD.n234 8.47207
R563 VDD.n435 VDD.n205 8.47207
R564 VDD.n435 VDD.n238 8.47207
R565 VDD.n435 VDD.n422 8.47207
R566 VDD.n435 VDD.n201 8.47207
R567 VDD.n435 VDD.n198 8.47207
R568 VDD.n435 VDD.n196 8.47207
R569 VDD.n435 VDD.n429 8.47207
R570 VDD.n435 VDD.n194 8.47207
R571 VDD.n435 VDD.n191 8.47207
R572 VDD.n435 VDD.n434 8.47207
R573 VDD.n504 VDD.n24 8.47207
R574 VDD.n504 VDD.n27 8.47207
R575 VDD.n504 VDD.n30 8.47207
R576 VDD.n504 VDD.n32 8.47207
R577 VDD.n504 VDD.n35 8.47207
R578 VDD.n504 VDD.n14 8.47207
R579 VDD.n504 VDD.n12 8.47207
R580 VDD.n504 VDD.n10 8.47207
R581 VDD.n504 VDD.n8 8.47207
R582 VDD.n504 VDD.n6 8.47207
R583 VDD.n504 VDD.n48 8.47207
R584 VDD.n504 VDD.n51 8.47207
R585 VDD.n504 VDD.n54 8.47207
R586 VDD.n508 VDD.n504 8.47207
R587 VDD.n506 VDD.n504 8.47207
R588 VDD.n504 VDD.t47 5.66717
R589 VDD.n504 VDD.t30 5.66717
R590 VDD.n504 VDD.t41 5.66717
R591 VDD.n361 VDD.n324 5.61655
R592 VDD.n361 VDD.n329 5.61655
R593 VDD.n481 VDD.n452 5.61655
R594 VDD.n481 VDD.n457 5.61655
R595 VDD.n412 VDD.n261 5.61655
R596 VDD.n412 VDD.n397 5.61655
R597 VDD.n502 VDD.n58 4.25119
R598 VDD.n502 VDD.n56 4.251
R599 VDD.n503 VDD.n502 4.251
R600 VDD.n383 VDD.n377 4.251
R601 VDD.n383 VDD.n376 4.251
R602 VDD.n383 VDD.n375 4.251
R603 VDD.n373 VDD.n277 4.251
R604 VDD.n373 VDD.n275 4.251
R605 VDD.n373 VDD.n274 4.251
R606 VDD.n504 VDD.t60 4.2505
R607 VDD.n504 VDD.t27 4.2505
R608 VDD.n504 VDD.t55 4.2505
R609 VDD.n504 VDD.t38 4.2505
R610 VDD.n383 VDD.n382 4.18701
R611 VDD.n374 VDD.n373 4.18701
R612 VDD.n502 VDD.n501 3.40124
R613 VDD.n383 VDD.n378 3.40124
R614 VDD.n373 VDD.n372 3.40124
R615 VDD.n504 VDD.t192 3.4005
R616 VDD.n504 VDD.t46 3.4005
R617 VDD.n504 VDD.t149 3.4005
R618 VDD.n291 VDD.t56 2.83383
R619 VDD.n295 VDD.t43 2.83383
R620 VDD.n299 VDD.t48 2.83383
R621 VDD.n504 VDD.t36 2.83383
R622 VDD.n502 VDD.n57 2.73623
R623 VDD.n384 VDD.n383 2.73623
R624 VDD.n373 VDD.n276 2.73623
R625 VDD.n383 VDD.n272 2.31532
R626 VDD.n373 VDD.n371 2.31532
R627 VDD.n504 VDD.t61 1.54595
R628 VDD.n382 VDD 1.42902
R629 VDD VDD.n374 1.42902
R630 VDD.n502 VDD.n500 1.42382
R631 VDD.n504 VDD.t25 1.41717
R632 VDD.n361 VDD.t169 0.810024
R633 VDD.n481 VDD.t108 0.810024
R634 VDD.n412 VDD.t129 0.810024
R635 VDD.n284 VDD.n120 0.773643
R636 VDD.n369 VDD.n368 0.773643
R637 VDD.n388 VDD.n386 0.773643
R638 VDD.n438 VDD.n60 0.744729
R639 VDD.n449 VDD.n448 0.744729
R640 VDD.n484 VDD.n121 0.744729
R641 VDD.n258 VDD.n257 0.744729
R642 VDD.n418 VDD.n416 0.744729
R643 VDD.n348 VDD.n347 0.744729
R644 VDD.n364 VDD.n304 0.744729
R645 VDD.n394 VDD.n393 0.744729
R646 VDD.n321 VDD.n320 0.744729
R647 VDD.n500 VDD.n59 0.501764
R648 VDD.n497 VDD.n60 0.466271
R649 VDD.n449 VDD.n134 0.466271
R650 VDD.n485 VDD.n484 0.466271
R651 VDD.n258 VDD.n254 0.466271
R652 VDD.n416 VDD.n240 0.466271
R653 VDD.n348 VDD.n344 0.466271
R654 VDD.n366 VDD.n364 0.466271
R655 VDD.n394 VDD.n390 0.466271
R656 VDD.n321 VDD.n317 0.466271
R657 VDD.n499 VDD.n497 0.443014
R658 VDD.n485 VDD.n120 0.443014
R659 VDD.n380 VDD.n240 0.443014
R660 VDD.n344 VDD.n342 0.443014
R661 VDD.n368 VDD.n366 0.443014
R662 VDD.n390 VDD.n388 0.443014
R663 VDD.n381 VDD.n272 0.408224
R664 VDD.n371 VDD.n273 0.408224
R665 VDD.n360 VDD.n359 0.375108
R666 VDD.n313 VDD.n312 0.375108
R667 VDD.n480 VDD.n479 0.375108
R668 VDD.n130 VDD.n129 0.375108
R669 VDD.n411 VDD.n410 0.375108
R670 VDD.n250 VDD.n249 0.375108
R671 VDD.n385 VDD.n272 0.367679
R672 VDD.n371 VDD.n370 0.367679
R673 VDD VDD.n57 0.351811
R674 VDD.n384 VDD 0.351811
R675 VDD.n276 VDD 0.351811
R676 VDD.n359 VDD.n358 0.351125
R677 VDD.n356 VDD.n355 0.351125
R678 VDD.n352 VDD.n351 0.351125
R679 VDD.n339 VDD.n338 0.351125
R680 VDD.n335 VDD.n334 0.351125
R681 VDD.n331 VDD.n330 0.351125
R682 VDD.n306 VDD.n305 0.351125
R683 VDD.n309 VDD.n308 0.351125
R684 VDD.n326 VDD.n325 0.351125
R685 VDD.n315 VDD.n314 0.351125
R686 VDD.n312 VDD.n311 0.351125
R687 VDD.n479 VDD.n478 0.351125
R688 VDD.n476 VDD.n475 0.351125
R689 VDD.n472 VDD.n471 0.351125
R690 VDD.n467 VDD.n466 0.351125
R691 VDD.n463 VDD.n462 0.351125
R692 VDD.n459 VDD.n458 0.351125
R693 VDD.n123 VDD.n122 0.351125
R694 VDD.n126 VDD.n125 0.351125
R695 VDD.n454 VDD.n453 0.351125
R696 VDD.n132 VDD.n131 0.351125
R697 VDD.n129 VDD.n128 0.351125
R698 VDD.n410 VDD.n409 0.351125
R699 VDD.n407 VDD.n406 0.351125
R700 VDD.n403 VDD.n402 0.351125
R701 VDD.n243 VDD.n242 0.351125
R702 VDD.n245 VDD.n244 0.351125
R703 VDD.n399 VDD.n398 0.351125
R704 VDD.n270 VDD.n269 0.351125
R705 VDD.n266 VDD.n265 0.351125
R706 VDD.n263 VDD.n262 0.351125
R707 VDD.n252 VDD.n251 0.351125
R708 VDD.n249 VDD.n248 0.351125
R709 VDD.n357 VDD.n356 0.31675
R710 VDD.n353 VDD.n352 0.31675
R711 VDD.n340 VDD.n339 0.31675
R712 VDD.n336 VDD.n335 0.31675
R713 VDD.n332 VDD.n331 0.31675
R714 VDD.n307 VDD.n306 0.31675
R715 VDD.n310 VDD.n309 0.31675
R716 VDD.n327 VDD.n326 0.31675
R717 VDD.n323 VDD.n315 0.31675
R718 VDD.n477 VDD.n476 0.31675
R719 VDD.n473 VDD.n472 0.31675
R720 VDD.n468 VDD.n467 0.31675
R721 VDD.n464 VDD.n463 0.31675
R722 VDD.n460 VDD.n459 0.31675
R723 VDD.n124 VDD.n123 0.31675
R724 VDD.n127 VDD.n126 0.31675
R725 VDD.n455 VDD.n454 0.31675
R726 VDD.n451 VDD.n132 0.31675
R727 VDD.n408 VDD.n407 0.31675
R728 VDD.n404 VDD.n403 0.31675
R729 VDD.n414 VDD.n243 0.31675
R730 VDD.n246 VDD.n245 0.31675
R731 VDD.n400 VDD.n399 0.31675
R732 VDD.n396 VDD.n270 0.31675
R733 VDD.n267 VDD.n266 0.31675
R734 VDD.n264 VDD.n263 0.31675
R735 VDD.n260 VDD.n252 0.31675
R736 VDD.n59 VDD.n57 0.300181
R737 VDD.n385 VDD.n384 0.300181
R738 VDD.n370 VDD.n276 0.300181
R739 VDD.n494 VDD.t33 0.246877
R740 VDD.n445 VDD.t0 0.246877
R741 VDD.n435 VDD.t23 0.246877
R742 VDD.n360 VDD.n357 0.174969
R743 VDD.n354 VDD.n353 0.174969
R744 VDD.n337 VDD.n336 0.174969
R745 VDD.n333 VDD.n332 0.174969
R746 VDD.n328 VDD.n327 0.174969
R747 VDD.n480 VDD.n477 0.174969
R748 VDD.n474 VDD.n473 0.174969
R749 VDD.n465 VDD.n464 0.174969
R750 VDD.n461 VDD.n460 0.174969
R751 VDD.n456 VDD.n455 0.174969
R752 VDD.n411 VDD.n408 0.174969
R753 VDD.n405 VDD.n404 0.174969
R754 VDD.n413 VDD.n246 0.174969
R755 VDD.n401 VDD.n400 0.174969
R756 VDD.n268 VDD.n264 0.174969
R757 VDD.n382 VDD.n381 0.157653
R758 VDD.n374 VDD.n273 0.157653
R759 VDD VDD.n68 0.152562
R760 VDD.n102 VDD 0.152562
R761 VDD VDD.n86 0.152562
R762 VDD.n444 VDD 0.152562
R763 VDD VDD.n141 0.152562
R764 VDD.n170 VDD 0.152562
R765 VDD VDD.n198 0.152562
R766 VDD.n231 VDD 0.152562
R767 VDD VDD.n216 0.152562
R768 VDD VDD.n506 0.152562
R769 VDD VDD.n6 0.152562
R770 VDD.n35 VDD 0.152562
R771 VDD.n350 VDD.n349 0.120988
R772 VDD.n470 VDD.n469 0.120988
R773 VDD.n415 VDD.n241 0.120988
R774 VDD.n324 VDD.n323 0.11699
R775 VDD.n329 VDD.n307 0.11699
R776 VDD.n452 VDD.n451 0.11699
R777 VDD.n457 VDD.n124 0.11699
R778 VDD.n261 VDD.n260 0.11699
R779 VDD.n397 VDD.n396 0.11699
R780 VDD.n332 VDD.n329 0.11665
R781 VDD.n327 VDD.n324 0.11665
R782 VDD.n460 VDD.n457 0.11665
R783 VDD.n455 VDD.n452 0.11665
R784 VDD.n400 VDD.n397 0.11665
R785 VDD.n264 VDD.n261 0.11665
R786 VDD.n362 VDD.n310 0.116611
R787 VDD.n482 VDD.n127 0.116611
R788 VDD.n267 VDD.n247 0.116611
R789 VDD VDD.n136 0.109481
R790 VDD VDD.n138 0.109481
R791 VDD.n140 VDD 0.109481
R792 VDD.n179 VDD 0.109481
R793 VDD.n176 VDD 0.109481
R794 VDD.n173 VDD 0.109481
R795 VDD VDD.n151 0.109481
R796 VDD VDD.n153 0.109481
R797 VDD VDD.n155 0.109481
R798 VDD VDD.n0 0.109481
R799 VDD VDD.n2 0.109481
R800 VDD VDD.n4 0.109481
R801 VDD.n44 VDD 0.109481
R802 VDD.n41 VDD 0.109481
R803 VDD.n38 VDD 0.109481
R804 VDD VDD.n16 0.109481
R805 VDD VDD.n18 0.109481
R806 VDD VDD.n20 0.109481
R807 VDD.n322 VDD.n313 0.107747
R808 VDD.n450 VDD.n130 0.107747
R809 VDD.n259 VDD.n250 0.107747
R810 VDD.n424 VDD.n135 0.0992963
R811 VDD.n255 VDD.n207 0.0992963
R812 VDD.n318 VDD.n218 0.0992963
R813 VDD.n363 VDD.n362 0.080963
R814 VDD.n483 VDD.n482 0.080963
R815 VDD.n395 VDD.n247 0.080963
R816 VDD.n498 VDD 0.0687407
R817 VDD.n119 VDD 0.0687407
R818 VDD.n379 VDD 0.0687407
R819 VDD.n387 VDD 0.0687407
R820 VDD.n341 VDD 0.0687407
R821 VDD.n367 VDD 0.0687407
R822 VDD.n323 VDD.n322 0.0677222
R823 VDD.n451 VDD.n450 0.0677222
R824 VDD.n260 VDD.n259 0.0677222
R825 VDD.n133 VDD 0.0636481
R826 VDD.n253 VDD 0.0636481
R827 VDD.n316 VDD 0.0636481
R828 VDD.n357 VDD.n354 0.058858
R829 VDD.n353 VDD.n350 0.058858
R830 VDD.n340 VDD.n337 0.058858
R831 VDD.n336 VDD.n333 0.058858
R832 VDD.n328 VDD.n310 0.058858
R833 VDD.n477 VDD.n474 0.058858
R834 VDD.n473 VDD.n470 0.058858
R835 VDD.n468 VDD.n465 0.058858
R836 VDD.n464 VDD.n461 0.058858
R837 VDD.n456 VDD.n127 0.058858
R838 VDD.n290 VDD.n289 0.058858
R839 VDD.n287 VDD.n286 0.058858
R840 VDD.n294 VDD.n293 0.058858
R841 VDD.n282 VDD.n281 0.058858
R842 VDD.n298 VDD.n297 0.058858
R843 VDD.n278 VDD 0.058858
R844 VDD.n286 VDD 0.058858
R845 VDD.n290 VDD 0.058858
R846 VDD.n281 VDD 0.058858
R847 VDD.n294 VDD 0.058858
R848 VDD.n298 VDD 0.058858
R849 VDD.n279 VDD.n278 0.058858
R850 VDD.n408 VDD.n405 0.058858
R851 VDD.n404 VDD.n241 0.058858
R852 VDD.n414 VDD.n413 0.058858
R853 VDD.n401 VDD.n246 0.058858
R854 VDD.n268 VDD.n267 0.058858
R855 VDD.n493 VDD.n492 0.058858
R856 VDD.n490 VDD.n61 0.058858
R857 VDD.n64 VDD.n63 0.058858
R858 VDD.n488 VDD.n487 0.058858
R859 VDD.n117 VDD.n66 0.058858
R860 VDD.n116 VDD.n115 0.058858
R861 VDD.n71 VDD.n70 0.058858
R862 VDD.n113 VDD.n112 0.058858
R863 VDD.n110 VDD.n109 0.058858
R864 VDD.n107 VDD.n75 0.058858
R865 VDD.n106 VDD.n105 0.058858
R866 VDD.n103 VDD.n77 0.058858
R867 VDD.n100 VDD.n99 0.058858
R868 VDD.n97 VDD.n79 0.058858
R869 VDD.n94 VDD.n81 0.058858
R870 VDD.n93 VDD.n92 0.058858
R871 VDD.n90 VDD.n83 0.058858
R872 VDD.n89 VDD.n88 0.058858
R873 VDD.n86 VDD.n85 0.058858
R874 VDD VDD.n89 0.058858
R875 VDD VDD.n83 0.058858
R876 VDD VDD.n93 0.058858
R877 VDD VDD.n81 0.058858
R878 VDD VDD.n79 0.058858
R879 VDD.n99 VDD 0.058858
R880 VDD.n102 VDD.n101 0.058858
R881 VDD VDD.n77 0.058858
R882 VDD.n106 VDD 0.058858
R883 VDD VDD.n75 0.058858
R884 VDD.n110 VDD 0.058858
R885 VDD.n113 VDD 0.058858
R886 VDD VDD.n71 0.058858
R887 VDD.n69 VDD.n68 0.058858
R888 VDD VDD.n116 0.058858
R889 VDD VDD.n66 0.058858
R890 VDD.n488 VDD 0.058858
R891 VDD VDD.n64 0.058858
R892 VDD VDD.n61 0.058858
R893 VDD.n493 VDD 0.058858
R894 VDD.n444 VDD.n443 0.058858
R895 VDD.n442 VDD.n441 0.058858
R896 VDD.n190 VDD.n189 0.058858
R897 VDD.n186 VDD.n185 0.058858
R898 VDD.n183 VDD.n182 0.058858
R899 VDD.n180 VDD.n141 0.058858
R900 VDD.n143 VDD.n142 0.058858
R901 VDD.n177 VDD.n145 0.058858
R902 VDD.n174 VDD.n147 0.058858
R903 VDD.n171 VDD.n149 0.058858
R904 VDD.n170 VDD.n169 0.058858
R905 VDD.n168 VDD.n167 0.058858
R906 VDD.n165 VDD.n164 0.058858
R907 VDD.n162 VDD.n161 0.058858
R908 VDD.n159 VDD.n158 0.058858
R909 VDD.n159 VDD 0.058858
R910 VDD.n162 VDD 0.058858
R911 VDD.n165 VDD 0.058858
R912 VDD.n167 VDD 0.058858
R913 VDD VDD.n149 0.058858
R914 VDD VDD.n147 0.058858
R915 VDD VDD.n145 0.058858
R916 VDD VDD.n143 0.058858
R917 VDD.n183 VDD 0.058858
R918 VDD.n186 VDD 0.058858
R919 VDD.n190 VDD 0.058858
R920 VDD.n441 VDD 0.058858
R921 VDD.n434 VDD.n433 0.058858
R922 VDD.n431 VDD.n191 0.058858
R923 VDD.n194 VDD.n193 0.058858
R924 VDD.n429 VDD.n428 0.058858
R925 VDD.n425 VDD.n196 0.058858
R926 VDD.n201 VDD.n200 0.058858
R927 VDD.n422 VDD.n421 0.058858
R928 VDD.n238 VDD.n237 0.058858
R929 VDD.n235 VDD.n205 0.058858
R930 VDD.n234 VDD.n233 0.058858
R931 VDD.n229 VDD.n228 0.058858
R932 VDD.n226 VDD.n209 0.058858
R933 VDD.n223 VDD.n211 0.058858
R934 VDD.n222 VDD.n221 0.058858
R935 VDD.n219 VDD.n213 0.058858
R936 VDD.n216 VDD.n215 0.058858
R937 VDD VDD.n213 0.058858
R938 VDD VDD.n222 0.058858
R939 VDD VDD.n211 0.058858
R940 VDD VDD.n209 0.058858
R941 VDD.n228 VDD 0.058858
R942 VDD.n231 VDD.n230 0.058858
R943 VDD.n234 VDD 0.058858
R944 VDD VDD.n205 0.058858
R945 VDD.n238 VDD 0.058858
R946 VDD.n422 VDD 0.058858
R947 VDD VDD.n201 0.058858
R948 VDD.n199 VDD.n198 0.058858
R949 VDD VDD.n196 0.058858
R950 VDD.n429 VDD 0.058858
R951 VDD VDD.n194 0.058858
R952 VDD VDD.n191 0.058858
R953 VDD.n434 VDD 0.058858
R954 VDD.n506 VDD.n505 0.058858
R955 VDD.n508 VDD.n507 0.058858
R956 VDD.n54 VDD.n53 0.058858
R957 VDD.n51 VDD.n50 0.058858
R958 VDD.n48 VDD.n47 0.058858
R959 VDD.n45 VDD.n6 0.058858
R960 VDD.n8 VDD.n7 0.058858
R961 VDD.n42 VDD.n10 0.058858
R962 VDD.n39 VDD.n12 0.058858
R963 VDD.n36 VDD.n14 0.058858
R964 VDD.n35 VDD.n34 0.058858
R965 VDD.n33 VDD.n32 0.058858
R966 VDD.n30 VDD.n29 0.058858
R967 VDD.n27 VDD.n26 0.058858
R968 VDD.n24 VDD.n23 0.058858
R969 VDD.n24 VDD 0.058858
R970 VDD.n27 VDD 0.058858
R971 VDD.n30 VDD 0.058858
R972 VDD.n32 VDD 0.058858
R973 VDD VDD.n14 0.058858
R974 VDD VDD.n12 0.058858
R975 VDD VDD.n10 0.058858
R976 VDD VDD.n8 0.058858
R977 VDD.n48 VDD 0.058858
R978 VDD.n51 VDD 0.058858
R979 VDD.n54 VDD 0.058858
R980 VDD VDD.n508 0.058858
R981 VDD VDD.n285 0.0585556
R982 VDD VDD.n271 0.0585556
R983 VDD.n301 VDD 0.0585556
R984 VDD.n489 VDD 0.0585556
R985 VDD.n496 VDD 0.0585556
R986 VDD VDD.n486 0.0585556
R987 VDD VDD.n73 0.0585556
R988 VDD.n239 VDD 0.0585556
R989 VDD.n389 VDD 0.0585556
R990 VDD.n96 VDD 0.0585556
R991 VDD.n343 VDD 0.0585556
R992 VDD.n365 VDD 0.0585556
R993 VDD.n430 VDD 0.0585556
R994 VDD VDD.n203 0.0585556
R995 VDD.n225 VDD 0.0585556
R996 VDD.n349 VDD.n340 0.0544815
R997 VDD.n469 VDD.n468 0.0544815
R998 VDD.n415 VDD.n414 0.0544815
R999 VDD.n437 VDD 0.053463
R1000 VDD.n427 VDD 0.053463
R1001 VDD.n419 VDD 0.053463
R1002 VDD.n391 VDD 0.053463
R1003 VDD.n345 VDD 0.053463
R1004 VDD.n302 VDD 0.053463
R1005 VDD VDD.n439 0.0514259
R1006 VDD VDD.n187 0.0514259
R1007 VDD.n417 VDD 0.0514259
R1008 VDD.n392 VDD 0.0514259
R1009 VDD.n346 VDD 0.0514259
R1010 VDD.n303 VDD 0.0514259
R1011 VDD.n447 VDD 0.0483704
R1012 VDD.n256 VDD 0.0483704
R1013 VDD.n319 VDD 0.0483704
R1014 VDD.n447 VDD 0.0463333
R1015 VDD.n256 VDD 0.0463333
R1016 VDD.n319 VDD 0.0463333
R1017 VDD.n439 VDD 0.0432778
R1018 VDD.n187 VDD 0.0432778
R1019 VDD.n417 VDD 0.0432778
R1020 VDD.n392 VDD 0.0432778
R1021 VDD.n346 VDD 0.0432778
R1022 VDD.n303 VDD 0.0432778
R1023 VDD.n437 VDD 0.0412407
R1024 VDD VDD.n427 0.0412407
R1025 VDD VDD.n419 0.0412407
R1026 VDD.n391 VDD 0.0412407
R1027 VDD.n345 VDD 0.0412407
R1028 VDD.n302 VDD 0.0412407
R1029 VDD.n363 VDD.n307 0.0361481
R1030 VDD.n483 VDD.n124 0.0361481
R1031 VDD.n285 VDD 0.0361481
R1032 VDD VDD.n271 0.0361481
R1033 VDD.n301 VDD 0.0361481
R1034 VDD.n396 VDD.n395 0.0361481
R1035 VDD.n496 VDD 0.0361481
R1036 VDD.n486 VDD 0.0361481
R1037 VDD.n239 VDD 0.0361481
R1038 VDD.n389 VDD 0.0361481
R1039 VDD.n343 VDD 0.0361481
R1040 VDD.n365 VDD 0.0361481
R1041 VDD.n133 VDD 0.0310556
R1042 VDD.n253 VDD 0.0310556
R1043 VDD.n316 VDD 0.0310556
R1044 VDD.n498 VDD 0.025963
R1045 VDD.n119 VDD 0.025963
R1046 VDD.n379 VDD 0.025963
R1047 VDD.n387 VDD 0.025963
R1048 VDD.n341 VDD 0.025963
R1049 VDD.n367 VDD 0.025963
R1050 VDD VDD.n288 0.0229074
R1051 VDD.n292 VDD 0.0229074
R1052 VDD VDD.n283 0.0229074
R1053 VDD.n296 VDD 0.0229074
R1054 VDD VDD.n280 0.0229074
R1055 VDD VDD.n300 0.0229074
R1056 VDD VDD.n491 0.0229074
R1057 VDD.n62 VDD 0.0229074
R1058 VDD VDD.n495 0.0229074
R1059 VDD.n65 VDD 0.0229074
R1060 VDD VDD.n118 0.0229074
R1061 VDD.n67 VDD 0.0229074
R1062 VDD VDD.n114 0.0229074
R1063 VDD.n72 VDD 0.0229074
R1064 VDD VDD.n111 0.0229074
R1065 VDD VDD.n74 0.0229074
R1066 VDD VDD.n108 0.0229074
R1067 VDD VDD.n76 0.0229074
R1068 VDD VDD.n104 0.0229074
R1069 VDD VDD.n78 0.0229074
R1070 VDD VDD.n98 0.0229074
R1071 VDD.n80 VDD 0.0229074
R1072 VDD VDD.n95 0.0229074
R1073 VDD.n82 VDD 0.0229074
R1074 VDD VDD.n91 0.0229074
R1075 VDD.n84 VDD 0.0229074
R1076 VDD VDD.n87 0.0229074
R1077 VDD VDD.n440 0.0229074
R1078 VDD VDD.n137 0.0229074
R1079 VDD VDD.n188 0.0229074
R1080 VDD VDD.n139 0.0229074
R1081 VDD VDD.n184 0.0229074
R1082 VDD VDD.n446 0.0229074
R1083 VDD VDD.n181 0.0229074
R1084 VDD.n144 VDD 0.0229074
R1085 VDD VDD.n178 0.0229074
R1086 VDD.n146 VDD 0.0229074
R1087 VDD VDD.n175 0.0229074
R1088 VDD.n148 VDD 0.0229074
R1089 VDD VDD.n172 0.0229074
R1090 VDD.n150 VDD 0.0229074
R1091 VDD VDD.n166 0.0229074
R1092 VDD VDD.n152 0.0229074
R1093 VDD VDD.n163 0.0229074
R1094 VDD VDD.n154 0.0229074
R1095 VDD VDD.n160 0.0229074
R1096 VDD VDD.n156 0.0229074
R1097 VDD VDD.n157 0.0229074
R1098 VDD VDD.n432 0.0229074
R1099 VDD.n192 VDD 0.0229074
R1100 VDD VDD.n436 0.0229074
R1101 VDD.n195 VDD 0.0229074
R1102 VDD VDD.n426 0.0229074
R1103 VDD.n197 VDD 0.0229074
R1104 VDD.n423 VDD 0.0229074
R1105 VDD.n202 VDD 0.0229074
R1106 VDD VDD.n420 0.0229074
R1107 VDD VDD.n204 0.0229074
R1108 VDD VDD.n236 0.0229074
R1109 VDD VDD.n206 0.0229074
R1110 VDD VDD.n232 0.0229074
R1111 VDD VDD.n208 0.0229074
R1112 VDD VDD.n227 0.0229074
R1113 VDD.n210 VDD 0.0229074
R1114 VDD VDD.n224 0.0229074
R1115 VDD.n212 VDD 0.0229074
R1116 VDD VDD.n220 0.0229074
R1117 VDD.n214 VDD 0.0229074
R1118 VDD.n217 VDD 0.0229074
R1119 VDD.n55 VDD 0.0229074
R1120 VDD VDD.n1 0.0229074
R1121 VDD VDD.n52 0.0229074
R1122 VDD VDD.n3 0.0229074
R1123 VDD VDD.n49 0.0229074
R1124 VDD VDD.n5 0.0229074
R1125 VDD VDD.n46 0.0229074
R1126 VDD.n9 VDD 0.0229074
R1127 VDD VDD.n43 0.0229074
R1128 VDD.n11 VDD 0.0229074
R1129 VDD VDD.n40 0.0229074
R1130 VDD.n13 VDD 0.0229074
R1131 VDD VDD.n37 0.0229074
R1132 VDD.n15 VDD 0.0229074
R1133 VDD VDD.n31 0.0229074
R1134 VDD VDD.n17 0.0229074
R1135 VDD VDD.n28 0.0229074
R1136 VDD VDD.n19 0.0229074
R1137 VDD VDD.n25 0.0229074
R1138 VDD VDD.n21 0.0229074
R1139 VDD VDD.n22 0.0229074
R1140 VDD VDD.n135 0.0178148
R1141 VDD.n255 VDD 0.0178148
R1142 VDD.n318 VDD 0.0178148
R1143 VDD.n289 VDD 0.00559259
R1144 VDD.n288 VDD 0.00559259
R1145 VDD VDD.n287 0.00559259
R1146 VDD VDD.n292 0.00559259
R1147 VDD.n293 VDD 0.00559259
R1148 VDD.n283 VDD 0.00559259
R1149 VDD VDD.n282 0.00559259
R1150 VDD VDD.n296 0.00559259
R1151 VDD.n297 VDD 0.00559259
R1152 VDD.n280 VDD 0.00559259
R1153 VDD VDD.n279 0.00559259
R1154 VDD.n300 VDD 0.00559259
R1155 VDD.n492 VDD 0.00559259
R1156 VDD.n491 VDD 0.00559259
R1157 VDD VDD.n490 0.00559259
R1158 VDD VDD.n62 0.00559259
R1159 VDD.n489 VDD 0.00559259
R1160 VDD.n495 VDD 0.00559259
R1161 VDD.n63 VDD 0.00559259
R1162 VDD VDD.n65 0.00559259
R1163 VDD.n487 VDD 0.00559259
R1164 VDD.n118 VDD 0.00559259
R1165 VDD VDD.n117 0.00559259
R1166 VDD VDD.n67 0.00559259
R1167 VDD.n115 VDD 0.00559259
R1168 VDD.n114 VDD 0.00559259
R1169 VDD.n70 VDD 0.00559259
R1170 VDD VDD.n72 0.00559259
R1171 VDD.n112 VDD 0.00559259
R1172 VDD.n111 VDD 0.00559259
R1173 VDD VDD.n73 0.00559259
R1174 VDD VDD.n74 0.00559259
R1175 VDD.n109 VDD 0.00559259
R1176 VDD.n108 VDD 0.00559259
R1177 VDD VDD.n107 0.00559259
R1178 VDD VDD.n76 0.00559259
R1179 VDD.n105 VDD 0.00559259
R1180 VDD.n104 VDD 0.00559259
R1181 VDD VDD.n103 0.00559259
R1182 VDD VDD.n78 0.00559259
R1183 VDD VDD.n100 0.00559259
R1184 VDD.n98 VDD 0.00559259
R1185 VDD VDD.n97 0.00559259
R1186 VDD VDD.n80 0.00559259
R1187 VDD.n96 VDD 0.00559259
R1188 VDD.n95 VDD 0.00559259
R1189 VDD VDD.n94 0.00559259
R1190 VDD VDD.n82 0.00559259
R1191 VDD.n92 VDD 0.00559259
R1192 VDD.n91 VDD 0.00559259
R1193 VDD VDD.n90 0.00559259
R1194 VDD VDD.n84 0.00559259
R1195 VDD.n88 VDD 0.00559259
R1196 VDD.n87 VDD 0.00559259
R1197 VDD VDD.n442 0.00559259
R1198 VDD.n440 VDD 0.00559259
R1199 VDD VDD.n136 0.00559259
R1200 VDD VDD.n137 0.00559259
R1201 VDD.n189 VDD 0.00559259
R1202 VDD.n188 VDD 0.00559259
R1203 VDD VDD.n138 0.00559259
R1204 VDD VDD.n139 0.00559259
R1205 VDD.n185 VDD 0.00559259
R1206 VDD.n184 VDD 0.00559259
R1207 VDD VDD.n140 0.00559259
R1208 VDD.n446 VDD 0.00559259
R1209 VDD.n182 VDD 0.00559259
R1210 VDD.n181 VDD 0.00559259
R1211 VDD.n142 VDD 0.00559259
R1212 VDD VDD.n144 0.00559259
R1213 VDD.n179 VDD 0.00559259
R1214 VDD.n178 VDD 0.00559259
R1215 VDD VDD.n177 0.00559259
R1216 VDD VDD.n146 0.00559259
R1217 VDD.n176 VDD 0.00559259
R1218 VDD.n175 VDD 0.00559259
R1219 VDD VDD.n174 0.00559259
R1220 VDD VDD.n148 0.00559259
R1221 VDD.n173 VDD 0.00559259
R1222 VDD.n172 VDD 0.00559259
R1223 VDD VDD.n171 0.00559259
R1224 VDD VDD.n150 0.00559259
R1225 VDD VDD.n168 0.00559259
R1226 VDD.n166 VDD 0.00559259
R1227 VDD VDD.n151 0.00559259
R1228 VDD VDD.n152 0.00559259
R1229 VDD.n164 VDD 0.00559259
R1230 VDD.n163 VDD 0.00559259
R1231 VDD VDD.n153 0.00559259
R1232 VDD VDD.n154 0.00559259
R1233 VDD.n161 VDD 0.00559259
R1234 VDD.n160 VDD 0.00559259
R1235 VDD VDD.n155 0.00559259
R1236 VDD VDD.n156 0.00559259
R1237 VDD.n158 VDD 0.00559259
R1238 VDD.n157 VDD 0.00559259
R1239 VDD.n433 VDD 0.00559259
R1240 VDD.n432 VDD 0.00559259
R1241 VDD VDD.n431 0.00559259
R1242 VDD VDD.n192 0.00559259
R1243 VDD.n430 VDD 0.00559259
R1244 VDD.n436 VDD 0.00559259
R1245 VDD.n193 VDD 0.00559259
R1246 VDD VDD.n195 0.00559259
R1247 VDD.n428 VDD 0.00559259
R1248 VDD.n426 VDD 0.00559259
R1249 VDD VDD.n425 0.00559259
R1250 VDD VDD.n197 0.00559259
R1251 VDD.n424 VDD 0.00559259
R1252 VDD.n423 VDD 0.00559259
R1253 VDD.n200 VDD 0.00559259
R1254 VDD VDD.n202 0.00559259
R1255 VDD.n421 VDD 0.00559259
R1256 VDD.n420 VDD 0.00559259
R1257 VDD VDD.n203 0.00559259
R1258 VDD VDD.n204 0.00559259
R1259 VDD.n237 VDD 0.00559259
R1260 VDD.n236 VDD 0.00559259
R1261 VDD VDD.n235 0.00559259
R1262 VDD VDD.n206 0.00559259
R1263 VDD.n233 VDD 0.00559259
R1264 VDD.n232 VDD 0.00559259
R1265 VDD VDD.n207 0.00559259
R1266 VDD VDD.n208 0.00559259
R1267 VDD VDD.n229 0.00559259
R1268 VDD.n227 VDD 0.00559259
R1269 VDD VDD.n226 0.00559259
R1270 VDD VDD.n210 0.00559259
R1271 VDD.n225 VDD 0.00559259
R1272 VDD.n224 VDD 0.00559259
R1273 VDD VDD.n223 0.00559259
R1274 VDD VDD.n212 0.00559259
R1275 VDD.n221 VDD 0.00559259
R1276 VDD.n220 VDD 0.00559259
R1277 VDD VDD.n219 0.00559259
R1278 VDD VDD.n214 0.00559259
R1279 VDD.n218 VDD 0.00559259
R1280 VDD.n217 VDD 0.00559259
R1281 VDD.n507 VDD 0.00559259
R1282 VDD.n55 VDD 0.00559259
R1283 VDD VDD.n0 0.00559259
R1284 VDD VDD.n1 0.00559259
R1285 VDD.n53 VDD 0.00559259
R1286 VDD.n52 VDD 0.00559259
R1287 VDD VDD.n2 0.00559259
R1288 VDD VDD.n3 0.00559259
R1289 VDD.n50 VDD 0.00559259
R1290 VDD.n49 VDD 0.00559259
R1291 VDD VDD.n4 0.00559259
R1292 VDD VDD.n5 0.00559259
R1293 VDD.n47 VDD 0.00559259
R1294 VDD.n46 VDD 0.00559259
R1295 VDD.n7 VDD 0.00559259
R1296 VDD VDD.n9 0.00559259
R1297 VDD.n44 VDD 0.00559259
R1298 VDD.n43 VDD 0.00559259
R1299 VDD VDD.n42 0.00559259
R1300 VDD VDD.n11 0.00559259
R1301 VDD.n41 VDD 0.00559259
R1302 VDD.n40 VDD 0.00559259
R1303 VDD VDD.n39 0.00559259
R1304 VDD VDD.n13 0.00559259
R1305 VDD.n38 VDD 0.00559259
R1306 VDD.n37 VDD 0.00559259
R1307 VDD VDD.n36 0.00559259
R1308 VDD VDD.n15 0.00559259
R1309 VDD VDD.n33 0.00559259
R1310 VDD.n31 VDD 0.00559259
R1311 VDD VDD.n16 0.00559259
R1312 VDD VDD.n17 0.00559259
R1313 VDD.n29 VDD 0.00559259
R1314 VDD.n28 VDD 0.00559259
R1315 VDD VDD.n18 0.00559259
R1316 VDD VDD.n19 0.00559259
R1317 VDD.n26 VDD 0.00559259
R1318 VDD.n25 VDD 0.00559259
R1319 VDD VDD.n20 0.00559259
R1320 VDD VDD.n21 0.00559259
R1321 VDD.n23 VDD 0.00559259
R1322 VDD.n22 VDD 0.00559259
R1323 VDD VDD.n69 0.00457407
R1324 VDD.n101 VDD 0.00457407
R1325 VDD.n85 VDD 0.00457407
R1326 VDD.n443 VDD 0.00457407
R1327 VDD VDD.n180 0.00457407
R1328 VDD.n169 VDD 0.00457407
R1329 VDD VDD.n199 0.00457407
R1330 VDD.n230 VDD 0.00457407
R1331 VDD.n215 VDD 0.00457407
R1332 VDD.n505 VDD 0.00457407
R1333 VDD VDD.n45 0.00457407
R1334 VDD.n34 VDD 0.00457407
R1335 VDD.n274 VDD.t60 0.00175
R1336 VDD.n277 VDD.t192 0.00175
R1337 VDD.n375 VDD.t27 0.00175
R1338 VDD.n377 VDD.t61 0.00175
R1339 VDD.n503 VDD.t38 0.00175
R1340 VDD.n58 VDD.t25 0.00162501
R1341 VDD.n501 VDD.t41 0.00160001
R1342 VDD.n378 VDD.t30 0.00160001
R1343 VDD.n372 VDD.t47 0.00160001
R1344 VDD.n372 VDD.t60 0.00139998
R1345 VDD.n378 VDD.t27 0.00139998
R1346 VDD.n501 VDD.t38 0.00139998
R1347 VDD.n58 VDD.t55 0.00137498
R1348 VDD.t36 VDD.n503 0.00124998
R1349 VDD.n377 VDD.t149 0.00124998
R1350 VDD.n375 VDD.t25 0.00124998
R1351 VDD.n277 VDD.t46 0.00124998
R1352 VDD.n274 VDD.t61 0.00124998
R1353 VDD.n275 VDD.t47 0.001
R1354 VDD.n376 VDD.t30 0.001
R1355 VDD.n56 VDD.t41 0.001
R1356 VDD.n56 VDD.t55 0.001
R1357 VDD.n376 VDD.t149 0.001
R1358 VDD.n275 VDD.t46 0.001
R1359 PH4 PH4.t0 17.3649
R1360 PH4.n1 PH4.t8 17.0005
R1361 PH4.n3 PH4.t2 17.0005
R1362 PH4.n4 PH4.t7 17.0005
R1363 PH4.n6 PH4.t4 17.0005
R1364 PH4.n7 PH4.t6 17.0005
R1365 PH4.n9 PH4.t5 17.0005
R1366 PH4.n10 PH4.t9 17.0005
R1367 PH4.n12 PH4.t3 17.0005
R1368 PH4.n21 PH4.t1 17.0005
R1369 PH4.n17 PH4.t12 15.0005
R1370 PH4.n0 PH4.t11 15.0005
R1371 PH4 PH4.t10 15.0005
R1372 PH4.n21 PH4.n19 9.9201
R1373 PH4.n13 PH4.n12 9.91525
R1374 PH4.n15 PH4.n3 9.12325
R1375 PH4.n14 PH4.n6 9.12325
R1376 PH4.n13 PH4.n9 9.12325
R1377 PH4.n16 PH4 9.0005
R1378 PH4.n19 PH4.n0 9.0005
R1379 PH4.n18 PH4.n17 9.0005
R1380 PH4.n16 PH4.n15 3.2455
R1381 PH4.n18 PH4.n16 2.13427
R1382 PH4.n3 PH4 1.19877
R1383 PH4.n6 PH4 1.19877
R1384 PH4.n9 PH4 1.19877
R1385 PH4.n12 PH4 1.19877
R1386 PH4.n15 PH4.n14 0.7925
R1387 PH4.n2 PH4 0.559983
R1388 PH4.n5 PH4 0.559983
R1389 PH4.n8 PH4 0.559983
R1390 PH4.n11 PH4 0.559983
R1391 PH4.n19 PH4.n18 0.4405
R1392 PH4.n14 PH4 0.4273
R1393 PH4 PH4.n13 0.3657
R1394 PH4.n20 PH4 0.3525
R1395 PH4.n2 PH4 0.292688
R1396 PH4.n5 PH4 0.292688
R1397 PH4.n8 PH4 0.292688
R1398 PH4.n11 PH4 0.292688
R1399 PH4 PH4.n1 0.282375
R1400 PH4 PH4.n4 0.282375
R1401 PH4 PH4.n7 0.282375
R1402 PH4 PH4.n10 0.282375
R1403 PH4.n22 PH4 0.210188
R1404 PH4 PH4.n22 0.162063
R1405 PH4.n1 PH4 0.089875
R1406 PH4.n4 PH4 0.089875
R1407 PH4.n7 PH4 0.089875
R1408 PH4.n10 PH4 0.089875
R1409 PH4.n0 PH4 0.0555
R1410 PH4.n3 PH4.n2 0.0403276
R1411 PH4.n6 PH4.n5 0.0403276
R1412 PH4.n9 PH4.n8 0.0403276
R1413 PH4.n12 PH4.n11 0.0403276
R1414 PH4.n22 PH4.n21 0.0403276
R1415 PH4.n21 PH4.n20 0.0403276
R1416 PH4.n17 PH4 0.0151667
R1417 PH4.n0 PH4 0.0115
R1418 PH4.n20 PH4 0.00998276
R1419 CTRL.n206 CTRL.n107 33.5433
R1420 CTRL.n208 CTRL.n207 29.2482
R1421 CTRL.n205 CTRL.n204 29.2482
R1422 CTRL.n195 CTRL.n108 27.5545
R1423 CTRL.n210 CTRL.n105 27.5545
R1424 CTRL.n191 CTRL.n108 27.2511
R1425 CTRL.n203 CTRL.n202 27.2511
R1426 CTRL.n209 CTRL.n32 27.2511
R1427 CTRL.n211 CTRL.n210 27.2511
R1428 CTRL.n208 CTRL.n206 15.5433
R1429 CTRL.n207 CTRL.t26 15.0005
R1430 CTRL.n106 CTRL.t25 15.0005
R1431 CTRL.n204 CTRL.t24 15.0005
R1432 CTRL.n107 CTRL.n106 11.2482
R1433 CTRL.n206 CTRL.n205 9.0005
R1434 CTRL.n198 CTRL.t13 8.44127
R1435 CTRL.t20 CTRL.n51 8.44127
R1436 CTRL.t0 CTRL.n17 6.49307
R1437 CTRL.t0 CTRL.n10 6.49272
R1438 CTRL.t0 CTRL.n11 6.49272
R1439 CTRL.t0 CTRL.n12 6.49272
R1440 CTRL.t0 CTRL.n13 6.49272
R1441 CTRL.t0 CTRL.n14 6.49272
R1442 CTRL.t0 CTRL.n216 6.49272
R1443 CTRL.n153 CTRL.t15 6.49272
R1444 CTRL.t8 CTRL.n200 6.49272
R1445 CTRL.t22 CTRL.n52 6.49272
R1446 CTRL.t0 CTRL.n19 6.49172
R1447 CTRL.t0 CTRL.n21 6.49172
R1448 CTRL.t0 CTRL.n23 6.49172
R1449 CTRL.t0 CTRL.n25 6.49172
R1450 CTRL.t0 CTRL.n27 6.49172
R1451 CTRL.t0 CTRL.n29 6.49172
R1452 CTRL.t0 CTRL.n31 6.49172
R1453 CTRL.t8 CTRL.n111 6.49172
R1454 CTRL.t8 CTRL.n112 6.49172
R1455 CTRL.t8 CTRL.n113 6.49172
R1456 CTRL.t8 CTRL.n114 6.49172
R1457 CTRL.t8 CTRL.n115 6.49172
R1458 CTRL.t8 CTRL.n116 6.49172
R1459 CTRL.t8 CTRL.n117 6.49172
R1460 CTRL.t8 CTRL.n118 6.49172
R1461 CTRL.t8 CTRL.n119 6.49172
R1462 CTRL.t8 CTRL.n120 6.49172
R1463 CTRL.t8 CTRL.n121 6.49172
R1464 CTRL.t8 CTRL.n122 6.49172
R1465 CTRL.t8 CTRL.n123 6.49172
R1466 CTRL.t8 CTRL.n124 6.49172
R1467 CTRL.t22 CTRL.n67 6.49172
R1468 CTRL.t22 CTRL.n68 6.49172
R1469 CTRL.t22 CTRL.n69 6.49172
R1470 CTRL.t22 CTRL.n70 6.49172
R1471 CTRL.t22 CTRL.n71 6.49172
R1472 CTRL.t22 CTRL.n72 6.49172
R1473 CTRL.t22 CTRL.n73 6.49172
R1474 CTRL.t22 CTRL.n74 6.49172
R1475 CTRL.t22 CTRL.n75 6.49172
R1476 CTRL.t22 CTRL.n76 6.49172
R1477 CTRL.t22 CTRL.n77 6.49172
R1478 CTRL.t22 CTRL.n78 6.49172
R1479 CTRL.t22 CTRL.n79 6.49172
R1480 CTRL.t22 CTRL.n80 6.49172
R1481 CTRL.n81 CTRL.t22 6.49172
R1482 CTRL.n217 CTRL.t0 6.49172
R1483 CTRL.t0 CTRL.n214 5.90366
R1484 CTRL.n109 CTRL.t4 5.90366
R1485 CTRL.n34 CTRL.t23 5.90366
R1486 CTRL.n201 CTRL.t8 5.90301
R1487 CTRL.n188 CTRL.t7 5.56394
R1488 CTRL.n155 CTRL.t14 5.56394
R1489 CTRL.t13 CTRL.n171 5.56394
R1490 CTRL.t13 CTRL.n151 5.56394
R1491 CTRL.t13 CTRL.n149 5.56394
R1492 CTRL.t13 CTRL.n147 5.56394
R1493 CTRL.t13 CTRL.n145 5.56394
R1494 CTRL.t13 CTRL.n143 5.56394
R1495 CTRL.t13 CTRL.n141 5.56394
R1496 CTRL.t13 CTRL.n139 5.56394
R1497 CTRL.t13 CTRL.n137 5.56394
R1498 CTRL.t13 CTRL.n135 5.56394
R1499 CTRL.t13 CTRL.n133 5.56394
R1500 CTRL.t13 CTRL.n131 5.56394
R1501 CTRL.t13 CTRL.n129 5.56394
R1502 CTRL.t13 CTRL.n127 5.56394
R1503 CTRL.t20 CTRL.n50 5.56394
R1504 CTRL.t20 CTRL.n49 5.56394
R1505 CTRL.t20 CTRL.n48 5.56394
R1506 CTRL.t20 CTRL.n47 5.56394
R1507 CTRL.t20 CTRL.n46 5.56394
R1508 CTRL.t20 CTRL.n45 5.56394
R1509 CTRL.t20 CTRL.n44 5.56394
R1510 CTRL.t20 CTRL.n43 5.56394
R1511 CTRL.t20 CTRL.n42 5.56394
R1512 CTRL.t20 CTRL.n41 5.56394
R1513 CTRL.t20 CTRL.n40 5.56394
R1514 CTRL.t20 CTRL.n39 5.56394
R1515 CTRL.t20 CTRL.n38 5.56394
R1516 CTRL.t20 CTRL.n37 5.56394
R1517 CTRL.n101 CTRL.t21 5.56394
R1518 CTRL.t3 CTRL.n0 5.56394
R1519 CTRL.t3 CTRL.n1 5.56394
R1520 CTRL.t3 CTRL.n2 5.56394
R1521 CTRL.t3 CTRL.n3 5.56394
R1522 CTRL.t3 CTRL.n4 5.56394
R1523 CTRL.t3 CTRL.n5 5.56394
R1524 CTRL.t3 CTRL.n6 5.56394
R1525 CTRL.t3 CTRL.n7 5.56394
R1526 CTRL.t3 CTRL.n8 5.56394
R1527 CTRL.n15 CTRL.t3 5.56394
R1528 CTRL.n182 CTRL.t3 5.56394
R1529 CTRL.n180 CTRL.t3 5.56394
R1530 CTRL.n178 CTRL.t3 5.56394
R1531 CTRL.n176 CTRL.t3 5.56394
R1532 CTRL.n174 CTRL.t3 5.56394
R1533 CTRL.n219 CTRL.t3 5.56394
R1534 CTRL.n10 CTRL.t1 5.56245
R1535 CTRL.n173 CTRL.t2 5.56245
R1536 CTRL.n11 CTRL.t1 5.56245
R1537 CTRL.n175 CTRL.t2 5.56245
R1538 CTRL.n12 CTRL.t1 5.56245
R1539 CTRL.n177 CTRL.t2 5.56245
R1540 CTRL.n13 CTRL.t1 5.56245
R1541 CTRL.n179 CTRL.t2 5.56245
R1542 CTRL.n14 CTRL.t1 5.56245
R1543 CTRL.n181 CTRL.t2 5.56245
R1544 CTRL.n17 CTRL.t1 5.56245
R1545 CTRL.n16 CTRL.t2 5.56245
R1546 CTRL.n216 CTRL.t1 5.56245
R1547 CTRL.n215 CTRL.t2 5.56245
R1548 CTRL.n19 CTRL.t1 5.56245
R1549 CTRL.n18 CTRL.t2 5.56245
R1550 CTRL.n21 CTRL.t1 5.56245
R1551 CTRL.n20 CTRL.t2 5.56245
R1552 CTRL.n23 CTRL.t1 5.56245
R1553 CTRL.n22 CTRL.t2 5.56245
R1554 CTRL.n25 CTRL.t1 5.56245
R1555 CTRL.n24 CTRL.t2 5.56245
R1556 CTRL.n27 CTRL.t1 5.56245
R1557 CTRL.n26 CTRL.t2 5.56245
R1558 CTRL.n29 CTRL.t1 5.56245
R1559 CTRL.n28 CTRL.t2 5.56245
R1560 CTRL.n31 CTRL.t1 5.56245
R1561 CTRL.n30 CTRL.t2 5.56245
R1562 CTRL.n153 CTRL.t10 5.56245
R1563 CTRL.n154 CTRL.t12 5.56245
R1564 CTRL.t9 CTRL.n111 5.56245
R1565 CTRL.n126 CTRL.t11 5.56245
R1566 CTRL.t9 CTRL.n112 5.56245
R1567 CTRL.n128 CTRL.t11 5.56245
R1568 CTRL.t9 CTRL.n113 5.56245
R1569 CTRL.n130 CTRL.t11 5.56245
R1570 CTRL.t9 CTRL.n114 5.56245
R1571 CTRL.n132 CTRL.t11 5.56245
R1572 CTRL.t9 CTRL.n115 5.56245
R1573 CTRL.n134 CTRL.t11 5.56245
R1574 CTRL.t9 CTRL.n116 5.56245
R1575 CTRL.n136 CTRL.t11 5.56245
R1576 CTRL.t9 CTRL.n117 5.56245
R1577 CTRL.n138 CTRL.t11 5.56245
R1578 CTRL.t9 CTRL.n118 5.56245
R1579 CTRL.n140 CTRL.t11 5.56245
R1580 CTRL.t9 CTRL.n119 5.56245
R1581 CTRL.n142 CTRL.t11 5.56245
R1582 CTRL.t9 CTRL.n120 5.56245
R1583 CTRL.n144 CTRL.t11 5.56245
R1584 CTRL.t9 CTRL.n121 5.56245
R1585 CTRL.n146 CTRL.t11 5.56245
R1586 CTRL.t9 CTRL.n122 5.56245
R1587 CTRL.n148 CTRL.t11 5.56245
R1588 CTRL.t9 CTRL.n123 5.56245
R1589 CTRL.n150 CTRL.t11 5.56245
R1590 CTRL.t9 CTRL.n124 5.56245
R1591 CTRL.n152 CTRL.t11 5.56245
R1592 CTRL.n200 CTRL.t9 5.56245
R1593 CTRL.n199 CTRL.t11 5.56245
R1594 CTRL.n172 CTRL.t11 5.56245
R1595 CTRL.n193 CTRL.t6 5.56245
R1596 CTRL.n189 CTRL.t5 5.56245
R1597 CTRL.t9 CTRL.n110 5.56245
R1598 CTRL.n35 CTRL.t17 5.56245
R1599 CTRL.n33 CTRL.t2 5.56245
R1600 CTRL.n213 CTRL.t1 5.56245
R1601 CTRL.n67 CTRL.t16 5.56245
R1602 CTRL.t18 CTRL.n53 5.56245
R1603 CTRL.n68 CTRL.t16 5.56245
R1604 CTRL.t18 CTRL.n54 5.56245
R1605 CTRL.n69 CTRL.t16 5.56245
R1606 CTRL.t18 CTRL.n55 5.56245
R1607 CTRL.n70 CTRL.t16 5.56245
R1608 CTRL.t18 CTRL.n56 5.56245
R1609 CTRL.n71 CTRL.t16 5.56245
R1610 CTRL.t18 CTRL.n57 5.56245
R1611 CTRL.n72 CTRL.t16 5.56245
R1612 CTRL.t18 CTRL.n58 5.56245
R1613 CTRL.n73 CTRL.t16 5.56245
R1614 CTRL.t18 CTRL.n59 5.56245
R1615 CTRL.n74 CTRL.t16 5.56245
R1616 CTRL.t18 CTRL.n60 5.56245
R1617 CTRL.n75 CTRL.t16 5.56245
R1618 CTRL.t18 CTRL.n61 5.56245
R1619 CTRL.n76 CTRL.t16 5.56245
R1620 CTRL.t18 CTRL.n62 5.56245
R1621 CTRL.n77 CTRL.t16 5.56245
R1622 CTRL.t18 CTRL.n63 5.56245
R1623 CTRL.n78 CTRL.t16 5.56245
R1624 CTRL.t18 CTRL.n64 5.56245
R1625 CTRL.n79 CTRL.t16 5.56245
R1626 CTRL.t18 CTRL.n65 5.56245
R1627 CTRL.n80 CTRL.t16 5.56245
R1628 CTRL.t18 CTRL.n66 5.56245
R1629 CTRL.n81 CTRL.t16 5.56245
R1630 CTRL.t18 CTRL.n82 5.56245
R1631 CTRL.t16 CTRL.n52 5.56245
R1632 CTRL.n83 CTRL.t18 5.56245
R1633 CTRL.n102 CTRL.t19 5.56245
R1634 CTRL.n217 CTRL.t1 5.56245
R1635 CTRL.n218 CTRL.t2 5.56245
R1636 CTRL.n84 CTRL.t20 4.08681
R1637 CTRL.t13 CTRL.n197 4.08669
R1638 CTRL.n205 CTRL.n203 3.98022
R1639 CTRL.n209 CTRL.n208 3.98022
R1640 CTRL.n84 CTRL.n83 1.06921
R1641 CTRL.n196 CTRL.n195 1.03328
R1642 CTRL.n191 CTRL.n190 1.03328
R1643 CTRL.n202 CTRL.n201 1.03328
R1644 CTRL.n214 CTRL.n32 1.03328
R1645 CTRL.n212 CTRL.n211 1.03328
R1646 CTRL.n105 CTRL.n104 1.03328
R1647 CTRL.n195 CTRL.n194 1.018
R1648 CTRL.n192 CTRL.n191 1.018
R1649 CTRL.n202 CTRL.n109 1.018
R1650 CTRL.n34 CTRL.n32 1.018
R1651 CTRL.n211 CTRL.n36 1.018
R1652 CTRL.n105 CTRL.n103 1.018
R1653 CTRL.n173 CTRL.n10 0.930769
R1654 CTRL.n175 CTRL.n11 0.930769
R1655 CTRL.n177 CTRL.n12 0.930769
R1656 CTRL.n179 CTRL.n13 0.930769
R1657 CTRL.n181 CTRL.n14 0.930769
R1658 CTRL.n17 CTRL.n16 0.930769
R1659 CTRL.n216 CTRL.n215 0.930769
R1660 CTRL.n19 CTRL.n18 0.930769
R1661 CTRL.n21 CTRL.n20 0.930769
R1662 CTRL.n23 CTRL.n22 0.930769
R1663 CTRL.n25 CTRL.n24 0.930769
R1664 CTRL.n27 CTRL.n26 0.930769
R1665 CTRL.n29 CTRL.n28 0.930769
R1666 CTRL.n31 CTRL.n30 0.930769
R1667 CTRL.n154 CTRL.n153 0.930769
R1668 CTRL.n126 CTRL.n111 0.930769
R1669 CTRL.n128 CTRL.n112 0.930769
R1670 CTRL.n130 CTRL.n113 0.930769
R1671 CTRL.n132 CTRL.n114 0.930769
R1672 CTRL.n134 CTRL.n115 0.930769
R1673 CTRL.n136 CTRL.n116 0.930769
R1674 CTRL.n138 CTRL.n117 0.930769
R1675 CTRL.n140 CTRL.n118 0.930769
R1676 CTRL.n142 CTRL.n119 0.930769
R1677 CTRL.n144 CTRL.n120 0.930769
R1678 CTRL.n146 CTRL.n121 0.930769
R1679 CTRL.n148 CTRL.n122 0.930769
R1680 CTRL.n150 CTRL.n123 0.930769
R1681 CTRL.n152 CTRL.n124 0.930769
R1682 CTRL.n200 CTRL.n199 0.930769
R1683 CTRL.n67 CTRL.n53 0.930769
R1684 CTRL.n68 CTRL.n54 0.930769
R1685 CTRL.n69 CTRL.n55 0.930769
R1686 CTRL.n70 CTRL.n56 0.930769
R1687 CTRL.n71 CTRL.n57 0.930769
R1688 CTRL.n72 CTRL.n58 0.930769
R1689 CTRL.n73 CTRL.n59 0.930769
R1690 CTRL.n74 CTRL.n60 0.930769
R1691 CTRL.n75 CTRL.n61 0.930769
R1692 CTRL.n76 CTRL.n62 0.930769
R1693 CTRL.n77 CTRL.n63 0.930769
R1694 CTRL.n78 CTRL.n64 0.930769
R1695 CTRL.n79 CTRL.n65 0.930769
R1696 CTRL.n80 CTRL.n66 0.930769
R1697 CTRL.n82 CTRL.n81 0.930769
R1698 CTRL.n83 CTRL.n52 0.930769
R1699 CTRL.n218 CTRL.n217 0.930769
R1700 CTRL.n174 CTRL.n173 0.928897
R1701 CTRL.n176 CTRL.n175 0.928897
R1702 CTRL.n178 CTRL.n177 0.928897
R1703 CTRL.n180 CTRL.n179 0.928897
R1704 CTRL.n182 CTRL.n181 0.928897
R1705 CTRL.n215 CTRL.n8 0.928897
R1706 CTRL.n18 CTRL.n7 0.928897
R1707 CTRL.n20 CTRL.n6 0.928897
R1708 CTRL.n22 CTRL.n5 0.928897
R1709 CTRL.n24 CTRL.n4 0.928897
R1710 CTRL.n26 CTRL.n3 0.928897
R1711 CTRL.n28 CTRL.n2 0.928897
R1712 CTRL.n30 CTRL.n1 0.928897
R1713 CTRL.n127 CTRL.n126 0.928897
R1714 CTRL.n129 CTRL.n128 0.928897
R1715 CTRL.n131 CTRL.n130 0.928897
R1716 CTRL.n133 CTRL.n132 0.928897
R1717 CTRL.n135 CTRL.n134 0.928897
R1718 CTRL.n137 CTRL.n136 0.928897
R1719 CTRL.n139 CTRL.n138 0.928897
R1720 CTRL.n141 CTRL.n140 0.928897
R1721 CTRL.n143 CTRL.n142 0.928897
R1722 CTRL.n145 CTRL.n144 0.928897
R1723 CTRL.n147 CTRL.n146 0.928897
R1724 CTRL.n149 CTRL.n148 0.928897
R1725 CTRL.n151 CTRL.n150 0.928897
R1726 CTRL.n171 CTRL.n152 0.928897
R1727 CTRL.n53 CTRL.n37 0.928897
R1728 CTRL.n54 CTRL.n38 0.928897
R1729 CTRL.n55 CTRL.n39 0.928897
R1730 CTRL.n56 CTRL.n40 0.928897
R1731 CTRL.n57 CTRL.n41 0.928897
R1732 CTRL.n58 CTRL.n42 0.928897
R1733 CTRL.n59 CTRL.n43 0.928897
R1734 CTRL.n60 CTRL.n44 0.928897
R1735 CTRL.n61 CTRL.n45 0.928897
R1736 CTRL.n62 CTRL.n46 0.928897
R1737 CTRL.n63 CTRL.n47 0.928897
R1738 CTRL.n64 CTRL.n48 0.928897
R1739 CTRL.n65 CTRL.n49 0.928897
R1740 CTRL.n66 CTRL.n50 0.928897
R1741 CTRL.n219 CTRL.n218 0.928551
R1742 CTRL.n16 CTRL.n15 0.928551
R1743 CTRL.n155 CTRL.n154 0.928206
R1744 CTRL.n82 CTRL.n51 0.81265
R1745 CTRL.n199 CTRL.n198 0.812304
R1746 CTRL.n188 CTRL.n187 0.58509
R1747 CTRL.n197 CTRL.n196 0.480361
R1748 CTRL.n197 CTRL.n125 0.430471
R1749 CTRL.n85 CTRL.n84 0.430325
R1750 CTRL.n198 CTRL.n125 0.354217
R1751 CTRL.n85 CTRL.n51 0.354217
R1752 CTRL.n170 CTRL.n125 0.351125
R1753 CTRL.n170 CTRL.n169 0.351125
R1754 CTRL.n169 CTRL.n168 0.351125
R1755 CTRL.n168 CTRL.n167 0.351125
R1756 CTRL.n167 CTRL.n166 0.351125
R1757 CTRL.n166 CTRL.n165 0.351125
R1758 CTRL.n165 CTRL.n164 0.351125
R1759 CTRL.n164 CTRL.n163 0.351125
R1760 CTRL.n163 CTRL.n162 0.351125
R1761 CTRL.n162 CTRL.n161 0.351125
R1762 CTRL.n161 CTRL.n160 0.351125
R1763 CTRL.n160 CTRL.n159 0.351125
R1764 CTRL.n159 CTRL.n158 0.351125
R1765 CTRL.n158 CTRL.n157 0.351125
R1766 CTRL.n157 CTRL.n156 0.351125
R1767 CTRL.n86 CTRL.n85 0.351125
R1768 CTRL.n87 CTRL.n86 0.351125
R1769 CTRL.n88 CTRL.n87 0.351125
R1770 CTRL.n89 CTRL.n88 0.351125
R1771 CTRL.n90 CTRL.n89 0.351125
R1772 CTRL.n91 CTRL.n90 0.351125
R1773 CTRL.n92 CTRL.n91 0.351125
R1774 CTRL.n93 CTRL.n92 0.351125
R1775 CTRL.n94 CTRL.n93 0.351125
R1776 CTRL.n95 CTRL.n94 0.351125
R1777 CTRL.n96 CTRL.n95 0.351125
R1778 CTRL.n97 CTRL.n96 0.351125
R1779 CTRL.n98 CTRL.n97 0.351125
R1780 CTRL.n99 CTRL.n98 0.351125
R1781 CTRL.n100 CTRL.n99 0.351125
R1782 CTRL.n228 CTRL.n227 0.351125
R1783 CTRL.n227 CTRL.n226 0.351125
R1784 CTRL.n226 CTRL.n225 0.351125
R1785 CTRL.n225 CTRL.n224 0.351125
R1786 CTRL.n224 CTRL.n223 0.351125
R1787 CTRL.n223 CTRL.n222 0.351125
R1788 CTRL.n222 CTRL.n221 0.351125
R1789 CTRL.n221 CTRL.n220 0.351125
R1790 CTRL.n220 CTRL.n9 0.351125
R1791 CTRL.n183 CTRL.n9 0.351125
R1792 CTRL.n184 CTRL.n183 0.351125
R1793 CTRL.n185 CTRL.n184 0.351125
R1794 CTRL.n186 CTRL.n185 0.351125
R1795 CTRL.n187 CTRL.n186 0.351125
R1796 CTRL.n196 CTRL.n172 0.342058
R1797 CTRL.n193 CTRL.n192 0.342058
R1798 CTRL.n189 CTRL.n109 0.342058
R1799 CTRL.n190 CTRL.n110 0.342058
R1800 CTRL.n35 CTRL.n34 0.342058
R1801 CTRL.n212 CTRL.n33 0.342058
R1802 CTRL.n214 CTRL.n213 0.342058
R1803 CTRL.n102 CTRL.n36 0.342058
R1804 CTRL.n190 CTRL.n172 0.341712
R1805 CTRL.n194 CTRL.n193 0.341712
R1806 CTRL.n192 CTRL.n189 0.341712
R1807 CTRL.n201 CTRL.n110 0.341712
R1808 CTRL.n36 CTRL.n35 0.341712
R1809 CTRL.n104 CTRL.n33 0.341712
R1810 CTRL.n213 CTRL.n212 0.341712
R1811 CTRL.n103 CTRL.n102 0.341712
R1812 CTRL.n103 CTRL.n101 0.339839
R1813 CTRL.n194 CTRL.n188 0.339494
R1814 CTRL.n104 CTRL.n0 0.339494
R1815 CTRL.n203 CTRL.n108 0.303948
R1816 CTRL.n210 CTRL.n209 0.303948
R1817 CTRL CTRL.n228 0.296125
R1818 CTRL CTRL.n0 0.289465
R1819 CTRL.n156 CTRL.n155 0.234465
R1820 CTRL.n220 CTRL.n219 0.234465
R1821 CTRL.n187 CTRL.n174 0.234119
R1822 CTRL.n186 CTRL.n176 0.234119
R1823 CTRL.n185 CTRL.n178 0.234119
R1824 CTRL.n184 CTRL.n180 0.234119
R1825 CTRL.n183 CTRL.n182 0.234119
R1826 CTRL.n15 CTRL.n9 0.234119
R1827 CTRL.n221 CTRL.n8 0.234119
R1828 CTRL.n222 CTRL.n7 0.234119
R1829 CTRL.n223 CTRL.n6 0.234119
R1830 CTRL.n224 CTRL.n5 0.234119
R1831 CTRL.n225 CTRL.n4 0.234119
R1832 CTRL.n226 CTRL.n3 0.234119
R1833 CTRL.n227 CTRL.n2 0.234119
R1834 CTRL.n228 CTRL.n1 0.234119
R1835 CTRL.n157 CTRL.n127 0.234119
R1836 CTRL.n158 CTRL.n129 0.234119
R1837 CTRL.n159 CTRL.n131 0.234119
R1838 CTRL.n160 CTRL.n133 0.234119
R1839 CTRL.n161 CTRL.n135 0.234119
R1840 CTRL.n162 CTRL.n137 0.234119
R1841 CTRL.n163 CTRL.n139 0.234119
R1842 CTRL.n164 CTRL.n141 0.234119
R1843 CTRL.n165 CTRL.n143 0.234119
R1844 CTRL.n166 CTRL.n145 0.234119
R1845 CTRL.n167 CTRL.n147 0.234119
R1846 CTRL.n168 CTRL.n149 0.234119
R1847 CTRL.n169 CTRL.n151 0.234119
R1848 CTRL.n171 CTRL.n170 0.234119
R1849 CTRL.n99 CTRL.n37 0.234119
R1850 CTRL.n98 CTRL.n38 0.234119
R1851 CTRL.n97 CTRL.n39 0.234119
R1852 CTRL.n96 CTRL.n40 0.234119
R1853 CTRL.n95 CTRL.n41 0.234119
R1854 CTRL.n94 CTRL.n42 0.234119
R1855 CTRL.n93 CTRL.n43 0.234119
R1856 CTRL.n92 CTRL.n44 0.234119
R1857 CTRL.n91 CTRL.n45 0.234119
R1858 CTRL.n90 CTRL.n46 0.234119
R1859 CTRL.n89 CTRL.n47 0.234119
R1860 CTRL.n88 CTRL.n48 0.234119
R1861 CTRL.n87 CTRL.n49 0.234119
R1862 CTRL.n86 CTRL.n50 0.234119
R1863 CTRL.n101 CTRL.n100 0.234119
R1864 CTRL.n207 CTRL 0.0555
R1865 CTRL.n106 CTRL 0.0555
R1866 CTRL.n204 CTRL 0.0555
R1867 CTRL.n156 CTRL 0.0555
R1868 CTRL.n100 CTRL 0.0555
R1869 CTRL.n107 CTRL 0.0247
R1870 psdiff_2.CLKP.n11 psdiff_2.CLKP 85.2142
R1871 psdiff_2.CLKP.n1 psdiff_2.CLKP.t5 17.0005
R1872 psdiff_2.CLKP.n3 psdiff_2.CLKP.t2 17.0005
R1873 psdiff_2.CLKP.n4 psdiff_2.CLKP.t7 17.0005
R1874 psdiff_2.CLKP.n6 psdiff_2.CLKP.t0 17.0005
R1875 psdiff_2.CLKP.n7 psdiff_2.CLKP.t4 17.0005
R1876 psdiff_2.CLKP.n9 psdiff_2.CLKP.t1 17.0005
R1877 psdiff_2.CLKP.n0 psdiff_2.CLKP.t6 17.0005
R1878 psdiff_2.CLKP.n15 psdiff_2.CLKP.t3 17.0005
R1879 psdiff_2.CLKP psdiff_2.CLKP.t8 15.0698
R1880 psdiff_2.CLKP.n10 psdiff_2.CLKP.t9 15.0005
R1881 psdiff_2.CLKP.n15 psdiff_2.CLKP.n14 9.91525
R1882 psdiff_2.CLKP.n11 psdiff_2.CLKP.n10 9.72119
R1883 psdiff_2.CLKP.n14 psdiff_2.CLKP.n3 9.12325
R1884 psdiff_2.CLKP.n13 psdiff_2.CLKP.n6 9.12325
R1885 psdiff_2.CLKP.n12 psdiff_2.CLKP.n9 9.12325
R1886 psdiff_2.CLKP.n3 psdiff_2.CLKP 1.19877
R1887 psdiff_2.CLKP.n6 psdiff_2.CLKP 1.19877
R1888 psdiff_2.CLKP.n9 psdiff_2.CLKP 1.19877
R1889 psdiff_2.CLKP.n15 psdiff_2.CLKP 1.19877
R1890 psdiff_2.CLKP.n13 psdiff_2.CLKP.n12 0.7925
R1891 psdiff_2.CLKP.n2 psdiff_2.CLKP 0.559983
R1892 psdiff_2.CLKP.n5 psdiff_2.CLKP 0.559983
R1893 psdiff_2.CLKP.n8 psdiff_2.CLKP 0.559983
R1894 psdiff_2.CLKP psdiff_2.CLKP.n16 0.559983
R1895 psdiff_2.CLKP psdiff_2.CLKP.n13 0.4273
R1896 psdiff_2.CLKP.n14 psdiff_2.CLKP 0.3657
R1897 psdiff_2.CLKP.n2 psdiff_2.CLKP 0.292688
R1898 psdiff_2.CLKP.n5 psdiff_2.CLKP 0.292688
R1899 psdiff_2.CLKP.n8 psdiff_2.CLKP 0.292688
R1900 psdiff_2.CLKP.n16 psdiff_2.CLKP 0.292688
R1901 psdiff_2.CLKP psdiff_2.CLKP.n1 0.282375
R1902 psdiff_2.CLKP psdiff_2.CLKP.n4 0.282375
R1903 psdiff_2.CLKP psdiff_2.CLKP.n7 0.282375
R1904 psdiff_2.CLKP psdiff_2.CLKP.n0 0.282375
R1905 psdiff_2.CLKP.n12 psdiff_2.CLKP.n11 0.1567
R1906 psdiff_2.CLKP.n1 psdiff_2.CLKP 0.089875
R1907 psdiff_2.CLKP.n4 psdiff_2.CLKP 0.089875
R1908 psdiff_2.CLKP.n7 psdiff_2.CLKP 0.089875
R1909 psdiff_2.CLKP.n0 psdiff_2.CLKP 0.089875
R1910 psdiff_2.CLKP.n10 psdiff_2.CLKP 0.0555
R1911 psdiff_2.CLKP.n3 psdiff_2.CLKP.n2 0.0403276
R1912 psdiff_2.CLKP.n6 psdiff_2.CLKP.n5 0.0403276
R1913 psdiff_2.CLKP.n9 psdiff_2.CLKP.n8 0.0403276
R1914 psdiff_2.CLKP.n16 psdiff_2.CLKP.n15 0.0403276
R1915 psdiff_2.CLKP.n10 psdiff_2.CLKP 0.0151667
R1916 VSS.n404 VSS.n397 32104.8
R1917 VSS.n405 VSS.n404 22733.7
R1918 VSS.n646 VSS.n632 22040.3
R1919 VSS.n696 VSS.n695 16407.2
R1920 VSS.n696 VSS.n240 16249.2
R1921 VSS.n793 VSS.n181 16132.8
R1922 VSS.n794 VSS.n793 15920.1
R1923 VSS.n646 VSS.n645 12930.5
R1924 VSS.n390 VSS.n283 7363.84
R1925 VSS.n627 VSS.n626 7363.84
R1926 VSS.n794 VSS.n180 5750
R1927 VSS.n645 VSS.n240 5340.56
R1928 VSS.n798 VSS.n797 1582.07
R1929 VSS.n799 VSS.n798 1582.07
R1930 VSS.n802 VSS.n801 1582.07
R1931 VSS.n803 VSS.n802 1582.07
R1932 VSS.n463 VSS.n462 1369.73
R1933 VSS.n486 VSS.n485 1369.73
R1934 VSS.n852 VSS.n851 1369.73
R1935 VSS.n844 VSS.n843 1369.73
R1936 VSS.n819 VSS.n818 1369.73
R1937 VSS.n639 VSS.n63 1369.73
R1938 VSS.n642 VSS.n641 1369.73
R1939 VSS.n184 VSS.n182 1349.63
R1940 VSS.n785 VSS.n784 1349.63
R1941 VSS.n778 VSS.n777 1349.63
R1942 VSS.n762 VSS.n761 1349.63
R1943 VSS.n204 VSS.n202 1349.63
R1944 VSS.n754 VSS.n753 1349.63
R1945 VSS.n747 VSS.n746 1349.63
R1946 VSS.n731 VSS.n730 1349.63
R1947 VSS.n224 VSS.n222 1349.63
R1948 VSS.n723 VSS.n722 1349.63
R1949 VSS.n716 VSS.n715 1349.63
R1950 VSS.n395 VSS.n394 1349.63
R1951 VSS.n624 VSS.n623 1349.63
R1952 VSS.n630 VSS.n629 1349.63
R1953 VSS.n398 VSS.n3 1349.63
R1954 VSS.n900 VSS.n899 1349.63
R1955 VSS.n893 VSS.n892 1349.63
R1956 VSS.n877 VSS.n876 1349.63
R1957 VSS.n22 VSS.n20 1349.63
R1958 VSS.n869 VSS.n868 1349.63
R1959 VSS.n614 VSS.n613 1349.63
R1960 VSS.n598 VSS.n597 1349.63
R1961 VSS.n302 VSS.n300 1349.63
R1962 VSS.n590 VSS.n589 1349.63
R1963 VSS.n665 VSS.n664 1349.63
R1964 VSS.n481 VSS.n480 1177.15
R1965 VSS.n839 VSS.n838 1177.15
R1966 VSS.n446 VSS.n445 1171.97
R1967 VSS.n503 VSS.n502 1171.97
R1968 VSS.n506 VSS.n505 1171.97
R1969 VSS.n509 VSS.n508 1171.97
R1970 VSS.n536 VSS.n535 1171.97
R1971 VSS.n555 VSS.n554 1171.97
R1972 VSS.n558 VSS.n557 1171.97
R1973 VSS.n561 VSS.n560 1171.97
R1974 VSS.n684 VSS.n683 1171.97
R1975 VSS.n690 VSS.n689 1171.97
R1976 VSS.n693 VSS.n692 1171.97
R1977 VSS.n240 VSS.n86 1158.05
R1978 VSS.n795 VSS.n794 1103.34
R1979 VSS.n408 VSS.n407 982.63
R1980 VSS.n417 VSS.n416 982.63
R1981 VSS.n412 VSS.n356 982.63
R1982 VSS.n466 VSS.n465 982.63
R1983 VSS.n472 VSS.n30 982.63
R1984 VSS.n860 VSS.n859 982.63
R1985 VSS.n855 VSS.n854 982.63
R1986 VSS.n847 VSS.n846 982.63
R1987 VSS.n830 VSS.n829 982.63
R1988 VSS.n827 VSS.n826 982.63
R1989 VSS.n822 VSS.n821 982.63
R1990 VSS.n814 VSS.n813 982.63
R1991 VSS.n781 VSS.n780 968.216
R1992 VSS.n774 VSS.n773 968.216
R1993 VSS.n771 VSS.n770 968.216
R1994 VSS.n767 VSS.n766 968.216
R1995 VSS.n750 VSS.n749 968.216
R1996 VSS.n743 VSS.n742 968.216
R1997 VSS.n740 VSS.n739 968.216
R1998 VSS.n736 VSS.n735 968.216
R1999 VSS.n719 VSS.n718 968.216
R2000 VSS.n712 VSS.n711 968.216
R2001 VSS.n706 VSS.n705 968.216
R2002 VSS.n702 VSS.n701 968.216
R2003 VSS.n896 VSS.n895 968.216
R2004 VSS.n889 VSS.n888 968.216
R2005 VSS.n886 VSS.n885 968.216
R2006 VSS.n882 VSS.n881 968.216
R2007 VSS.n289 VSS.n26 968.216
R2008 VSS.n610 VSS.n609 968.216
R2009 VSS.n607 VSS.n606 968.216
R2010 VSS.n603 VSS.n602 968.216
R2011 VSS.n307 VSS.n261 968.216
R2012 VSS.n661 VSS.n660 968.216
R2013 VSS.n656 VSS.n655 968.216
R2014 VSS.n652 VSS.n651 968.216
R2015 VSS.n647 VSS.n646 946.211
R2016 VSS.n793 VSS.n792 880.197
R2017 VSS.n697 VSS.n696 880.197
R2018 VSS.n374 VSS.n373 840.764
R2019 VSS.n434 VSS.n433 840.764
R2020 VSS.n437 VSS.n436 840.764
R2021 VSS.n441 VSS.n346 840.764
R2022 VSS.n512 VSS.n511 840.764
R2023 VSS.n520 VSS.n519 840.764
R2024 VSS.n523 VSS.n522 840.764
R2025 VSS.n539 VSS.n538 840.764
R2026 VSS.n564 VSS.n563 840.764
R2027 VSS.n573 VSS.n572 840.764
R2028 VSS.n568 VSS.n257 840.764
R2029 VSS.n687 VSS.n686 840.764
R2030 VSS.n404 VSS.n403 821.516
R2031 VSS.t347 VSS.t329 519.758
R2032 VSS.t331 VSS.t324 519.758
R2033 VSS.t338 VSS.t326 519.758
R2034 VSS.t151 VSS.t336 519.758
R2035 VSS.t148 VSS.t337 519.758
R2036 VSS.t96 VSS.t83 519.758
R2037 VSS.t89 VSS.t93 519.758
R2038 VSS.t87 VSS.t112 519.758
R2039 VSS.t95 VSS.t85 519.758
R2040 VSS.t92 VSS.t100 519.758
R2041 VSS.t48 VSS.t54 519.758
R2042 VSS.t63 VSS.t58 519.758
R2043 VSS.t44 VSS.t50 519.758
R2044 VSS.t46 VSS.t56 519.758
R2045 VSS.t53 VSS.t69 519.758
R2046 VSS.t153 VSS.t244 519.758
R2047 VSS.t150 VSS.t252 519.758
R2048 VSS.t249 VSS.t240 519.758
R2049 VSS.t235 VSS.t242 519.758
R2050 VSS.t251 VSS.t237 519.758
R2051 VSS.t380 VSS.t387 519.758
R2052 VSS.t384 VSS.t377 519.758
R2053 VSS.t391 VSS.t396 519.758
R2054 VSS.t149 VSS.t373 519.758
R2055 VSS.t146 VSS.t375 519.758
R2056 VSS.t147 VSS.t463 519.758
R2057 VSS.t152 VSS.t468 519.758
R2058 VSS.t466 VSS.t457 519.758
R2059 VSS.t472 VSS.t476 519.758
R2060 VSS.t454 VSS.t464 519.758
R2061 VSS.n377 VSS.t444 424.318
R2062 VSS.n377 VSS.t436 424.318
R2063 VSS.n407 VSS.t436 424.318
R2064 VSS.n408 VSS.t448 424.318
R2065 VSS.t448 VSS.n375 424.318
R2066 VSS.t442 VSS.n375 424.318
R2067 VSS.n417 VSS.t442 424.318
R2068 VSS.n416 VSS.t446 424.318
R2069 VSS.n409 VSS.t446 424.318
R2070 VSS.t438 VSS.n409 424.318
R2071 VSS.n412 VSS.t438 424.318
R2072 VSS.n356 VSS.t450 424.318
R2073 VSS.t450 VSS.n354 424.318
R2074 VSS.n354 VSS.t440 424.318
R2075 VSS.n462 VSS.t440 424.318
R2076 VSS.n463 VSS.t367 424.318
R2077 VSS.t367 VSS.n350 424.318
R2078 VSS.n350 VSS.t371 424.318
R2079 VSS.n465 VSS.t371 424.318
R2080 VSS.n466 VSS.t369 424.318
R2081 VSS.t369 VSS.n348 424.318
R2082 VSS.t365 VSS.n348 424.318
R2083 VSS.n486 VSS.t365 424.318
R2084 VSS.n485 VSS.t363 424.318
R2085 VSS.n467 VSS.t363 424.318
R2086 VSS.t361 VSS.n467 424.318
R2087 VSS.n481 VSS.t361 424.318
R2088 VSS.n472 VSS.t212 424.318
R2089 VSS.n30 VSS.t216 424.318
R2090 VSS.t216 VSS.n28 424.318
R2091 VSS.t204 VSS.n28 424.318
R2092 VSS.n860 VSS.t204 424.318
R2093 VSS.n859 VSS.t208 424.318
R2094 VSS.n31 VSS.t208 424.318
R2095 VSS.t214 VSS.n31 424.318
R2096 VSS.n855 VSS.t214 424.318
R2097 VSS.n854 VSS.t210 424.318
R2098 VSS.n33 VSS.t210 424.318
R2099 VSS.t202 VSS.n33 424.318
R2100 VSS.n852 VSS.t202 424.318
R2101 VSS.n851 VSS.t194 424.318
R2102 VSS.n37 VSS.t194 424.318
R2103 VSS.t200 VSS.n37 424.318
R2104 VSS.n847 VSS.t200 424.318
R2105 VSS.n846 VSS.t198 424.318
R2106 VSS.n39 VSS.t198 424.318
R2107 VSS.t196 VSS.n39 424.318
R2108 VSS.n844 VSS.t196 424.318
R2109 VSS.n843 VSS.t132 424.318
R2110 VSS.n43 VSS.t132 424.318
R2111 VSS.t130 VSS.n43 424.318
R2112 VSS.n839 VSS.t130 424.318
R2113 VSS.n830 VSS.t228 424.318
R2114 VSS.n829 VSS.t224 424.318
R2115 VSS.n49 VSS.t224 424.318
R2116 VSS.t218 VSS.n49 424.318
R2117 VSS.n827 VSS.t218 424.318
R2118 VSS.n826 VSS.t232 424.318
R2119 VSS.n53 VSS.t232 424.318
R2120 VSS.t230 VSS.n53 424.318
R2121 VSS.n822 VSS.t230 424.318
R2122 VSS.n821 VSS.t226 424.318
R2123 VSS.n55 VSS.t226 424.318
R2124 VSS.t220 VSS.n55 424.318
R2125 VSS.n819 VSS.t220 424.318
R2126 VSS.n818 VSS.t564 424.318
R2127 VSS.n59 VSS.t564 424.318
R2128 VSS.t558 VSS.n59 424.318
R2129 VSS.n814 VSS.t558 424.318
R2130 VSS.n813 VSS.t560 424.318
R2131 VSS.n61 VSS.t560 424.318
R2132 VSS.t562 VSS.n61 424.318
R2133 VSS.n63 VSS.t562 424.318
R2134 VSS.n639 VSS.t164 424.318
R2135 VSS.t164 VSS.n635 424.318
R2136 VSS.n635 VSS.t166 424.318
R2137 VSS.n641 VSS.t166 424.318
R2138 VSS.n642 VSS.t188 424.318
R2139 VSS.n644 VSS.t188 424.318
R2140 VSS.n792 VSS.t180 418.094
R2141 VSS.n182 VSS.t180 418.094
R2142 VSS.n184 VSS.t0 418.094
R2143 VSS.t0 VSS.n183 418.094
R2144 VSS.t2 VSS.n183 418.094
R2145 VSS.n785 VSS.t2 418.094
R2146 VSS.n784 VSS.t6 418.094
R2147 VSS.n186 VSS.t6 418.094
R2148 VSS.t10 VSS.n186 418.094
R2149 VSS.n781 VSS.t10 418.094
R2150 VSS.n780 VSS.t8 418.094
R2151 VSS.n188 VSS.t8 418.094
R2152 VSS.t4 VSS.n188 418.094
R2153 VSS.n778 VSS.t4 418.094
R2154 VSS.n777 VSS.t496 418.094
R2155 VSS.n192 VSS.t496 418.094
R2156 VSS.t492 VSS.n192 418.094
R2157 VSS.n774 VSS.t492 418.094
R2158 VSS.n773 VSS.t502 418.094
R2159 VSS.n194 VSS.t502 418.094
R2160 VSS.t498 VSS.n194 418.094
R2161 VSS.n771 VSS.t498 418.094
R2162 VSS.n770 VSS.t490 418.094
R2163 VSS.n198 VSS.t490 418.094
R2164 VSS.t504 VSS.n198 418.094
R2165 VSS.n767 VSS.t504 418.094
R2166 VSS.n766 VSS.t500 418.094
R2167 VSS.n200 VSS.t500 418.094
R2168 VSS.t494 VSS.n200 418.094
R2169 VSS.n762 VSS.t494 418.094
R2170 VSS.n761 VSS.t168 418.094
R2171 VSS.n202 VSS.t168 418.094
R2172 VSS.n204 VSS.t530 418.094
R2173 VSS.t530 VSS.n203 418.094
R2174 VSS.t532 VSS.n203 418.094
R2175 VSS.n754 VSS.t532 418.094
R2176 VSS.n753 VSS.t592 418.094
R2177 VSS.n206 VSS.t592 418.094
R2178 VSS.t590 VSS.n206 418.094
R2179 VSS.n750 VSS.t590 418.094
R2180 VSS.n749 VSS.t596 418.094
R2181 VSS.n208 VSS.t596 418.094
R2182 VSS.t594 VSS.n208 418.094
R2183 VSS.n747 VSS.t594 418.094
R2184 VSS.n746 VSS.t12 418.094
R2185 VSS.n212 VSS.t12 418.094
R2186 VSS.t24 VSS.n212 418.094
R2187 VSS.n743 VSS.t24 418.094
R2188 VSS.n742 VSS.t18 418.094
R2189 VSS.n214 VSS.t18 418.094
R2190 VSS.t14 VSS.n214 418.094
R2191 VSS.n740 VSS.t14 418.094
R2192 VSS.n739 VSS.t22 418.094
R2193 VSS.n218 VSS.t22 418.094
R2194 VSS.t20 VSS.n218 418.094
R2195 VSS.n736 VSS.t20 418.094
R2196 VSS.n735 VSS.t16 418.094
R2197 VSS.n220 VSS.t16 418.094
R2198 VSS.t26 VSS.n220 418.094
R2199 VSS.n731 VSS.t26 418.094
R2200 VSS.n730 VSS.t186 418.094
R2201 VSS.n222 VSS.t186 418.094
R2202 VSS.n224 VSS.t192 418.094
R2203 VSS.t192 VSS.n223 418.094
R2204 VSS.t190 VSS.n223 418.094
R2205 VSS.n723 VSS.t190 418.094
R2206 VSS.n722 VSS.t604 418.094
R2207 VSS.n226 VSS.t604 418.094
R2208 VSS.t600 VSS.n226 418.094
R2209 VSS.n719 VSS.t600 418.094
R2210 VSS.n718 VSS.t598 418.094
R2211 VSS.n228 VSS.t598 418.094
R2212 VSS.t602 VSS.n228 418.094
R2213 VSS.n716 VSS.t602 418.094
R2214 VSS.n715 VSS.t28 418.094
R2215 VSS.n232 VSS.t28 418.094
R2216 VSS.t32 VSS.n232 418.094
R2217 VSS.n712 VSS.t32 418.094
R2218 VSS.n711 VSS.t30 418.094
R2219 VSS.n234 VSS.t30 418.094
R2220 VSS.t36 VSS.n234 418.094
R2221 VSS.n706 VSS.t36 418.094
R2222 VSS.n705 VSS.t34 418.094
R2223 VSS.n236 VSS.t34 418.094
R2224 VSS.t42 VSS.n236 418.094
R2225 VSS.n702 VSS.t42 418.094
R2226 VSS.n701 VSS.t40 418.094
R2227 VSS.n238 VSS.t40 418.094
R2228 VSS.t38 VSS.n238 418.094
R2229 VSS.n697 VSS.t38 418.094
R2230 VSS.n397 VSS.t184 418.094
R2231 VSS.n382 VSS.t184 418.094
R2232 VSS.t182 VSS.n382 418.094
R2233 VSS.n395 VSS.t182 418.094
R2234 VSS.n394 VSS.t170 418.094
R2235 VSS.n387 VSS.t170 418.094
R2236 VSS.t172 VSS.n387 418.094
R2237 VSS.n390 VSS.t172 418.094
R2238 VSS.n283 VSS.t154 418.094
R2239 VSS.t154 VSS.n281 418.094
R2240 VSS.n281 VSS.t156 418.094
R2241 VSS.n623 VSS.t156 418.094
R2242 VSS.n624 VSS.t144 418.094
R2243 VSS.t144 VSS.n277 418.094
R2244 VSS.n277 VSS.t142 418.094
R2245 VSS.n626 VSS.t142 418.094
R2246 VSS.n627 VSS.t178 418.094
R2247 VSS.t178 VSS.n273 418.094
R2248 VSS.n273 VSS.t176 418.094
R2249 VSS.n629 VSS.t176 418.094
R2250 VSS.n630 VSS.t160 418.094
R2251 VSS.t160 VSS.n270 418.094
R2252 VSS.n270 VSS.t158 418.094
R2253 VSS.n632 VSS.t158 418.094
R2254 VSS.n403 VSS.t461 418.094
R2255 VSS.n398 VSS.t461 418.094
R2256 VSS.n3 VSS.t430 418.094
R2257 VSS.t430 VSS.n2 418.094
R2258 VSS.t428 VSS.n2 418.094
R2259 VSS.n900 VSS.t428 418.094
R2260 VSS.n899 VSS.t138 418.094
R2261 VSS.n4 VSS.t138 418.094
R2262 VSS.t134 VSS.n4 418.094
R2263 VSS.n896 VSS.t134 418.094
R2264 VSS.n895 VSS.t140 418.094
R2265 VSS.n6 VSS.t140 418.094
R2266 VSS.t136 VSS.n6 418.094
R2267 VSS.n893 VSS.t136 418.094
R2268 VSS.n892 VSS.t580 418.094
R2269 VSS.n10 VSS.t580 418.094
R2270 VSS.t586 VSS.n10 418.094
R2271 VSS.n889 VSS.t586 418.094
R2272 VSS.n888 VSS.t588 418.094
R2273 VSS.n12 VSS.t588 418.094
R2274 VSS.t574 VSS.n12 418.094
R2275 VSS.n886 VSS.t574 418.094
R2276 VSS.n885 VSS.t578 418.094
R2277 VSS.n16 VSS.t578 418.094
R2278 VSS.t582 VSS.n16 418.094
R2279 VSS.n882 VSS.t582 418.094
R2280 VSS.n881 VSS.t584 418.094
R2281 VSS.n18 VSS.t584 418.094
R2282 VSS.t576 VSS.n18 418.094
R2283 VSS.n877 VSS.t576 418.094
R2284 VSS.n876 VSS.t116 418.094
R2285 VSS.n20 VSS.t116 418.094
R2286 VSS.n22 VSS.t608 418.094
R2287 VSS.t608 VSS.n21 418.094
R2288 VSS.t606 VSS.n21 418.094
R2289 VSS.n869 VSS.t606 418.094
R2290 VSS.n868 VSS.t122 418.094
R2291 VSS.n24 VSS.t122 418.094
R2292 VSS.t124 VSS.n24 418.094
R2293 VSS.n26 VSS.t124 418.094
R2294 VSS.n289 VSS.t126 418.094
R2295 VSS.t126 VSS.n286 418.094
R2296 VSS.t128 VSS.n286 418.094
R2297 VSS.n614 VSS.t128 418.094
R2298 VSS.n613 VSS.t426 418.094
R2299 VSS.n290 VSS.t426 418.094
R2300 VSS.t420 VSS.n290 418.094
R2301 VSS.n610 VSS.t420 418.094
R2302 VSS.n609 VSS.t416 418.094
R2303 VSS.n292 VSS.t416 418.094
R2304 VSS.t412 VSS.n292 418.094
R2305 VSS.n607 VSS.t412 418.094
R2306 VSS.n606 VSS.t422 418.094
R2307 VSS.n296 VSS.t422 418.094
R2308 VSS.t414 VSS.n296 418.094
R2309 VSS.n603 VSS.t414 418.094
R2310 VSS.n602 VSS.t418 418.094
R2311 VSS.n298 VSS.t418 418.094
R2312 VSS.t424 VSS.n298 418.094
R2313 VSS.n598 VSS.t424 418.094
R2314 VSS.n597 VSS.t264 418.094
R2315 VSS.n300 VSS.t264 418.094
R2316 VSS.n302 VSS.t308 418.094
R2317 VSS.t308 VSS.n301 418.094
R2318 VSS.t310 VSS.n301 418.094
R2319 VSS.n590 VSS.t310 418.094
R2320 VSS.n589 VSS.t510 418.094
R2321 VSS.n304 VSS.t510 418.094
R2322 VSS.t508 VSS.n304 418.094
R2323 VSS.n307 VSS.t508 418.094
R2324 VSS.n261 VSS.t506 418.094
R2325 VSS.t506 VSS.n259 418.094
R2326 VSS.t512 VSS.n259 418.094
R2327 VSS.n665 VSS.t512 418.094
R2328 VSS.n664 VSS.t526 418.094
R2329 VSS.n262 VSS.t526 418.094
R2330 VSS.t514 VSS.n262 418.094
R2331 VSS.n661 VSS.t514 418.094
R2332 VSS.n660 VSS.t528 418.094
R2333 VSS.n264 VSS.t528 418.094
R2334 VSS.t520 VSS.n264 418.094
R2335 VSS.n656 VSS.t520 418.094
R2336 VSS.n655 VSS.t516 418.094
R2337 VSS.n266 VSS.t516 418.094
R2338 VSS.t522 VSS.n266 418.094
R2339 VSS.n652 VSS.t522 418.094
R2340 VSS.n651 VSS.t518 418.094
R2341 VSS.n268 VSS.t518 418.094
R2342 VSS.t524 VSS.n268 418.094
R2343 VSS.n647 VSS.t524 418.094
R2344 VSS.t278 VSS.n181 363.058
R2345 VSS.n367 VSS.t278 363.058
R2346 VSS.n367 VSS.t274 363.058
R2347 VSS.n373 VSS.t274 363.058
R2348 VSS.n374 VSS.t282 363.058
R2349 VSS.t282 VSS.n365 363.058
R2350 VSS.n365 VSS.t284 363.058
R2351 VSS.n433 VSS.t284 363.058
R2352 VSS.n434 VSS.t280 363.058
R2353 VSS.t280 VSS.n361 363.058
R2354 VSS.n361 VSS.t272 363.058
R2355 VSS.n436 VSS.t272 363.058
R2356 VSS.n437 VSS.t286 363.058
R2357 VSS.t286 VSS.n359 363.058
R2358 VSS.t276 VSS.n359 363.058
R2359 VSS.n446 VSS.t276 363.058
R2360 VSS.n445 VSS.t320 363.058
R2361 VSS.n438 VSS.t320 363.058
R2362 VSS.t316 VSS.n438 363.058
R2363 VSS.n441 VSS.t316 363.058
R2364 VSS.n346 VSS.t322 363.058
R2365 VSS.t322 VSS.n344 363.058
R2366 VSS.n344 VSS.t318 363.058
R2367 VSS.n502 VSS.t318 363.058
R2368 VSS.n503 VSS.t312 363.058
R2369 VSS.t312 VSS.n341 363.058
R2370 VSS.n341 VSS.t314 363.058
R2371 VSS.n505 VSS.t314 363.058
R2372 VSS.n506 VSS.t401 363.058
R2373 VSS.n508 VSS.t401 363.058
R2374 VSS.n509 VSS.t546 363.058
R2375 VSS.t546 VSS.n334 363.058
R2376 VSS.n334 VSS.t554 363.058
R2377 VSS.n511 VSS.t554 363.058
R2378 VSS.n512 VSS.t550 363.058
R2379 VSS.t550 VSS.n332 363.058
R2380 VSS.n332 VSS.t544 363.058
R2381 VSS.n519 VSS.t544 363.058
R2382 VSS.n520 VSS.t548 363.058
R2383 VSS.t548 VSS.n328 363.058
R2384 VSS.n328 VSS.t556 363.058
R2385 VSS.n522 VSS.t556 363.058
R2386 VSS.n523 VSS.t552 363.058
R2387 VSS.t552 VSS.n326 363.058
R2388 VSS.n326 VSS.t542 363.058
R2389 VSS.n535 VSS.t542 363.058
R2390 VSS.n536 VSS.t534 363.058
R2391 VSS.t534 VSS.n322 363.058
R2392 VSS.n322 VSS.t536 363.058
R2393 VSS.n538 VSS.t536 363.058
R2394 VSS.n539 VSS.t538 363.058
R2395 VSS.t538 VSS.n320 363.058
R2396 VSS.n320 VSS.t540 363.058
R2397 VSS.n554 VSS.t540 363.058
R2398 VSS.n555 VSS.t434 363.058
R2399 VSS.t434 VSS.n317 363.058
R2400 VSS.n317 VSS.t432 363.058
R2401 VSS.n557 VSS.t432 363.058
R2402 VSS.n558 VSS.t341 363.058
R2403 VSS.n560 VSS.t341 363.058
R2404 VSS.n561 VSS.t290 363.058
R2405 VSS.t290 VSS.n310 363.058
R2406 VSS.n310 VSS.t300 363.058
R2407 VSS.n563 VSS.t300 363.058
R2408 VSS.n564 VSS.t296 363.058
R2409 VSS.t296 VSS.n308 363.058
R2410 VSS.t294 VSS.n308 363.058
R2411 VSS.n573 VSS.t294 363.058
R2412 VSS.n572 VSS.t292 363.058
R2413 VSS.n565 VSS.t292 363.058
R2414 VSS.t302 VSS.n565 363.058
R2415 VSS.n568 VSS.t302 363.058
R2416 VSS.n257 VSS.t298 363.058
R2417 VSS.t298 VSS.n255 363.058
R2418 VSS.n255 VSS.t288 363.058
R2419 VSS.n683 VSS.t288 363.058
R2420 VSS.n684 VSS.t570 363.058
R2421 VSS.t570 VSS.n251 363.058
R2422 VSS.n251 VSS.t568 363.058
R2423 VSS.n686 VSS.t568 363.058
R2424 VSS.n687 VSS.t566 363.058
R2425 VSS.t566 VSS.n246 363.058
R2426 VSS.n246 VSS.t572 363.058
R2427 VSS.n689 VSS.t572 363.058
R2428 VSS.n690 VSS.t304 363.058
R2429 VSS.t304 VSS.n243 363.058
R2430 VSS.n243 VSS.t306 363.058
R2431 VSS.n692 VSS.t306 363.058
R2432 VSS.n693 VSS.t78 363.058
R2433 VSS.n695 VSS.t78 363.058
R2434 VSS.n798 VSS.n143 297.546
R2435 VSS.n802 VSS.n45 297.546
R2436 VSS.t444 VSS.n180 290.324
R2437 VSS.n798 VSS.n144 266.872
R2438 VSS.n802 VSS.n46 266.872
R2439 VSS.n795 VSS.t347 259.878
R2440 VSS.t329 VSS.n145 259.878
R2441 VSS.t324 VSS.n145 259.878
R2442 VSS.n176 VSS.t331 259.878
R2443 VSS.n176 VSS.t338 259.878
R2444 VSS.t326 VSS.n146 259.878
R2445 VSS.t336 VSS.n146 259.878
R2446 VSS.n169 VSS.t151 259.878
R2447 VSS.n169 VSS.t148 259.878
R2448 VSS.t337 VSS.n148 259.878
R2449 VSS.t83 VSS.n148 259.878
R2450 VSS.n168 VSS.t96 259.878
R2451 VSS.n168 VSS.t89 259.878
R2452 VSS.t93 VSS.n152 259.878
R2453 VSS.t112 VSS.n152 259.878
R2454 VSS.n163 VSS.t87 259.878
R2455 VSS.n163 VSS.t95 259.878
R2456 VSS.t85 VSS.n153 259.878
R2457 VSS.n153 VSS.t92 259.878
R2458 VSS.n797 VSS.t100 259.878
R2459 VSS.n799 VSS.t48 259.878
R2460 VSS.t54 VSS.n104 259.878
R2461 VSS.t58 VSS.n104 259.878
R2462 VSS.n135 VSS.t63 259.878
R2463 VSS.n135 VSS.t44 259.878
R2464 VSS.t50 VSS.n105 259.878
R2465 VSS.t56 VSS.n105 259.878
R2466 VSS.n128 VSS.t46 259.878
R2467 VSS.n128 VSS.t53 259.878
R2468 VSS.t69 VSS.n107 259.878
R2469 VSS.t244 VSS.n107 259.878
R2470 VSS.n127 VSS.t153 259.878
R2471 VSS.n127 VSS.t150 259.878
R2472 VSS.t252 VSS.n111 259.878
R2473 VSS.t240 VSS.n111 259.878
R2474 VSS.n122 VSS.t249 259.878
R2475 VSS.n122 VSS.t235 259.878
R2476 VSS.t242 VSS.n112 259.878
R2477 VSS.n112 VSS.t251 259.878
R2478 VSS.n801 VSS.t237 259.878
R2479 VSS.n803 VSS.t380 259.878
R2480 VSS.t387 VSS.n74 259.878
R2481 VSS.t377 VSS.n74 259.878
R2482 VSS.n100 VSS.t384 259.878
R2483 VSS.n100 VSS.t391 259.878
R2484 VSS.t396 VSS.n75 259.878
R2485 VSS.t373 VSS.n75 259.878
R2486 VSS.n93 VSS.t149 259.878
R2487 VSS.n93 VSS.t146 259.878
R2488 VSS.t375 VSS.n77 259.878
R2489 VSS.t463 VSS.n77 259.878
R2490 VSS.n92 VSS.t147 259.878
R2491 VSS.n92 VSS.t152 259.878
R2492 VSS.t468 VSS.n81 259.878
R2493 VSS.t457 VSS.n81 259.878
R2494 VSS.n87 VSS.t466 259.878
R2495 VSS.n87 VSS.t472 259.878
R2496 VSS.t476 VSS.n82 259.878
R2497 VSS.t464 VSS.n82 259.878
R2498 VSS.n86 VSS.t454 259.878
R2499 VSS.n480 VSS.t174 174.847
R2500 VSS.t174 VSS.n143 174.847
R2501 VSS.t206 VSS.n144 174.847
R2502 VSS.n469 VSS.t206 174.847
R2503 VSS.n838 VSS.t162 174.847
R2504 VSS.n45 VSS.t162 174.847
R2505 VSS.t222 VSS.n46 174.847
R2506 VSS.n47 VSS.t222 174.847
R2507 VSS.t212 VSS.n469 172.161
R2508 VSS.t228 VSS.n47 172.161
R2509 VSS.n405 VSS.n180 133.995
R2510 VSS.n645 VSS.n644 29.7772
R2511 VSS.n101 VSS.t381 17.3511
R2512 VSS.n579 VSS.t388 17.3511
R2513 VSS.n94 VSS.t398 17.3511
R2514 VSS.n96 VSS.t407 17.3511
R2515 VSS.n672 VSS.t379 17.3511
R2516 VSS.n78 VSS.t392 17.3511
R2517 VSS.n88 VSS.t452 17.3511
R2518 VSS.n66 VSS.t469 17.3511
R2519 VSS.n69 VSS.t479 17.3511
R2520 VSS.n71 VSS.t465 17.3511
R2521 VSS.n83 VSS.t455 17.3511
R2522 VSS.n140 VSS.t60 17.3511
R2523 VSS.n136 VSS.t66 17.3511
R2524 VSS.n129 VSS.t75 17.3511
R2525 VSS.n131 VSS.t51 17.3511
R2526 VSS.n524 VSS.t59 17.3511
R2527 VSS.n108 VSS.t77 17.3511
R2528 VSS.n123 VSS.t234 17.3511
R2529 VSS.n543 VSS.t253 17.3511
R2530 VSS.n116 VSS.t260 17.3511
R2531 VSS.n118 VSS.t243 17.3511
R2532 VSS.n113 VSS.t256 17.3511
R2533 VSS.n177 VSS.t355 17.3511
R2534 VSS.n422 VSS.t330 17.3511
R2535 VSS.n170 VSS.t332 17.3511
R2536 VSS.n172 VSS.t343 17.3511
R2537 VSS.n452 VSS.t328 17.3511
R2538 VSS.n149 VSS.t102 17.3511
R2539 VSS.n164 VSS.t97 17.3511
R2540 VSS.n491 VSS.t110 17.3511
R2541 VSS.n157 VSS.t88 17.3511
R2542 VSS.n159 VSS.t103 17.3511
R2543 VSS.n154 VSS.t113 17.3511
R2544 VSS.n648 VSS.t519 17.3133
R2545 VSS.n269 VSS.t525 17.3133
R2546 VSS.n653 VSS.t517 17.3133
R2547 VSS.n267 VSS.t523 17.3133
R2548 VSS.n657 VSS.t529 17.3133
R2549 VSS.n667 VSS.t513 17.3133
R2550 VSS.n305 VSS.t507 17.3133
R2551 VSS.n662 VSS.t527 17.3133
R2552 VSS.n263 VSS.t515 17.3133
R2553 VSS.n587 VSS.t511 17.3133
R2554 VSS.n306 VSS.t509 17.3133
R2555 VSS.n303 VSS.t311 17.3133
R2556 VSS.n593 VSS.t309 17.3133
R2557 VSS.n295 VSS.t413 17.3133
R2558 VSS.n293 VSS.t417 17.3133
R2559 VSS.n604 VSS.t423 17.3133
R2560 VSS.n297 VSS.t415 17.3133
R2561 VSS.n599 VSS.t419 17.3133
R2562 VSS.n299 VSS.t425 17.3133
R2563 VSS.n594 VSS.t265 17.3133
R2564 VSS.n616 VSS.t129 17.3133
R2565 VSS.n287 VSS.t127 17.3133
R2566 VSS.n611 VSS.t427 17.3133
R2567 VSS.n291 VSS.t421 17.3133
R2568 VSS.n866 VSS.t123 17.3133
R2569 VSS.n25 VSS.t125 17.3133
R2570 VSS.n23 VSS.t607 17.3133
R2571 VSS.n872 VSS.t609 17.3133
R2572 VSS.n15 VSS.t575 17.3133
R2573 VSS.n13 VSS.t589 17.3133
R2574 VSS.n883 VSS.t579 17.3133
R2575 VSS.n17 VSS.t583 17.3133
R2576 VSS.n878 VSS.t585 17.3133
R2577 VSS.n19 VSS.t577 17.3133
R2578 VSS.n873 VSS.t117 17.3133
R2579 VSS.n9 VSS.t137 17.3133
R2580 VSS.n7 VSS.t141 17.3133
R2581 VSS.n890 VSS.t581 17.3133
R2582 VSS.n11 VSS.t587 17.3133
R2583 VSS.n897 VSS.t139 17.3133
R2584 VSS.n5 VSS.t135 17.3133
R2585 VSS.n902 VSS.t429 17.3133
R2586 VSS.n399 VSS.t431 17.3133
R2587 VSS.n400 VSS.t462 17.3133
R2588 VSS.n274 VSS.t161 17.3133
R2589 VSS.n271 VSS.t159 17.3133
R2590 VSS.n278 VSS.t179 17.3133
R2591 VSS.n275 VSS.t177 17.3133
R2592 VSS.n621 VSS.t157 17.3133
R2593 VSS.n388 VSS.t155 17.3133
R2594 VSS.n620 VSS.t145 17.3133
R2595 VSS.n279 VSS.t143 17.3133
R2596 VSS.n386 VSS.t183 17.3133
R2597 VSS.n383 VSS.t185 17.3133
R2598 VSS.n391 VSS.t171 17.3133
R2599 VSS.n389 VSS.t173 17.3133
R2600 VSS.n241 VSS.t79 17.3133
R2601 VSS.n247 VSS.t305 17.3133
R2602 VSS.n244 VSS.t307 17.3133
R2603 VSS.n252 VSS.t567 17.3133
R2604 VSS.n681 VSS.t289 17.3133
R2605 VSS.n566 VSS.t299 17.3133
R2606 VSS.n680 VSS.t571 17.3133
R2607 VSS.n253 VSS.t569 17.3133
R2608 VSS.n575 VSS.t295 17.3133
R2609 VSS.n311 VSS.t297 17.3133
R2610 VSS.n569 VSS.t293 17.3133
R2611 VSS.n567 VSS.t303 17.3133
R2612 VSS.n552 VSS.t541 17.3133
R2613 VSS.n323 VSS.t539 17.3133
R2614 VSS.n551 VSS.t435 17.3133
R2615 VSS.n318 VSS.t433 17.3133
R2616 VSS.n315 VSS.t342 17.3133
R2617 VSS.n314 VSS.t291 17.3133
R2618 VSS.n312 VSS.t301 17.3133
R2619 VSS.n533 VSS.t543 17.3133
R2620 VSS.n329 VSS.t553 17.3133
R2621 VSS.n532 VSS.t535 17.3133
R2622 VSS.n324 VSS.t537 17.3133
R2623 VSS.n517 VSS.t545 17.3133
R2624 VSS.n335 VSS.t551 17.3133
R2625 VSS.n516 VSS.t549 17.3133
R2626 VSS.n330 VSS.t557 17.3133
R2627 VSS.n500 VSS.t319 17.3133
R2628 VSS.n439 VSS.t323 17.3133
R2629 VSS.n499 VSS.t313 17.3133
R2630 VSS.n342 VSS.t315 17.3133
R2631 VSS.n339 VSS.t402 17.3133
R2632 VSS.n338 VSS.t547 17.3133
R2633 VSS.n336 VSS.t555 17.3133
R2634 VSS.n448 VSS.t277 17.3133
R2635 VSS.n362 VSS.t287 17.3133
R2636 VSS.n442 VSS.t321 17.3133
R2637 VSS.n440 VSS.t317 17.3133
R2638 VSS.n431 VSS.t285 17.3133
R2639 VSS.n368 VSS.t283 17.3133
R2640 VSS.n430 VSS.t281 17.3133
R2641 VSS.n363 VSS.t273 17.3133
R2642 VSS.n370 VSS.t279 17.3133
R2643 VSS.n369 VSS.t275 17.3133
R2644 VSS.n698 VSS.t41 17.3133
R2645 VSS.n239 VSS.t39 17.3133
R2646 VSS.n703 VSS.t35 17.3133
R2647 VSS.n237 VSS.t43 17.3133
R2648 VSS.n708 VSS.t31 17.3133
R2649 VSS.n231 VSS.t603 17.3133
R2650 VSS.n229 VSS.t599 17.3133
R2651 VSS.n713 VSS.t29 17.3133
R2652 VSS.n233 VSS.t33 17.3133
R2653 VSS.n720 VSS.t605 17.3133
R2654 VSS.n227 VSS.t601 17.3133
R2655 VSS.n225 VSS.t191 17.3133
R2656 VSS.n726 VSS.t193 17.3133
R2657 VSS.n217 VSS.t15 17.3133
R2658 VSS.n215 VSS.t19 17.3133
R2659 VSS.n737 VSS.t23 17.3133
R2660 VSS.n219 VSS.t21 17.3133
R2661 VSS.n732 VSS.t17 17.3133
R2662 VSS.n221 VSS.t27 17.3133
R2663 VSS.n727 VSS.t187 17.3133
R2664 VSS.n211 VSS.t595 17.3133
R2665 VSS.n209 VSS.t597 17.3133
R2666 VSS.n744 VSS.t13 17.3133
R2667 VSS.n213 VSS.t25 17.3133
R2668 VSS.n751 VSS.t593 17.3133
R2669 VSS.n207 VSS.t591 17.3133
R2670 VSS.n205 VSS.t533 17.3133
R2671 VSS.n757 VSS.t531 17.3133
R2672 VSS.n197 VSS.t499 17.3133
R2673 VSS.n195 VSS.t503 17.3133
R2674 VSS.n768 VSS.t491 17.3133
R2675 VSS.n199 VSS.t505 17.3133
R2676 VSS.n763 VSS.t501 17.3133
R2677 VSS.n201 VSS.t495 17.3133
R2678 VSS.n758 VSS.t169 17.3133
R2679 VSS.n191 VSS.t5 17.3133
R2680 VSS.n189 VSS.t9 17.3133
R2681 VSS.n775 VSS.t497 17.3133
R2682 VSS.n193 VSS.t493 17.3133
R2683 VSS.n782 VSS.t7 17.3133
R2684 VSS.n187 VSS.t11 17.3133
R2685 VSS.n185 VSS.t3 17.3133
R2686 VSS.n788 VSS.t1 17.3133
R2687 VSS.n789 VSS.t181 17.3133
R2688 VSS.n235 VSS.t37 17.3133
R2689 VSS.n633 VSS.t189 17.3133
R2690 VSS.n637 VSS.t165 17.3133
R2691 VSS.n636 VSS.t167 17.3133
R2692 VSS.n810 VSS.t561 17.3133
R2693 VSS.n58 VSS.t221 17.3133
R2694 VSS.n56 VSS.t227 17.3133
R2695 VSS.n815 VSS.t565 17.3133
R2696 VSS.n60 VSS.t559 17.3133
R2697 VSS.n52 VSS.t219 17.3133
R2698 VSS.n50 VSS.t225 17.3133
R2699 VSS.n823 VSS.t233 17.3133
R2700 VSS.n54 VSS.t231 17.3133
R2701 VSS.n48 VSS.t229 17.3133
R2702 VSS.n62 VSS.t563 17.3133
R2703 VSS.n835 VSS.t163 17.3133
R2704 VSS.n833 VSS.t223 17.3133
R2705 VSS.n42 VSS.t197 17.3133
R2706 VSS.n40 VSS.t199 17.3133
R2707 VSS.n840 VSS.t133 17.3133
R2708 VSS.n44 VSS.t131 17.3133
R2709 VSS.n36 VSS.t203 17.3133
R2710 VSS.n34 VSS.t211 17.3133
R2711 VSS.n848 VSS.t195 17.3133
R2712 VSS.n38 VSS.t201 17.3133
R2713 VSS.n862 VSS.t205 17.3133
R2714 VSS.n470 VSS.t217 17.3133
R2715 VSS.n856 VSS.t209 17.3133
R2716 VSS.n32 VSS.t215 17.3133
R2717 VSS.n471 VSS.t213 17.3133
R2718 VSS.n477 VSS.t175 17.3133
R2719 VSS.n475 VSS.t207 17.3133
R2720 VSS.n488 VSS.t366 17.3133
R2721 VSS.n351 VSS.t370 17.3133
R2722 VSS.n482 VSS.t364 17.3133
R2723 VSS.n468 VSS.t362 17.3133
R2724 VSS.n460 VSS.t441 17.3133
R2725 VSS.n410 VSS.t451 17.3133
R2726 VSS.n459 VSS.t368 17.3133
R2727 VSS.n352 VSS.t372 17.3133
R2728 VSS.n419 VSS.t443 17.3133
R2729 VSS.n378 VSS.t449 17.3133
R2730 VSS.n413 VSS.t447 17.3133
R2731 VSS.n411 VSS.t439 17.3133
R2732 VSS.n380 VSS.t445 17.3133
R2733 VSS.n379 VSS.t437 17.3133
R2734 VSS.n248 VSS.t573 17.3133
R2735 VSS.n265 VSS.t521 17.3133
R2736 VSS.n102 VSS.t383 17.0005
R2737 VSS.n101 VSS.t406 17.0005
R2738 VSS.n580 VSS.t390 17.0005
R2739 VSS.n579 VSS.t378 17.0005
R2740 VSS.n95 VSS.t399 17.0005
R2741 VSS.n94 VSS.t385 17.0005
R2742 VSS.n97 VSS.t374 17.0005
R2743 VSS.n96 VSS.t397 17.0005
R2744 VSS.n673 VSS.t382 17.0005
R2745 VSS.n672 VSS.t405 17.0005
R2746 VSS.n79 VSS.t394 17.0005
R2747 VSS.n78 VSS.t376 17.0005
R2748 VSS.n89 VSS.t453 17.0005
R2749 VSS.n88 VSS.t481 17.0005
R2750 VSS.n67 VSS.t471 17.0005
R2751 VSS.n66 VSS.t458 17.0005
R2752 VSS.n70 VSS.t480 17.0005
R2753 VSS.n69 VSS.t467 17.0005
R2754 VSS.n72 VSS.t470 17.0005
R2755 VSS.n71 VSS.t477 17.0005
R2756 VSS.n84 VSS.t456 17.0005
R2757 VSS.n83 VSS.t483 17.0005
R2758 VSS.n141 VSS.t62 17.0005
R2759 VSS.n140 VSS.t49 17.0005
R2760 VSS.n137 VSS.t68 17.0005
R2761 VSS.n136 VSS.t55 17.0005
R2762 VSS.n130 VSS.t45 17.0005
R2763 VSS.n129 VSS.t64 17.0005
R2764 VSS.n132 VSS.t52 17.0005
R2765 VSS.n131 VSS.t74 17.0005
R2766 VSS.n525 VSS.t61 17.0005
R2767 VSS.n524 VSS.t47 17.0005
R2768 VSS.n109 VSS.t82 17.0005
R2769 VSS.n108 VSS.t70 17.0005
R2770 VSS.n124 VSS.t239 17.0005
R2771 VSS.n123 VSS.t263 17.0005
R2772 VSS.n544 VSS.t255 17.0005
R2773 VSS.n543 VSS.t241 17.0005
R2774 VSS.n117 VSS.t236 17.0005
R2775 VSS.n116 VSS.t250 17.0005
R2776 VSS.n119 VSS.t246 17.0005
R2777 VSS.n118 VSS.t266 17.0005
R2778 VSS.n114 VSS.t258 17.0005
R2779 VSS.n113 VSS.t238 17.0005
R2780 VSS.n178 VSS.t358 17.0005
R2781 VSS.n177 VSS.t348 17.0005
R2782 VSS.n423 VSS.t325 17.0005
R2783 VSS.n422 VSS.t350 17.0005
R2784 VSS.n171 VSS.t335 17.0005
R2785 VSS.n170 VSS.t353 17.0005
R2786 VSS.n173 VSS.t344 17.0005
R2787 VSS.n172 VSS.t327 17.0005
R2788 VSS.n453 VSS.t333 17.0005
R2789 VSS.n452 VSS.t349 17.0005
R2790 VSS.n150 VSS.t104 17.0005
R2791 VSS.n149 VSS.t84 17.0005
R2792 VSS.n165 VSS.t99 17.0005
R2793 VSS.n164 VSS.t90 17.0005
R2794 VSS.n492 VSS.t109 17.0005
R2795 VSS.n491 VSS.t94 17.0005
R2796 VSS.n158 VSS.t91 17.0005
R2797 VSS.n157 VSS.t115 17.0005
R2798 VSS.n160 VSS.t106 17.0005
R2799 VSS.n159 VSS.t86 17.0005
R2800 VSS.n155 VSS.t114 17.0005
R2801 VSS.n154 VSS.t101 17.0005
R2802 VSS.n406 VSS.n379 17.0005
R2803 VSS.n407 VSS.n406 17.0005
R2804 VSS.n406 VSS.n377 17.0005
R2805 VSS.n406 VSS.n405 17.0005
R2806 VSS.n415 VSS.n411 17.0005
R2807 VSS.n415 VSS.n412 17.0005
R2808 VSS.n415 VSS.n409 17.0005
R2809 VSS.n416 VSS.n415 17.0005
R2810 VSS.n418 VSS.n408 17.0005
R2811 VSS.n418 VSS.n375 17.0005
R2812 VSS.n419 VSS.n418 17.0005
R2813 VSS.n418 VSS.n417 17.0005
R2814 VSS.n464 VSS.n352 17.0005
R2815 VSS.n465 VSS.n464 17.0005
R2816 VSS.n464 VSS.n350 17.0005
R2817 VSS.n464 VSS.n463 17.0005
R2818 VSS.n461 VSS.n356 17.0005
R2819 VSS.n461 VSS.n354 17.0005
R2820 VSS.n461 VSS.n460 17.0005
R2821 VSS.n462 VSS.n461 17.0005
R2822 VSS.n484 VSS.n468 17.0005
R2823 VSS.n484 VSS.n481 17.0005
R2824 VSS.n484 VSS.n467 17.0005
R2825 VSS.n485 VSS.n484 17.0005
R2826 VSS.n487 VSS.n466 17.0005
R2827 VSS.n487 VSS.n348 17.0005
R2828 VSS.n488 VSS.n487 17.0005
R2829 VSS.n487 VSS.n486 17.0005
R2830 VSS.n473 VSS.n469 17.0005
R2831 VSS.n473 VSS.n144 17.0005
R2832 VSS.n479 VSS.n143 17.0005
R2833 VSS.n480 VSS.n479 17.0005
R2834 VSS.n473 VSS.n471 17.0005
R2835 VSS.n473 VSS.n472 17.0005
R2836 VSS.n858 VSS.n32 17.0005
R2837 VSS.n858 VSS.n855 17.0005
R2838 VSS.n858 VSS.n31 17.0005
R2839 VSS.n859 VSS.n858 17.0005
R2840 VSS.n861 VSS.n30 17.0005
R2841 VSS.n861 VSS.n28 17.0005
R2842 VSS.n862 VSS.n861 17.0005
R2843 VSS.n861 VSS.n860 17.0005
R2844 VSS.n850 VSS.n38 17.0005
R2845 VSS.n850 VSS.n847 17.0005
R2846 VSS.n850 VSS.n37 17.0005
R2847 VSS.n851 VSS.n850 17.0005
R2848 VSS.n854 VSS.n853 17.0005
R2849 VSS.n853 VSS.n33 17.0005
R2850 VSS.n853 VSS.n36 17.0005
R2851 VSS.n853 VSS.n852 17.0005
R2852 VSS.n842 VSS.n44 17.0005
R2853 VSS.n842 VSS.n839 17.0005
R2854 VSS.n842 VSS.n43 17.0005
R2855 VSS.n843 VSS.n842 17.0005
R2856 VSS.n846 VSS.n845 17.0005
R2857 VSS.n845 VSS.n39 17.0005
R2858 VSS.n845 VSS.n42 17.0005
R2859 VSS.n845 VSS.n844 17.0005
R2860 VSS.n831 VSS.n47 17.0005
R2861 VSS.n831 VSS.n46 17.0005
R2862 VSS.n837 VSS.n45 17.0005
R2863 VSS.n838 VSS.n837 17.0005
R2864 VSS.n812 VSS.n62 17.0005
R2865 VSS.n812 VSS.n63 17.0005
R2866 VSS.n831 VSS.n48 17.0005
R2867 VSS.n831 VSS.n830 17.0005
R2868 VSS.n825 VSS.n54 17.0005
R2869 VSS.n825 VSS.n822 17.0005
R2870 VSS.n825 VSS.n53 17.0005
R2871 VSS.n826 VSS.n825 17.0005
R2872 VSS.n829 VSS.n828 17.0005
R2873 VSS.n828 VSS.n49 17.0005
R2874 VSS.n828 VSS.n52 17.0005
R2875 VSS.n828 VSS.n827 17.0005
R2876 VSS.n817 VSS.n60 17.0005
R2877 VSS.n817 VSS.n814 17.0005
R2878 VSS.n817 VSS.n59 17.0005
R2879 VSS.n818 VSS.n817 17.0005
R2880 VSS.n821 VSS.n820 17.0005
R2881 VSS.n820 VSS.n55 17.0005
R2882 VSS.n820 VSS.n58 17.0005
R2883 VSS.n820 VSS.n819 17.0005
R2884 VSS.n812 VSS.n61 17.0005
R2885 VSS.n813 VSS.n812 17.0005
R2886 VSS.n640 VSS.n636 17.0005
R2887 VSS.n641 VSS.n640 17.0005
R2888 VSS.n640 VSS.n635 17.0005
R2889 VSS.n640 VSS.n639 17.0005
R2890 VSS.n644 VSS.n643 17.0005
R2891 VSS.n643 VSS.n642 17.0005
R2892 VSS.n797 VSS.n796 17.0005
R2893 VSS.n796 VSS.n153 17.0005
R2894 VSS.n796 VSS.n162 17.0005
R2895 VSS.n796 VSS.n163 17.0005
R2896 VSS.n796 VSS.n152 17.0005
R2897 VSS.n796 VSS.n168 17.0005
R2898 VSS.n796 VSS.n151 17.0005
R2899 VSS.n796 VSS.n148 17.0005
R2900 VSS.n796 VSS.n169 17.0005
R2901 VSS.n796 VSS.n146 17.0005
R2902 VSS.n796 VSS.n175 17.0005
R2903 VSS.n796 VSS.n176 17.0005
R2904 VSS.n796 VSS.n145 17.0005
R2905 VSS.n796 VSS.n795 17.0005
R2906 VSS.n801 VSS.n800 17.0005
R2907 VSS.n800 VSS.n112 17.0005
R2908 VSS.n800 VSS.n121 17.0005
R2909 VSS.n800 VSS.n122 17.0005
R2910 VSS.n800 VSS.n111 17.0005
R2911 VSS.n800 VSS.n127 17.0005
R2912 VSS.n800 VSS.n110 17.0005
R2913 VSS.n800 VSS.n107 17.0005
R2914 VSS.n800 VSS.n128 17.0005
R2915 VSS.n800 VSS.n105 17.0005
R2916 VSS.n800 VSS.n134 17.0005
R2917 VSS.n800 VSS.n135 17.0005
R2918 VSS.n800 VSS.n104 17.0005
R2919 VSS.n800 VSS.n799 17.0005
R2920 VSS.n804 VSS.n86 17.0005
R2921 VSS.n804 VSS.n82 17.0005
R2922 VSS.n805 VSS.n804 17.0005
R2923 VSS.n804 VSS.n87 17.0005
R2924 VSS.n804 VSS.n81 17.0005
R2925 VSS.n804 VSS.n92 17.0005
R2926 VSS.n804 VSS.n80 17.0005
R2927 VSS.n804 VSS.n77 17.0005
R2928 VSS.n804 VSS.n93 17.0005
R2929 VSS.n804 VSS.n75 17.0005
R2930 VSS.n804 VSS.n99 17.0005
R2931 VSS.n804 VSS.n100 17.0005
R2932 VSS.n804 VSS.n74 17.0005
R2933 VSS.n804 VSS.n803 17.0005
R2934 VSS.n710 VSS.n235 17.0005
R2935 VSS.n710 VSS.n706 17.0005
R2936 VSS.n791 VSS.n182 17.0005
R2937 VSS.n792 VSS.n791 17.0005
R2938 VSS.n786 VSS.n184 17.0005
R2939 VSS.n786 VSS.n183 17.0005
R2940 VSS.n786 VSS.n185 17.0005
R2941 VSS.n786 VSS.n785 17.0005
R2942 VSS.n783 VSS.n187 17.0005
R2943 VSS.n783 VSS.n781 17.0005
R2944 VSS.n783 VSS 17.0005
R2945 VSS.n783 VSS.n186 17.0005
R2946 VSS.n783 VSS.n782 17.0005
R2947 VSS.n784 VSS.n783 17.0005
R2948 VSS.n776 VSS.n193 17.0005
R2949 VSS.n776 VSS.n774 17.0005
R2950 VSS.n776 VSS 17.0005
R2951 VSS.n776 VSS.n192 17.0005
R2952 VSS.n776 VSS.n775 17.0005
R2953 VSS.n777 VSS.n776 17.0005
R2954 VSS.n780 VSS.n779 17.0005
R2955 VSS.n779 VSS.n188 17.0005
R2956 VSS.n779 VSS.n191 17.0005
R2957 VSS.n779 VSS.n778 17.0005
R2958 VSS.n760 VSS.n202 17.0005
R2959 VSS.n761 VSS.n760 17.0005
R2960 VSS.n765 VSS.n201 17.0005
R2961 VSS.n765 VSS.n762 17.0005
R2962 VSS.n765 VSS.n200 17.0005
R2963 VSS.n766 VSS.n765 17.0005
R2964 VSS.n769 VSS.n199 17.0005
R2965 VSS.n769 VSS.n767 17.0005
R2966 VSS.n769 VSS 17.0005
R2967 VSS.n769 VSS.n198 17.0005
R2968 VSS.n769 VSS.n768 17.0005
R2969 VSS.n770 VSS.n769 17.0005
R2970 VSS.n773 VSS.n772 17.0005
R2971 VSS.n772 VSS.n194 17.0005
R2972 VSS.n772 VSS.n197 17.0005
R2973 VSS.n772 VSS.n771 17.0005
R2974 VSS.n755 VSS.n204 17.0005
R2975 VSS.n755 VSS.n203 17.0005
R2976 VSS.n755 VSS.n205 17.0005
R2977 VSS.n755 VSS.n754 17.0005
R2978 VSS.n752 VSS.n207 17.0005
R2979 VSS.n752 VSS.n750 17.0005
R2980 VSS.n752 VSS 17.0005
R2981 VSS.n752 VSS.n206 17.0005
R2982 VSS.n752 VSS.n751 17.0005
R2983 VSS.n753 VSS.n752 17.0005
R2984 VSS.n745 VSS.n213 17.0005
R2985 VSS.n745 VSS.n743 17.0005
R2986 VSS.n745 VSS 17.0005
R2987 VSS.n745 VSS.n212 17.0005
R2988 VSS.n745 VSS.n744 17.0005
R2989 VSS.n746 VSS.n745 17.0005
R2990 VSS.n749 VSS.n748 17.0005
R2991 VSS.n748 VSS.n208 17.0005
R2992 VSS.n748 VSS.n211 17.0005
R2993 VSS.n748 VSS.n747 17.0005
R2994 VSS.n729 VSS.n222 17.0005
R2995 VSS.n730 VSS.n729 17.0005
R2996 VSS.n734 VSS.n221 17.0005
R2997 VSS.n734 VSS.n731 17.0005
R2998 VSS.n734 VSS.n220 17.0005
R2999 VSS.n735 VSS.n734 17.0005
R3000 VSS.n738 VSS.n219 17.0005
R3001 VSS.n738 VSS.n736 17.0005
R3002 VSS.n738 VSS 17.0005
R3003 VSS.n738 VSS.n218 17.0005
R3004 VSS.n738 VSS.n737 17.0005
R3005 VSS.n739 VSS.n738 17.0005
R3006 VSS.n742 VSS.n741 17.0005
R3007 VSS.n741 VSS.n214 17.0005
R3008 VSS.n741 VSS.n217 17.0005
R3009 VSS.n741 VSS.n740 17.0005
R3010 VSS.n724 VSS.n224 17.0005
R3011 VSS.n724 VSS.n223 17.0005
R3012 VSS.n724 VSS.n225 17.0005
R3013 VSS.n724 VSS.n723 17.0005
R3014 VSS.n721 VSS.n227 17.0005
R3015 VSS.n721 VSS.n719 17.0005
R3016 VSS.n721 VSS 17.0005
R3017 VSS.n721 VSS.n226 17.0005
R3018 VSS.n721 VSS.n720 17.0005
R3019 VSS.n722 VSS.n721 17.0005
R3020 VSS.n714 VSS.n233 17.0005
R3021 VSS.n714 VSS.n712 17.0005
R3022 VSS.n714 VSS 17.0005
R3023 VSS.n714 VSS.n232 17.0005
R3024 VSS.n714 VSS.n713 17.0005
R3025 VSS.n715 VSS.n714 17.0005
R3026 VSS.n718 VSS.n717 17.0005
R3027 VSS.n717 VSS.n228 17.0005
R3028 VSS.n717 VSS.n231 17.0005
R3029 VSS.n717 VSS.n716 17.0005
R3030 VSS.n710 VSS.n234 17.0005
R3031 VSS.n711 VSS.n710 17.0005
R3032 VSS.n704 VSS.n237 17.0005
R3033 VSS.n704 VSS.n702 17.0005
R3034 VSS.n704 VSS 17.0005
R3035 VSS.n704 VSS.n236 17.0005
R3036 VSS.n704 VSS.n703 17.0005
R3037 VSS.n705 VSS.n704 17.0005
R3038 VSS.n700 VSS.n239 17.0005
R3039 VSS.n700 VSS.n697 17.0005
R3040 VSS.n700 VSS.n238 17.0005
R3041 VSS.n701 VSS.n700 17.0005
R3042 VSS.n688 VSS.n248 17.0005
R3043 VSS.n689 VSS.n688 17.0005
R3044 VSS.n372 VSS.n369 17.0005
R3045 VSS.n373 VSS.n372 17.0005
R3046 VSS.n372 VSS.n367 17.0005
R3047 VSS.n372 VSS.n181 17.0005
R3048 VSS.n435 VSS.n363 17.0005
R3049 VSS.n436 VSS.n435 17.0005
R3050 VSS.n435 VSS.n361 17.0005
R3051 VSS.n435 VSS.n434 17.0005
R3052 VSS.n432 VSS.n374 17.0005
R3053 VSS.n432 VSS.n365 17.0005
R3054 VSS.n432 VSS.n431 17.0005
R3055 VSS.n433 VSS.n432 17.0005
R3056 VSS.n444 VSS.n440 17.0005
R3057 VSS.n444 VSS.n441 17.0005
R3058 VSS.n444 VSS.n438 17.0005
R3059 VSS.n445 VSS.n444 17.0005
R3060 VSS.n447 VSS.n437 17.0005
R3061 VSS.n447 VSS.n359 17.0005
R3062 VSS.n448 VSS.n447 17.0005
R3063 VSS.n447 VSS.n446 17.0005
R3064 VSS.n510 VSS.n336 17.0005
R3065 VSS.n511 VSS.n510 17.0005
R3066 VSS.n510 VSS.n334 17.0005
R3067 VSS.n510 VSS.n509 17.0005
R3068 VSS.n508 VSS.n507 17.0005
R3069 VSS.n507 VSS.n506 17.0005
R3070 VSS.n504 VSS.n342 17.0005
R3071 VSS.n505 VSS.n504 17.0005
R3072 VSS.n504 VSS.n341 17.0005
R3073 VSS.n504 VSS.n503 17.0005
R3074 VSS.n501 VSS.n346 17.0005
R3075 VSS.n501 VSS.n344 17.0005
R3076 VSS.n501 VSS.n500 17.0005
R3077 VSS.n502 VSS.n501 17.0005
R3078 VSS.n521 VSS.n330 17.0005
R3079 VSS.n522 VSS.n521 17.0005
R3080 VSS.n521 VSS.n328 17.0005
R3081 VSS.n521 VSS.n520 17.0005
R3082 VSS.n518 VSS.n512 17.0005
R3083 VSS.n518 VSS.n332 17.0005
R3084 VSS.n518 VSS.n517 17.0005
R3085 VSS.n519 VSS.n518 17.0005
R3086 VSS.n537 VSS.n324 17.0005
R3087 VSS.n538 VSS.n537 17.0005
R3088 VSS.n537 VSS.n322 17.0005
R3089 VSS.n537 VSS.n536 17.0005
R3090 VSS.n534 VSS.n523 17.0005
R3091 VSS.n534 VSS.n326 17.0005
R3092 VSS.n534 VSS.n533 17.0005
R3093 VSS.n535 VSS.n534 17.0005
R3094 VSS.n562 VSS.n312 17.0005
R3095 VSS.n563 VSS.n562 17.0005
R3096 VSS.n562 VSS.n310 17.0005
R3097 VSS.n562 VSS.n561 17.0005
R3098 VSS.n560 VSS.n559 17.0005
R3099 VSS.n559 VSS.n558 17.0005
R3100 VSS.n556 VSS.n318 17.0005
R3101 VSS.n557 VSS.n556 17.0005
R3102 VSS.n556 VSS.n317 17.0005
R3103 VSS.n556 VSS.n555 17.0005
R3104 VSS.n553 VSS.n539 17.0005
R3105 VSS.n553 VSS.n320 17.0005
R3106 VSS.n553 VSS.n552 17.0005
R3107 VSS.n554 VSS.n553 17.0005
R3108 VSS.n571 VSS.n567 17.0005
R3109 VSS.n571 VSS.n568 17.0005
R3110 VSS.n571 VSS.n565 17.0005
R3111 VSS.n572 VSS.n571 17.0005
R3112 VSS.n574 VSS.n564 17.0005
R3113 VSS.n574 VSS.n308 17.0005
R3114 VSS.n575 VSS.n574 17.0005
R3115 VSS.n574 VSS.n573 17.0005
R3116 VSS.n685 VSS.n253 17.0005
R3117 VSS.n686 VSS.n685 17.0005
R3118 VSS.n685 VSS.n251 17.0005
R3119 VSS.n685 VSS.n684 17.0005
R3120 VSS.n682 VSS.n257 17.0005
R3121 VSS.n682 VSS.n255 17.0005
R3122 VSS.n682 VSS.n681 17.0005
R3123 VSS.n683 VSS.n682 17.0005
R3124 VSS.n688 VSS.n246 17.0005
R3125 VSS.n688 VSS.n687 17.0005
R3126 VSS.n691 VSS.n244 17.0005
R3127 VSS.n692 VSS.n691 17.0005
R3128 VSS.n691 VSS.n243 17.0005
R3129 VSS.n691 VSS.n690 17.0005
R3130 VSS.n695 VSS.n694 17.0005
R3131 VSS.n694 VSS.n693 17.0005
R3132 VSS.n393 VSS.n389 17.0005
R3133 VSS.n393 VSS.n390 17.0005
R3134 VSS.n393 VSS.n387 17.0005
R3135 VSS.n394 VSS.n393 17.0005
R3136 VSS.n397 VSS.n396 17.0005
R3137 VSS.n396 VSS.n382 17.0005
R3138 VSS.n396 VSS.n386 17.0005
R3139 VSS.n396 VSS.n395 17.0005
R3140 VSS.n625 VSS.n279 17.0005
R3141 VSS.n626 VSS.n625 17.0005
R3142 VSS.n625 VSS.n277 17.0005
R3143 VSS.n625 VSS.n624 17.0005
R3144 VSS.n622 VSS.n283 17.0005
R3145 VSS.n622 VSS.n281 17.0005
R3146 VSS.n622 VSS.n621 17.0005
R3147 VSS.n623 VSS.n622 17.0005
R3148 VSS.n628 VSS.n275 17.0005
R3149 VSS.n629 VSS.n628 17.0005
R3150 VSS.n628 VSS.n273 17.0005
R3151 VSS.n628 VSS.n627 17.0005
R3152 VSS.n631 VSS.n271 17.0005
R3153 VSS.n632 VSS.n631 17.0005
R3154 VSS.n631 VSS.n270 17.0005
R3155 VSS.n631 VSS.n630 17.0005
R3156 VSS.n659 VSS.n265 17.0005
R3157 VSS.n659 VSS.n656 17.0005
R3158 VSS.n402 VSS.n398 17.0005
R3159 VSS.n403 VSS.n402 17.0005
R3160 VSS.n901 VSS.n3 17.0005
R3161 VSS.n901 VSS.n2 17.0005
R3162 VSS.n902 VSS.n901 17.0005
R3163 VSS.n901 VSS.n900 17.0005
R3164 VSS.n898 VSS.n5 17.0005
R3165 VSS.n898 VSS.n896 17.0005
R3166 VSS.n898 VSS 17.0005
R3167 VSS.n898 VSS.n4 17.0005
R3168 VSS.n898 VSS.n897 17.0005
R3169 VSS.n899 VSS.n898 17.0005
R3170 VSS.n891 VSS.n11 17.0005
R3171 VSS.n891 VSS.n889 17.0005
R3172 VSS.n891 VSS 17.0005
R3173 VSS.n891 VSS.n10 17.0005
R3174 VSS.n891 VSS.n890 17.0005
R3175 VSS.n892 VSS.n891 17.0005
R3176 VSS.n895 VSS.n894 17.0005
R3177 VSS.n894 VSS.n6 17.0005
R3178 VSS.n894 VSS.n9 17.0005
R3179 VSS.n894 VSS.n893 17.0005
R3180 VSS.n875 VSS.n20 17.0005
R3181 VSS.n876 VSS.n875 17.0005
R3182 VSS.n880 VSS.n19 17.0005
R3183 VSS.n880 VSS.n877 17.0005
R3184 VSS.n880 VSS.n18 17.0005
R3185 VSS.n881 VSS.n880 17.0005
R3186 VSS.n884 VSS.n17 17.0005
R3187 VSS.n884 VSS.n882 17.0005
R3188 VSS.n884 VSS 17.0005
R3189 VSS.n884 VSS.n16 17.0005
R3190 VSS.n884 VSS.n883 17.0005
R3191 VSS.n885 VSS.n884 17.0005
R3192 VSS.n888 VSS.n887 17.0005
R3193 VSS.n887 VSS.n12 17.0005
R3194 VSS.n887 VSS.n15 17.0005
R3195 VSS.n887 VSS.n886 17.0005
R3196 VSS.n870 VSS.n22 17.0005
R3197 VSS.n870 VSS.n21 17.0005
R3198 VSS.n870 VSS.n23 17.0005
R3199 VSS.n870 VSS.n869 17.0005
R3200 VSS.n867 VSS.n25 17.0005
R3201 VSS.n867 VSS.n26 17.0005
R3202 VSS.n867 VSS 17.0005
R3203 VSS.n867 VSS.n24 17.0005
R3204 VSS.n867 VSS.n866 17.0005
R3205 VSS.n868 VSS.n867 17.0005
R3206 VSS.n612 VSS.n291 17.0005
R3207 VSS.n612 VSS.n610 17.0005
R3208 VSS.n612 VSS 17.0005
R3209 VSS.n612 VSS.n290 17.0005
R3210 VSS.n612 VSS.n611 17.0005
R3211 VSS.n613 VSS.n612 17.0005
R3212 VSS.n615 VSS.n289 17.0005
R3213 VSS.n615 VSS.n286 17.0005
R3214 VSS.n616 VSS.n615 17.0005
R3215 VSS.n615 VSS.n614 17.0005
R3216 VSS.n596 VSS.n300 17.0005
R3217 VSS.n597 VSS.n596 17.0005
R3218 VSS.n601 VSS.n299 17.0005
R3219 VSS.n601 VSS.n598 17.0005
R3220 VSS.n601 VSS.n298 17.0005
R3221 VSS.n602 VSS.n601 17.0005
R3222 VSS.n605 VSS.n297 17.0005
R3223 VSS.n605 VSS.n603 17.0005
R3224 VSS.n605 VSS 17.0005
R3225 VSS.n605 VSS.n296 17.0005
R3226 VSS.n605 VSS.n604 17.0005
R3227 VSS.n606 VSS.n605 17.0005
R3228 VSS.n609 VSS.n608 17.0005
R3229 VSS.n608 VSS.n292 17.0005
R3230 VSS.n608 VSS.n295 17.0005
R3231 VSS.n608 VSS.n607 17.0005
R3232 VSS.n591 VSS.n302 17.0005
R3233 VSS.n591 VSS.n301 17.0005
R3234 VSS.n591 VSS.n303 17.0005
R3235 VSS.n591 VSS.n590 17.0005
R3236 VSS.n588 VSS.n306 17.0005
R3237 VSS.n588 VSS.n307 17.0005
R3238 VSS.n588 VSS 17.0005
R3239 VSS.n588 VSS.n304 17.0005
R3240 VSS.n588 VSS.n587 17.0005
R3241 VSS.n589 VSS.n588 17.0005
R3242 VSS.n663 VSS.n263 17.0005
R3243 VSS.n663 VSS.n661 17.0005
R3244 VSS.n663 VSS 17.0005
R3245 VSS.n663 VSS.n262 17.0005
R3246 VSS.n663 VSS.n662 17.0005
R3247 VSS.n664 VSS.n663 17.0005
R3248 VSS.n666 VSS.n261 17.0005
R3249 VSS.n666 VSS.n259 17.0005
R3250 VSS.n667 VSS.n666 17.0005
R3251 VSS.n666 VSS.n665 17.0005
R3252 VSS.n659 VSS.n264 17.0005
R3253 VSS.n660 VSS.n659 17.0005
R3254 VSS.n654 VSS.n267 17.0005
R3255 VSS.n654 VSS.n652 17.0005
R3256 VSS.n654 VSS 17.0005
R3257 VSS.n654 VSS.n266 17.0005
R3258 VSS.n654 VSS.n653 17.0005
R3259 VSS.n655 VSS.n654 17.0005
R3260 VSS.n650 VSS.n269 17.0005
R3261 VSS.n650 VSS.n647 17.0005
R3262 VSS.n650 VSS.n268 17.0005
R3263 VSS.n651 VSS.n650 17.0005
R3264 VSS VSS.t612 16.0687
R3265 VSS.n834 VSS.t610 15.9923
R3266 VSS.n476 VSS.t611 15.9923
R3267 VSS.n385 VSS.n358 14.735
R3268 VSS.n619 VSS.n618 14.735
R3269 VSS.n669 VSS.n258 14.735
R3270 VSS.n429 VSS.n428 13.9411
R3271 VSS.n498 VSS.n497 13.9411
R3272 VSS.n515 VSS.n514 13.9411
R3273 VSS.n531 VSS.n530 13.9411
R3274 VSS.n550 VSS.n549 13.9411
R3275 VSS.n578 VSS.n576 13.9411
R3276 VSS.n679 VSS.n678 13.9411
R3277 VSS.n249 VSS.n65 13.9411
R3278 VSS.n451 VSS.n449 13.9411
R3279 VSS.n421 VSS.n1 13.9411
R3280 VSS.n490 VSS.n347 13.9411
R3281 VSS.n865 VSS.n864 13.9411
R3282 VSS.n542 VSS.n540 13.9411
R3283 VSS.n586 VSS.n585 13.9411
R3284 VSS.n808 VSS.n64 13.9411
R3285 VSS.n807 VSS.n806 13.5005
R3286 VSS.n676 VSS.n675 13.5005
R3287 VSS.n583 VSS.n582 13.5005
R3288 VSS.n578 VSS.n577 13.5005
R3289 VSS.n547 VSS.n546 13.5005
R3290 VSS.n528 VSS.n527 13.5005
R3291 VSS.n138 VSS.n27 13.5005
R3292 VSS.n514 VSS.n513 13.5005
R3293 VSS.n495 VSS.n494 13.5005
R3294 VSS.n497 VSS.n496 13.5005
R3295 VSS.n530 VSS.n529 13.5005
R3296 VSS.n549 VSS.n548 13.5005
R3297 VSS.n678 VSS.n677 13.5005
R3298 VSS.n707 VSS.n65 13.5005
R3299 VSS.n428 VSS.n427 13.5005
R3300 VSS.n426 VSS.n425 13.5005
R3301 VSS.n421 VSS.n420 13.5005
R3302 VSS.n490 VSS.n489 13.5005
R3303 VSS.n864 VSS.n863 13.5005
R3304 VSS.n285 VSS.n284 13.5005
R3305 VSS.n542 VSS.n541 13.5005
R3306 VSS.n585 VSS.n584 13.5005
R3307 VSS.n671 VSS.n670 13.5005
R3308 VSS.n809 VSS.n808 13.5005
R3309 VSS.n451 VSS.n450 13.5005
R3310 VSS.n456 VSS.n455 13.5005
R3311 VSS.n458 VSS.n457 13.5005
R3312 VSS.n358 VSS.n357 13.5005
R3313 VSS.n618 VSS.n617 13.5005
R3314 VSS.n669 VSS.n668 13.5005
R3315 VSS.n406 VSS.n381 8.45768
R3316 VSS.n415 VSS.n414 8.45768
R3317 VSS.n464 VSS.n353 8.45768
R3318 VSS.n484 VSS.n483 8.45768
R3319 VSS.n474 VSS.n473 8.45768
R3320 VSS.n479 VSS.n478 8.45768
R3321 VSS.n858 VSS.n857 8.45768
R3322 VSS.n850 VSS.n849 8.45768
R3323 VSS.n842 VSS.n841 8.45768
R3324 VSS.n832 VSS.n831 8.45768
R3325 VSS.n837 VSS.n836 8.45768
R3326 VSS.n825 VSS.n824 8.45768
R3327 VSS.n817 VSS.n816 8.45768
R3328 VSS.n812 VSS.n811 8.45768
R3329 VSS.n640 VSS.n638 8.45768
R3330 VSS.n643 VSS.n634 8.45768
R3331 VSS.n791 VSS.n790 8.45768
R3332 VSS.n760 VSS.n759 8.45768
R3333 VSS.n765 VSS.n764 8.45768
R3334 VSS.n729 VSS.n728 8.45768
R3335 VSS.n734 VSS.n733 8.45768
R3336 VSS.n710 VSS.n709 8.45768
R3337 VSS.n700 VSS.n699 8.45768
R3338 VSS.n372 VSS.n371 8.45768
R3339 VSS.n435 VSS.n364 8.45768
R3340 VSS.n444 VSS.n443 8.45768
R3341 VSS.n510 VSS.n337 8.45768
R3342 VSS.n507 VSS.n340 8.45768
R3343 VSS.n504 VSS.n343 8.45768
R3344 VSS.n521 VSS.n331 8.45768
R3345 VSS.n537 VSS.n325 8.45768
R3346 VSS.n562 VSS.n313 8.45768
R3347 VSS.n559 VSS.n316 8.45768
R3348 VSS.n556 VSS.n319 8.45768
R3349 VSS.n571 VSS.n570 8.45768
R3350 VSS.n685 VSS.n254 8.45768
R3351 VSS.n688 VSS.n250 8.45768
R3352 VSS.n691 VSS.n245 8.45768
R3353 VSS.n694 VSS.n242 8.45768
R3354 VSS.n393 VSS.n392 8.45768
R3355 VSS.n625 VSS.n280 8.45768
R3356 VSS.n628 VSS.n276 8.45768
R3357 VSS.n631 VSS.n272 8.45768
R3358 VSS.n402 VSS.n401 8.45768
R3359 VSS.n875 VSS.n874 8.45768
R3360 VSS.n880 VSS.n879 8.45768
R3361 VSS.n596 VSS.n595 8.45768
R3362 VSS.n601 VSS.n600 8.45768
R3363 VSS.n659 VSS.n658 8.45768
R3364 VSS.n650 VSS.n649 8.45768
R3365 VSS.n418 VSS.n376 8.45768
R3366 VSS.n461 VSS.n355 8.45768
R3367 VSS.n487 VSS.n349 8.45768
R3368 VSS.n861 VSS.n29 8.45768
R3369 VSS.n853 VSS.n35 8.45768
R3370 VSS.n845 VSS.n41 8.45768
R3371 VSS.n828 VSS.n51 8.45768
R3372 VSS.n820 VSS.n57 8.45768
R3373 VSS.n787 VSS.n786 8.45768
R3374 VSS.n779 VSS.n190 8.45768
R3375 VSS.n772 VSS.n196 8.45768
R3376 VSS.n756 VSS.n755 8.45768
R3377 VSS.n748 VSS.n210 8.45768
R3378 VSS.n741 VSS.n216 8.45768
R3379 VSS.n725 VSS.n724 8.45768
R3380 VSS.n717 VSS.n230 8.45768
R3381 VSS.n432 VSS.n366 8.45768
R3382 VSS.n447 VSS.n360 8.45768
R3383 VSS.n501 VSS.n345 8.45768
R3384 VSS.n518 VSS.n333 8.45768
R3385 VSS.n534 VSS.n327 8.45768
R3386 VSS.n553 VSS.n321 8.45768
R3387 VSS.n574 VSS.n309 8.45768
R3388 VSS.n682 VSS.n256 8.45768
R3389 VSS.n396 VSS.n384 8.45768
R3390 VSS.n622 VSS.n282 8.45768
R3391 VSS.n901 VSS.n0 8.45768
R3392 VSS.n894 VSS.n8 8.45768
R3393 VSS.n887 VSS.n14 8.45768
R3394 VSS.n871 VSS.n870 8.45768
R3395 VSS.n615 VSS.n288 8.45768
R3396 VSS.n608 VSS.n294 8.45768
R3397 VSS.n592 VSS.n591 8.45768
R3398 VSS.n666 VSS.n260 8.45768
R3399 VSS.n796 VSS.n156 8.4148
R3400 VSS.n796 VSS.n167 8.4148
R3401 VSS.n796 VSS.n147 8.4148
R3402 VSS.n796 VSS.n179 8.4148
R3403 VSS.n800 VSS.n115 8.4148
R3404 VSS.n800 VSS.n126 8.4148
R3405 VSS.n800 VSS.n106 8.4148
R3406 VSS.n800 VSS.n142 8.4148
R3407 VSS.n804 VSS.n85 8.4148
R3408 VSS.n804 VSS.n91 8.4148
R3409 VSS.n804 VSS.n76 8.4148
R3410 VSS.n804 VSS.n103 8.4148
R3411 VSS.n808 VSS.n807 0.775529
R3412 VSS.n676 VSS.n671 0.775529
R3413 VSS.n585 VSS.n583 0.775529
R3414 VSS.n547 VSS.n542 0.775529
R3415 VSS.n528 VSS.n285 0.775529
R3416 VSS.n864 VSS.n27 0.775529
R3417 VSS.n495 VSS.n490 0.775529
R3418 VSS.n426 VSS.n421 0.775529
R3419 VSS.n457 VSS.n456 0.775529
R3420 VSS.n103 VSS.n102 0.486213
R3421 VSS.n85 VSS.n84 0.486213
R3422 VSS.n142 VSS.n141 0.486213
R3423 VSS.n115 VSS.n114 0.486213
R3424 VSS.n179 VSS.n178 0.486213
R3425 VSS.n156 VSS.n155 0.486213
R3426 VSS.n671 VSS.n669 0.441129
R3427 VSS.n618 VSS.n285 0.441129
R3428 VSS.n457 VSS.n358 0.441129
R3429 VSS.n807 VSS.n65 0.437357
R3430 VSS.n678 VSS.n676 0.437357
R3431 VSS.n583 VSS.n578 0.437357
R3432 VSS.n549 VSS.n547 0.437357
R3433 VSS.n530 VSS.n528 0.437357
R3434 VSS.n514 VSS.n27 0.437357
R3435 VSS.n497 VSS.n495 0.437357
R3436 VSS.n428 VSS.n426 0.437357
R3437 VSS.n456 VSS.n451 0.437357
R3438 VSS.n102 VSS.n101 0.351125
R3439 VSS.n580 VSS.n579 0.351125
R3440 VSS.n95 VSS.n94 0.351125
R3441 VSS.n97 VSS.n96 0.351125
R3442 VSS.n673 VSS.n672 0.351125
R3443 VSS.n79 VSS.n78 0.351125
R3444 VSS.n89 VSS.n88 0.351125
R3445 VSS.n67 VSS.n66 0.351125
R3446 VSS.n70 VSS.n69 0.351125
R3447 VSS.n72 VSS.n71 0.351125
R3448 VSS.n84 VSS.n83 0.351125
R3449 VSS.n141 VSS.n140 0.351125
R3450 VSS.n137 VSS.n136 0.351125
R3451 VSS.n130 VSS.n129 0.351125
R3452 VSS.n132 VSS.n131 0.351125
R3453 VSS.n525 VSS.n524 0.351125
R3454 VSS.n109 VSS.n108 0.351125
R3455 VSS.n124 VSS.n123 0.351125
R3456 VSS.n544 VSS.n543 0.351125
R3457 VSS.n117 VSS.n116 0.351125
R3458 VSS.n119 VSS.n118 0.351125
R3459 VSS.n114 VSS.n113 0.351125
R3460 VSS.n178 VSS.n177 0.351125
R3461 VSS.n423 VSS.n422 0.351125
R3462 VSS.n171 VSS.n170 0.351125
R3463 VSS.n173 VSS.n172 0.351125
R3464 VSS.n453 VSS.n452 0.351125
R3465 VSS.n150 VSS.n149 0.351125
R3466 VSS.n165 VSS.n164 0.351125
R3467 VSS.n492 VSS.n491 0.351125
R3468 VSS.n158 VSS.n157 0.351125
R3469 VSS.n160 VSS.n159 0.351125
R3470 VSS.n155 VSS.n154 0.351125
R3471 VSS.n99 VSS.n98 0.348833
R3472 VSS.n90 VSS.n80 0.348833
R3473 VSS.n805 VSS.n73 0.348833
R3474 VSS.n134 VSS.n133 0.348833
R3475 VSS.n125 VSS.n110 0.348833
R3476 VSS.n121 VSS.n120 0.348833
R3477 VSS.n175 VSS.n174 0.348833
R3478 VSS.n166 VSS.n151 0.348833
R3479 VSS.n162 VSS.n161 0.348833
R3480 VSS.n581 VSS.n580 0.313313
R3481 VSS.n99 VSS.n95 0.313313
R3482 VSS.n98 VSS.n97 0.313313
R3483 VSS.n674 VSS.n673 0.313313
R3484 VSS.n80 VSS.n79 0.313313
R3485 VSS.n90 VSS.n89 0.313313
R3486 VSS.n68 VSS.n67 0.313313
R3487 VSS.n805 VSS.n70 0.313313
R3488 VSS.n73 VSS.n72 0.313313
R3489 VSS.n139 VSS.n137 0.313313
R3490 VSS.n134 VSS.n130 0.313313
R3491 VSS.n133 VSS.n132 0.313313
R3492 VSS.n526 VSS.n525 0.313313
R3493 VSS.n110 VSS.n109 0.313313
R3494 VSS.n125 VSS.n124 0.313313
R3495 VSS.n545 VSS.n544 0.313313
R3496 VSS.n121 VSS.n117 0.313313
R3497 VSS.n120 VSS.n119 0.313313
R3498 VSS.n424 VSS.n423 0.313313
R3499 VSS.n175 VSS.n171 0.313313
R3500 VSS.n174 VSS.n173 0.313313
R3501 VSS.n454 VSS.n453 0.313313
R3502 VSS.n151 VSS.n150 0.313313
R3503 VSS.n166 VSS.n165 0.313313
R3504 VSS.n493 VSS.n492 0.313313
R3505 VSS.n162 VSS.n158 0.313313
R3506 VSS.n161 VSS.n160 0.313313
R3507 VSS.n582 VSS.n99 0.283139
R3508 VSS.n138 VSS.n134 0.283139
R3509 VSS.n425 VSS.n175 0.283139
R3510 VSS.n806 VSS.n68 0.255639
R3511 VSS.n546 VSS.n545 0.255639
R3512 VSS.n494 VSS.n493 0.255639
R3513 VSS.n790 VSS 0.228195
R3514 VSS.n759 VSS 0.228195
R3515 VSS.n728 VSS 0.228195
R3516 VSS.n478 VSS 0.228195
R3517 VSS.n836 VSS 0.228195
R3518 VSS VSS.n634 0.228195
R3519 VSS VSS.n340 0.228195
R3520 VSS VSS.n316 0.228195
R3521 VSS VSS.n242 0.228195
R3522 VSS.n401 VSS 0.228195
R3523 VSS.n874 VSS 0.228195
R3524 VSS.n595 VSS 0.228195
R3525 VSS.n675 VSS.n80 0.228139
R3526 VSS.n527 VSS.n110 0.228139
R3527 VSS.n455 VSS.n151 0.228139
R3528 VSS.n98 VSS.n76 0.1734
R3529 VSS.n91 VSS.n90 0.1734
R3530 VSS.n85 VSS.n73 0.1734
R3531 VSS.n133 VSS.n106 0.1734
R3532 VSS.n126 VSS.n125 0.1734
R3533 VSS.n120 VSS.n115 0.1734
R3534 VSS.n174 VSS.n147 0.1734
R3535 VSS.n167 VSS.n166 0.1734
R3536 VSS.n161 VSS.n156 0.1734
R3537 VSS.n493 VSS.n167 0.1734
R3538 VSS.n454 VSS.n147 0.1734
R3539 VSS.n424 VSS.n179 0.1734
R3540 VSS.n545 VSS.n126 0.1734
R3541 VSS.n526 VSS.n106 0.1734
R3542 VSS.n142 VSS.n139 0.1734
R3543 VSS.n91 VSS.n68 0.1734
R3544 VSS.n674 VSS.n76 0.1734
R3545 VSS.n581 VSS.n103 0.1734
R3546 VSS.n782 VSS 0.157861
R3547 VSS.n775 VSS 0.157861
R3548 VSS.n768 VSS 0.157861
R3549 VSS.n751 VSS 0.157861
R3550 VSS.n744 VSS 0.157861
R3551 VSS.n737 VSS 0.157861
R3552 VSS.n720 VSS 0.157861
R3553 VSS.n713 VSS 0.157861
R3554 VSS.n703 VSS 0.157861
R3555 VSS.n897 VSS 0.157861
R3556 VSS.n890 VSS 0.157861
R3557 VSS.n883 VSS 0.157861
R3558 VSS.n866 VSS 0.157861
R3559 VSS.n611 VSS 0.157861
R3560 VSS.n604 VSS 0.157861
R3561 VSS.n587 VSS 0.157861
R3562 VSS.n662 VSS 0.157861
R3563 VSS.n653 VSS 0.157861
R3564 VSS.n675 VSS.n674 0.121194
R3565 VSS.n527 VSS.n526 0.121194
R3566 VSS.n455 VSS.n454 0.121194
R3567 VSS.n357 VSS 0.102861
R3568 VSS.n347 VSS 0.102861
R3569 VSS.n617 VSS 0.102861
R3570 VSS.n540 VSS 0.102861
R3571 VSS.n668 VSS 0.102861
R3572 VSS VSS.n64 0.102861
R3573 VSS.n806 VSS.n805 0.0936944
R3574 VSS.n546 VSS.n121 0.0936944
R3575 VSS.n494 VSS.n162 0.0936944
R3576 VSS.n790 VSS.n789 0.0876395
R3577 VSS.n764 VSS.n763 0.0876395
R3578 VSS.n759 VSS.n758 0.0876395
R3579 VSS.n733 VSS.n732 0.0876395
R3580 VSS.n728 VSS.n727 0.0876395
R3581 VSS.n709 VSS.n708 0.0876395
R3582 VSS.n699 VSS.n698 0.0876395
R3583 VSS.n381 VSS.n380 0.0876395
R3584 VSS.n414 VSS.n413 0.0876395
R3585 VSS.n459 VSS.n353 0.0876395
R3586 VSS.n483 VSS.n482 0.0876395
R3587 VSS.n475 VSS.n474 0.0876395
R3588 VSS.n857 VSS.n856 0.0876395
R3589 VSS.n849 VSS.n848 0.0876395
R3590 VSS.n841 VSS.n840 0.0876395
R3591 VSS.n833 VSS.n832 0.0876395
R3592 VSS.n824 VSS.n823 0.0876395
R3593 VSS.n816 VSS.n815 0.0876395
R3594 VSS.n811 VSS.n810 0.0876395
R3595 VSS.n638 VSS.n637 0.0876395
R3596 VSS.n381 VSS 0.0876395
R3597 VSS.n414 VSS 0.0876395
R3598 VSS.n353 VSS 0.0876395
R3599 VSS.n483 VSS 0.0876395
R3600 VSS.n474 VSS 0.0876395
R3601 VSS.n478 VSS.n477 0.0876395
R3602 VSS.n857 VSS 0.0876395
R3603 VSS.n849 VSS 0.0876395
R3604 VSS.n841 VSS 0.0876395
R3605 VSS.n832 VSS 0.0876395
R3606 VSS.n836 VSS.n835 0.0876395
R3607 VSS.n824 VSS 0.0876395
R3608 VSS.n816 VSS 0.0876395
R3609 VSS.n811 VSS 0.0876395
R3610 VSS.n638 VSS 0.0876395
R3611 VSS.n634 VSS.n633 0.0876395
R3612 VSS.n764 VSS 0.0876395
R3613 VSS.n733 VSS 0.0876395
R3614 VSS.n709 VSS 0.0876395
R3615 VSS.n699 VSS 0.0876395
R3616 VSS.n371 VSS.n370 0.0876395
R3617 VSS.n430 VSS.n364 0.0876395
R3618 VSS.n443 VSS.n442 0.0876395
R3619 VSS.n499 VSS.n343 0.0876395
R3620 VSS.n338 VSS.n337 0.0876395
R3621 VSS.n516 VSS.n331 0.0876395
R3622 VSS.n532 VSS.n325 0.0876395
R3623 VSS.n551 VSS.n319 0.0876395
R3624 VSS.n314 VSS.n313 0.0876395
R3625 VSS.n570 VSS.n569 0.0876395
R3626 VSS.n680 VSS.n254 0.0876395
R3627 VSS.n252 VSS.n250 0.0876395
R3628 VSS.n247 VSS.n245 0.0876395
R3629 VSS.n371 VSS 0.0876395
R3630 VSS.n364 VSS 0.0876395
R3631 VSS.n443 VSS 0.0876395
R3632 VSS.n337 VSS 0.0876395
R3633 VSS.n340 VSS.n339 0.0876395
R3634 VSS.n343 VSS 0.0876395
R3635 VSS.n331 VSS 0.0876395
R3636 VSS.n325 VSS 0.0876395
R3637 VSS.n313 VSS 0.0876395
R3638 VSS.n316 VSS.n315 0.0876395
R3639 VSS.n319 VSS 0.0876395
R3640 VSS.n570 VSS 0.0876395
R3641 VSS.n254 VSS 0.0876395
R3642 VSS.n250 VSS 0.0876395
R3643 VSS.n245 VSS 0.0876395
R3644 VSS.n242 VSS.n241 0.0876395
R3645 VSS.n392 VSS.n391 0.0876395
R3646 VSS.n620 VSS.n280 0.0876395
R3647 VSS.n278 VSS.n276 0.0876395
R3648 VSS.n274 VSS.n272 0.0876395
R3649 VSS.n392 VSS 0.0876395
R3650 VSS.n280 VSS 0.0876395
R3651 VSS.n276 VSS 0.0876395
R3652 VSS.n272 VSS 0.0876395
R3653 VSS.n401 VSS.n400 0.0876395
R3654 VSS.n879 VSS.n878 0.0876395
R3655 VSS.n874 VSS.n873 0.0876395
R3656 VSS.n600 VSS.n599 0.0876395
R3657 VSS.n595 VSS.n594 0.0876395
R3658 VSS.n658 VSS.n657 0.0876395
R3659 VSS.n649 VSS.n648 0.0876395
R3660 VSS.n879 VSS 0.0876395
R3661 VSS.n600 VSS 0.0876395
R3662 VSS.n658 VSS 0.0876395
R3663 VSS.n649 VSS 0.0876395
R3664 VSS.n787 VSS 0.0876395
R3665 VSS VSS.n190 0.0876395
R3666 VSS VSS.n196 0.0876395
R3667 VSS.n756 VSS 0.0876395
R3668 VSS VSS.n210 0.0876395
R3669 VSS VSS.n216 0.0876395
R3670 VSS.n725 VSS 0.0876395
R3671 VSS VSS.n230 0.0876395
R3672 VSS.n376 VSS 0.0876395
R3673 VSS VSS.n355 0.0876395
R3674 VSS.n349 VSS 0.0876395
R3675 VSS.n29 VSS 0.0876395
R3676 VSS VSS.n35 0.0876395
R3677 VSS VSS.n41 0.0876395
R3678 VSS VSS.n51 0.0876395
R3679 VSS VSS.n57 0.0876395
R3680 VSS.n378 VSS.n376 0.0876395
R3681 VSS.n410 VSS.n355 0.0876395
R3682 VSS.n351 VSS.n349 0.0876395
R3683 VSS.n470 VSS.n29 0.0876395
R3684 VSS.n35 VSS.n34 0.0876395
R3685 VSS.n41 VSS.n40 0.0876395
R3686 VSS.n51 VSS.n50 0.0876395
R3687 VSS.n57 VSS.n56 0.0876395
R3688 VSS.n788 VSS.n787 0.0876395
R3689 VSS.n190 VSS.n189 0.0876395
R3690 VSS.n196 VSS.n195 0.0876395
R3691 VSS.n757 VSS.n756 0.0876395
R3692 VSS.n210 VSS.n209 0.0876395
R3693 VSS.n216 VSS.n215 0.0876395
R3694 VSS.n726 VSS.n725 0.0876395
R3695 VSS.n230 VSS.n229 0.0876395
R3696 VSS VSS.n366 0.0876395
R3697 VSS.n360 VSS 0.0876395
R3698 VSS VSS.n345 0.0876395
R3699 VSS VSS.n333 0.0876395
R3700 VSS VSS.n327 0.0876395
R3701 VSS VSS.n321 0.0876395
R3702 VSS.n309 VSS 0.0876395
R3703 VSS VSS.n256 0.0876395
R3704 VSS.n368 VSS.n366 0.0876395
R3705 VSS.n362 VSS.n360 0.0876395
R3706 VSS.n439 VSS.n345 0.0876395
R3707 VSS.n335 VSS.n333 0.0876395
R3708 VSS.n329 VSS.n327 0.0876395
R3709 VSS.n323 VSS.n321 0.0876395
R3710 VSS.n311 VSS.n309 0.0876395
R3711 VSS.n566 VSS.n256 0.0876395
R3712 VSS VSS.n384 0.0876395
R3713 VSS VSS.n282 0.0876395
R3714 VSS.n384 VSS.n383 0.0876395
R3715 VSS.n388 VSS.n282 0.0876395
R3716 VSS VSS.n0 0.0876395
R3717 VSS VSS.n8 0.0876395
R3718 VSS VSS.n14 0.0876395
R3719 VSS.n871 VSS 0.0876395
R3720 VSS.n288 VSS 0.0876395
R3721 VSS VSS.n294 0.0876395
R3722 VSS.n592 VSS 0.0876395
R3723 VSS.n260 VSS 0.0876395
R3724 VSS.n399 VSS.n0 0.0876395
R3725 VSS.n8 VSS.n7 0.0876395
R3726 VSS.n14 VSS.n13 0.0876395
R3727 VSS.n872 VSS.n871 0.0876395
R3728 VSS.n288 VSS.n287 0.0876395
R3729 VSS.n294 VSS.n293 0.0876395
R3730 VSS.n593 VSS.n592 0.0876395
R3731 VSS.n305 VSS.n260 0.0876395
R3732 VSS.n385 VSS 0.0875833
R3733 VSS.n619 VSS 0.0875833
R3734 VSS VSS.n258 0.0875833
R3735 VSS VSS.n429 0.0799444
R3736 VSS.n449 VSS 0.0799444
R3737 VSS VSS.n498 0.0799444
R3738 VSS VSS.n515 0.0799444
R3739 VSS VSS.n531 0.0799444
R3740 VSS VSS.n550 0.0799444
R3741 VSS.n576 VSS 0.0799444
R3742 VSS VSS.n679 0.0799444
R3743 VSS.n249 VSS 0.0799444
R3744 VSS.n450 VSS 0.0768889
R3745 VSS.n496 VSS 0.0768889
R3746 VSS.n529 VSS 0.0768889
R3747 VSS.n548 VSS 0.0768889
R3748 VSS.n677 VSS 0.0768889
R3749 VSS VSS.n707 0.0768889
R3750 VSS.n476 VSS 0.0768889
R3751 VSS.n834 VSS 0.0768889
R3752 VSS.n420 VSS 0.0707778
R3753 VSS.n458 VSS 0.0707778
R3754 VSS.n489 VSS 0.0707778
R3755 VSS.n863 VSS 0.0707778
R3756 VSS.n284 VSS 0.0707778
R3757 VSS.n541 VSS 0.0707778
R3758 VSS.n584 VSS 0.0707778
R3759 VSS.n670 VSS 0.0707778
R3760 VSS VSS.n809 0.0707778
R3761 VSS.n582 VSS.n581 0.0661944
R3762 VSS.n139 VSS.n138 0.0661944
R3763 VSS.n425 VSS.n424 0.0661944
R3764 VSS.n450 VSS 0.0646667
R3765 VSS.n496 VSS 0.0646667
R3766 VSS.n529 VSS 0.0646667
R3767 VSS.n548 VSS 0.0646667
R3768 VSS.n677 VSS 0.0646667
R3769 VSS.n707 VSS 0.0646667
R3770 VSS.n420 VSS 0.0539722
R3771 VSS VSS.n458 0.0539722
R3772 VSS.n489 VSS 0.0539722
R3773 VSS.n863 VSS 0.0539722
R3774 VSS.n284 VSS 0.0539722
R3775 VSS.n541 VSS 0.0539722
R3776 VSS.n584 VSS 0.0539722
R3777 VSS.n670 VSS 0.0539722
R3778 VSS.n809 VSS 0.0539722
R3779 VSS VSS.n385 0.0539722
R3780 VSS VSS.n619 0.0539722
R3781 VSS VSS.n258 0.0539722
R3782 VSS VSS.n476 0.0463333
R3783 VSS VSS.n834 0.0463333
R3784 VSS.n429 VSS 0.0448056
R3785 VSS.n449 VSS 0.0448056
R3786 VSS.n498 VSS 0.0448056
R3787 VSS.n515 VSS 0.0448056
R3788 VSS.n531 VSS 0.0448056
R3789 VSS.n550 VSS 0.0448056
R3790 VSS.n576 VSS 0.0448056
R3791 VSS.n679 VSS 0.0448056
R3792 VSS VSS.n249 0.0448056
R3793 VSS.n357 VSS 0.0386944
R3794 VSS.n347 VSS 0.0386944
R3795 VSS.n617 VSS 0.0386944
R3796 VSS.n540 VSS 0.0386944
R3797 VSS.n668 VSS 0.0386944
R3798 VSS VSS.n64 0.0386944
R3799 VSS.n187 VSS 0.0341111
R3800 VSS VSS.n191 0.0341111
R3801 VSS.n193 VSS 0.0341111
R3802 VSS VSS.n197 0.0341111
R3803 VSS.n199 VSS 0.0341111
R3804 VSS VSS.n201 0.0341111
R3805 VSS.n207 VSS 0.0341111
R3806 VSS VSS.n211 0.0341111
R3807 VSS.n213 VSS 0.0341111
R3808 VSS VSS.n217 0.0341111
R3809 VSS.n219 VSS 0.0341111
R3810 VSS VSS.n221 0.0341111
R3811 VSS.n227 VSS 0.0341111
R3812 VSS VSS.n231 0.0341111
R3813 VSS.n233 VSS 0.0341111
R3814 VSS VSS.n235 0.0341111
R3815 VSS.n237 VSS 0.0341111
R3816 VSS VSS.n239 0.0341111
R3817 VSS VSS.n379 0.0341111
R3818 VSS VSS.n419 0.0341111
R3819 VSS VSS.n411 0.0341111
R3820 VSS.n460 VSS 0.0341111
R3821 VSS VSS.n352 0.0341111
R3822 VSS VSS.n488 0.0341111
R3823 VSS VSS.n468 0.0341111
R3824 VSS.n471 VSS 0.0341111
R3825 VSS VSS.n862 0.0341111
R3826 VSS VSS.n32 0.0341111
R3827 VSS VSS.n36 0.0341111
R3828 VSS VSS.n38 0.0341111
R3829 VSS VSS.n42 0.0341111
R3830 VSS VSS.n44 0.0341111
R3831 VSS.n48 VSS 0.0341111
R3832 VSS VSS.n52 0.0341111
R3833 VSS VSS.n54 0.0341111
R3834 VSS VSS.n58 0.0341111
R3835 VSS VSS.n60 0.0341111
R3836 VSS VSS.n62 0.0341111
R3837 VSS VSS.n636 0.0341111
R3838 VSS VSS.n369 0.0341111
R3839 VSS.n431 VSS 0.0341111
R3840 VSS VSS.n363 0.0341111
R3841 VSS VSS.n448 0.0341111
R3842 VSS VSS.n440 0.0341111
R3843 VSS.n500 VSS 0.0341111
R3844 VSS VSS.n342 0.0341111
R3845 VSS VSS.n336 0.0341111
R3846 VSS.n517 VSS 0.0341111
R3847 VSS VSS.n330 0.0341111
R3848 VSS.n533 VSS 0.0341111
R3849 VSS VSS.n324 0.0341111
R3850 VSS.n552 VSS 0.0341111
R3851 VSS VSS.n318 0.0341111
R3852 VSS VSS.n312 0.0341111
R3853 VSS VSS.n575 0.0341111
R3854 VSS VSS.n567 0.0341111
R3855 VSS.n681 VSS 0.0341111
R3856 VSS VSS.n253 0.0341111
R3857 VSS VSS.n248 0.0341111
R3858 VSS VSS.n244 0.0341111
R3859 VSS.n386 VSS 0.0341111
R3860 VSS VSS.n389 0.0341111
R3861 VSS.n621 VSS 0.0341111
R3862 VSS VSS.n279 0.0341111
R3863 VSS.n275 VSS 0.0341111
R3864 VSS VSS.n271 0.0341111
R3865 VSS VSS.n902 0.0341111
R3866 VSS.n5 VSS 0.0341111
R3867 VSS VSS.n9 0.0341111
R3868 VSS.n11 VSS 0.0341111
R3869 VSS VSS.n15 0.0341111
R3870 VSS.n17 VSS 0.0341111
R3871 VSS VSS.n19 0.0341111
R3872 VSS.n23 VSS 0.0341111
R3873 VSS.n25 VSS 0.0341111
R3874 VSS VSS.n616 0.0341111
R3875 VSS.n291 VSS 0.0341111
R3876 VSS VSS.n295 0.0341111
R3877 VSS.n297 VSS 0.0341111
R3878 VSS VSS.n299 0.0341111
R3879 VSS.n303 VSS 0.0341111
R3880 VSS.n306 VSS 0.0341111
R3881 VSS VSS.n667 0.0341111
R3882 VSS.n263 VSS 0.0341111
R3883 VSS.n265 VSS 0.0341111
R3884 VSS.n267 VSS 0.0341111
R3885 VSS VSS.n269 0.0341111
R3886 VSS VSS.n788 0.0188333
R3887 VSS.n427 VSS.n185 0.0188333
R3888 VSS VSS.n185 0.0188333
R3889 VSS.n782 VSS 0.0188333
R3890 VSS VSS.n187 0.0188333
R3891 VSS.n189 VSS 0.0188333
R3892 VSS VSS.n191 0.0188333
R3893 VSS.n775 VSS 0.0188333
R3894 VSS VSS.n193 0.0188333
R3895 VSS.n195 VSS 0.0188333
R3896 VSS VSS.n197 0.0188333
R3897 VSS.n768 VSS 0.0188333
R3898 VSS VSS.n199 0.0188333
R3899 VSS.n763 VSS 0.0188333
R3900 VSS VSS.n201 0.0188333
R3901 VSS VSS.n757 0.0188333
R3902 VSS.n513 VSS.n205 0.0188333
R3903 VSS VSS.n205 0.0188333
R3904 VSS.n751 VSS 0.0188333
R3905 VSS VSS.n207 0.0188333
R3906 VSS.n209 VSS 0.0188333
R3907 VSS VSS.n211 0.0188333
R3908 VSS.n744 VSS 0.0188333
R3909 VSS VSS.n213 0.0188333
R3910 VSS.n215 VSS 0.0188333
R3911 VSS VSS.n217 0.0188333
R3912 VSS.n737 VSS 0.0188333
R3913 VSS VSS.n219 0.0188333
R3914 VSS.n732 VSS 0.0188333
R3915 VSS VSS.n221 0.0188333
R3916 VSS VSS.n726 0.0188333
R3917 VSS.n577 VSS.n225 0.0188333
R3918 VSS VSS.n225 0.0188333
R3919 VSS.n720 VSS 0.0188333
R3920 VSS VSS.n227 0.0188333
R3921 VSS.n229 VSS 0.0188333
R3922 VSS VSS.n231 0.0188333
R3923 VSS.n713 VSS 0.0188333
R3924 VSS VSS.n233 0.0188333
R3925 VSS.n708 VSS 0.0188333
R3926 VSS VSS.n235 0.0188333
R3927 VSS.n703 VSS 0.0188333
R3928 VSS VSS.n237 0.0188333
R3929 VSS.n698 VSS 0.0188333
R3930 VSS.n239 VSS 0.0188333
R3931 VSS.n380 VSS 0.0188333
R3932 VSS.n379 VSS 0.0188333
R3933 VSS VSS.n378 0.0188333
R3934 VSS.n419 VSS 0.0188333
R3935 VSS.n413 VSS 0.0188333
R3936 VSS.n411 VSS 0.0188333
R3937 VSS VSS.n410 0.0188333
R3938 VSS.n460 VSS 0.0188333
R3939 VSS VSS.n459 0.0188333
R3940 VSS.n352 VSS 0.0188333
R3941 VSS VSS.n351 0.0188333
R3942 VSS.n488 VSS 0.0188333
R3943 VSS.n482 VSS 0.0188333
R3944 VSS VSS.n468 0.0188333
R3945 VSS VSS.n475 0.0188333
R3946 VSS.n471 VSS 0.0188333
R3947 VSS VSS.n470 0.0188333
R3948 VSS.n862 VSS 0.0188333
R3949 VSS.n856 VSS 0.0188333
R3950 VSS VSS.n32 0.0188333
R3951 VSS.n34 VSS 0.0188333
R3952 VSS VSS.n36 0.0188333
R3953 VSS.n848 VSS 0.0188333
R3954 VSS VSS.n38 0.0188333
R3955 VSS.n40 VSS 0.0188333
R3956 VSS VSS.n42 0.0188333
R3957 VSS.n840 VSS 0.0188333
R3958 VSS VSS.n44 0.0188333
R3959 VSS VSS.n833 0.0188333
R3960 VSS VSS.n48 0.0188333
R3961 VSS.n50 VSS 0.0188333
R3962 VSS VSS.n52 0.0188333
R3963 VSS.n823 VSS 0.0188333
R3964 VSS VSS.n54 0.0188333
R3965 VSS.n56 VSS 0.0188333
R3966 VSS VSS.n58 0.0188333
R3967 VSS.n815 VSS 0.0188333
R3968 VSS VSS.n60 0.0188333
R3969 VSS.n810 VSS 0.0188333
R3970 VSS VSS.n62 0.0188333
R3971 VSS.n637 VSS 0.0188333
R3972 VSS.n636 VSS 0.0188333
R3973 VSS.n370 VSS 0.0188333
R3974 VSS.n369 VSS 0.0188333
R3975 VSS VSS.n368 0.0188333
R3976 VSS.n431 VSS 0.0188333
R3977 VSS VSS.n430 0.0188333
R3978 VSS.n363 VSS 0.0188333
R3979 VSS VSS.n362 0.0188333
R3980 VSS.n448 VSS 0.0188333
R3981 VSS.n442 VSS 0.0188333
R3982 VSS.n440 VSS 0.0188333
R3983 VSS VSS.n439 0.0188333
R3984 VSS.n500 VSS 0.0188333
R3985 VSS VSS.n499 0.0188333
R3986 VSS.n342 VSS 0.0188333
R3987 VSS VSS.n338 0.0188333
R3988 VSS.n336 VSS 0.0188333
R3989 VSS VSS.n335 0.0188333
R3990 VSS.n517 VSS 0.0188333
R3991 VSS VSS.n516 0.0188333
R3992 VSS.n330 VSS 0.0188333
R3993 VSS VSS.n329 0.0188333
R3994 VSS.n533 VSS 0.0188333
R3995 VSS VSS.n532 0.0188333
R3996 VSS.n324 VSS 0.0188333
R3997 VSS VSS.n323 0.0188333
R3998 VSS.n552 VSS 0.0188333
R3999 VSS VSS.n551 0.0188333
R4000 VSS.n318 VSS 0.0188333
R4001 VSS VSS.n314 0.0188333
R4002 VSS.n312 VSS 0.0188333
R4003 VSS VSS.n311 0.0188333
R4004 VSS.n575 VSS 0.0188333
R4005 VSS.n569 VSS 0.0188333
R4006 VSS.n567 VSS 0.0188333
R4007 VSS VSS.n566 0.0188333
R4008 VSS.n681 VSS 0.0188333
R4009 VSS VSS.n680 0.0188333
R4010 VSS.n253 VSS 0.0188333
R4011 VSS VSS.n252 0.0188333
R4012 VSS.n248 VSS 0.0188333
R4013 VSS VSS.n247 0.0188333
R4014 VSS.n244 VSS 0.0188333
R4015 VSS.n383 VSS 0.0188333
R4016 VSS VSS.n386 0.0188333
R4017 VSS.n391 VSS 0.0188333
R4018 VSS.n389 VSS 0.0188333
R4019 VSS VSS.n388 0.0188333
R4020 VSS.n621 VSS 0.0188333
R4021 VSS VSS.n620 0.0188333
R4022 VSS.n279 VSS 0.0188333
R4023 VSS VSS.n278 0.0188333
R4024 VSS.n275 VSS 0.0188333
R4025 VSS VSS.n274 0.0188333
R4026 VSS.n271 VSS 0.0188333
R4027 VSS VSS.n399 0.0188333
R4028 VSS.n897 VSS 0.0188333
R4029 VSS VSS.n5 0.0188333
R4030 VSS.n7 VSS 0.0188333
R4031 VSS VSS.n9 0.0188333
R4032 VSS.n890 VSS 0.0188333
R4033 VSS VSS.n11 0.0188333
R4034 VSS.n13 VSS 0.0188333
R4035 VSS VSS.n15 0.0188333
R4036 VSS.n883 VSS 0.0188333
R4037 VSS VSS.n17 0.0188333
R4038 VSS.n878 VSS 0.0188333
R4039 VSS VSS.n19 0.0188333
R4040 VSS VSS.n872 0.0188333
R4041 VSS.n866 VSS 0.0188333
R4042 VSS VSS.n25 0.0188333
R4043 VSS.n287 VSS 0.0188333
R4044 VSS.n616 VSS 0.0188333
R4045 VSS.n611 VSS 0.0188333
R4046 VSS VSS.n291 0.0188333
R4047 VSS.n293 VSS 0.0188333
R4048 VSS VSS.n295 0.0188333
R4049 VSS.n604 VSS 0.0188333
R4050 VSS VSS.n297 0.0188333
R4051 VSS.n599 VSS 0.0188333
R4052 VSS VSS.n299 0.0188333
R4053 VSS VSS.n593 0.0188333
R4054 VSS.n587 VSS 0.0188333
R4055 VSS.n306 VSS 0.0188333
R4056 VSS VSS.n305 0.0188333
R4057 VSS.n667 VSS 0.0188333
R4058 VSS.n662 VSS 0.0188333
R4059 VSS VSS.n263 0.0188333
R4060 VSS.n657 VSS 0.0188333
R4061 VSS VSS.n265 0.0188333
R4062 VSS.n653 VSS 0.0188333
R4063 VSS VSS.n267 0.0188333
R4064 VSS.n648 VSS 0.0188333
R4065 VSS.n269 VSS 0.0188333
R4066 VSS.n427 VSS 0.0157778
R4067 VSS.n513 VSS 0.0157778
R4068 VSS.n577 VSS 0.0157778
R4069 VSS.n789 VSS 0.0111944
R4070 VSS.n758 VSS 0.0111944
R4071 VSS.n727 VSS 0.0111944
R4072 VSS.n477 VSS 0.0111944
R4073 VSS.n835 VSS 0.0111944
R4074 VSS.n633 VSS 0.0111944
R4075 VSS.n339 VSS 0.0111944
R4076 VSS.n315 VSS 0.0111944
R4077 VSS.n241 VSS 0.0111944
R4078 VSS.n400 VSS 0.0111944
R4079 VSS VSS.n1 0.0111944
R4080 VSS.n873 VSS 0.0111944
R4081 VSS VSS.n865 0.0111944
R4082 VSS.n594 VSS 0.0111944
R4083 VSS VSS.n586 0.0111944
R4084 VSS.n902 VSS.n1 0.00813889
R4085 VSS.n865 VSS.n23 0.00813889
R4086 VSS.n586 VSS.n303 0.00813889
R4087 psdiff_2.buff_d8_1.VIN.n28 psdiff_2.buff_d8_1.VIN.n27 20.4895
R4088 psdiff_2.buff_d8_1.VIN.n19 psdiff_2.buff_d8_1.VIN.n18 18.6537
R4089 psdiff_2.buff_d8_1.VIN.n4 psdiff_2.buff_d8_1.VIN.t8 17.3511
R4090 psdiff_2.buff_d8_1.VIN.n6 psdiff_2.buff_d8_1.VIN.t21 17.3511
R4091 psdiff_2.buff_d8_1.VIN.n13 psdiff_2.buff_d8_1.VIN.t20 17.3511
R4092 psdiff_2.buff_d8_1.VIN.n11 psdiff_2.buff_d8_1.VIN.t18 17.3511
R4093 psdiff_2.buff_d8_1.VIN.n9 psdiff_2.buff_d8_1.VIN.t26 17.3511
R4094 psdiff_2.buff_d8_1.VIN.n7 psdiff_2.buff_d8_1.VIN.t17 17.3511
R4095 psdiff_2.buff_d8_1.VIN.n20 psdiff_2.buff_d8_1.VIN.t3 17.3511
R4096 psdiff_2.buff_d8_1.VIN.n26 psdiff_2.buff_d8_1.VIN.t5 17.3511
R4097 psdiff_2.buff_d8_1.VIN.n0 psdiff_2.buff_d8_1.VIN.t15 17.3511
R4098 psdiff_2.buff_d8_1.VIN.n2 psdiff_2.buff_d8_1.VIN.t12 17.3511
R4099 psdiff_2.buff_d8_1.VIN.n23 psdiff_2.buff_d8_1.VIN.t1 17.2171
R4100 psdiff_2.buff_d8_1.VIN.n4 psdiff_2.buff_d8_1.VIN.t16 17.0005
R4101 psdiff_2.buff_d8_1.VIN.n5 psdiff_2.buff_d8_1.VIN.t7 17.0005
R4102 psdiff_2.buff_d8_1.VIN.n6 psdiff_2.buff_d8_1.VIN.t19 17.0005
R4103 psdiff_2.buff_d8_1.VIN.n14 psdiff_2.buff_d8_1.VIN.t30 17.0005
R4104 psdiff_2.buff_d8_1.VIN.n13 psdiff_2.buff_d8_1.VIN.t22 17.0005
R4105 psdiff_2.buff_d8_1.VIN.n12 psdiff_2.buff_d8_1.VIN.t31 17.0005
R4106 psdiff_2.buff_d8_1.VIN.n11 psdiff_2.buff_d8_1.VIN.t25 17.0005
R4107 psdiff_2.buff_d8_1.VIN.n10 psdiff_2.buff_d8_1.VIN.t27 17.0005
R4108 psdiff_2.buff_d8_1.VIN.n9 psdiff_2.buff_d8_1.VIN.t23 17.0005
R4109 psdiff_2.buff_d8_1.VIN.n8 psdiff_2.buff_d8_1.VIN.t28 17.0005
R4110 psdiff_2.buff_d8_1.VIN.n7 psdiff_2.buff_d8_1.VIN.t24 17.0005
R4111 psdiff_2.buff_d8_1.VIN.n18 psdiff_2.buff_d8_1.VIN.t29 17.0005
R4112 psdiff_2.buff_d8_1.VIN.n19 psdiff_2.buff_d8_1.VIN.t0 17.0005
R4113 psdiff_2.buff_d8_1.VIN.n20 psdiff_2.buff_d8_1.VIN.t9 17.0005
R4114 psdiff_2.buff_d8_1.VIN.n21 psdiff_2.buff_d8_1.VIN.t2 17.0005
R4115 psdiff_2.buff_d8_1.VIN.n26 psdiff_2.buff_d8_1.VIN.t14 17.0005
R4116 psdiff_2.buff_d8_1.VIN.n27 psdiff_2.buff_d8_1.VIN.t4 17.0005
R4117 psdiff_2.buff_d8_1.VIN.n0 psdiff_2.buff_d8_1.VIN.t10 17.0005
R4118 psdiff_2.buff_d8_1.VIN.n1 psdiff_2.buff_d8_1.VIN.t13 17.0005
R4119 psdiff_2.buff_d8_1.VIN.n2 psdiff_2.buff_d8_1.VIN.t6 17.0005
R4120 psdiff_2.buff_d8_1.VIN.n3 psdiff_2.buff_d8_1.VIN.t11 17.0005
R4121 psdiff_2.buff_d8_1.VIN.n28 psdiff_2.buff_d8_1.VIN.t32 15.0005
R4122 psdiff_2.buff_d8_1.VIN.n15 psdiff_2.buff_d8_1.VIN.n14 0.997375
R4123 psdiff_2.buff_d8_1.VIN.n18 psdiff_2.buff_d8_1.VIN.n17 0.965015
R4124 psdiff_2.buff_d8_1.VIN.n27 psdiff_2.buff_d8_1.VIN.n25 0.965015
R4125 psdiff_2.buff_d8_1.VIN.n16 psdiff_2.buff_d8_1.VIN.n15 0.78425
R4126 psdiff_2.buff_d8_1.VIN.n17 psdiff_2.buff_d8_1.VIN.n16 0.78425
R4127 psdiff_2.buff_d8_1.VIN.n23 psdiff_2.buff_d8_1.VIN.n22 0.78425
R4128 psdiff_2.buff_d8_1.VIN.n24 psdiff_2.buff_d8_1.VIN.n23 0.78425
R4129 psdiff_2.buff_d8_1.VIN.n25 psdiff_2.buff_d8_1.VIN.n24 0.78425
R4130 psdiff_2.buff_d8_1.VIN.n14 psdiff_2.buff_d8_1.VIN.n13 0.622687
R4131 psdiff_2.buff_d8_1.VIN.n12 psdiff_2.buff_d8_1.VIN.n11 0.622687
R4132 psdiff_2.buff_d8_1.VIN.n10 psdiff_2.buff_d8_1.VIN.n9 0.622687
R4133 psdiff_2.buff_d8_1.VIN.n8 psdiff_2.buff_d8_1.VIN.n7 0.622687
R4134 psdiff_2.buff_d8_1.VIN.n18 psdiff_2.buff_d8_1.VIN.n6 0.590328
R4135 psdiff_2.buff_d8_1.VIN.n5 psdiff_2.buff_d8_1.VIN.n4 0.351125
R4136 psdiff_2.buff_d8_1.VIN.n21 psdiff_2.buff_d8_1.VIN.n20 0.351125
R4137 psdiff_2.buff_d8_1.VIN.n1 psdiff_2.buff_d8_1.VIN.n0 0.351125
R4138 psdiff_2.buff_d8_1.VIN.n3 psdiff_2.buff_d8_1.VIN.n2 0.351125
R4139 psdiff_2.buff_d8_1.VIN.n27 psdiff_2.buff_d8_1.VIN.n26 0.318765
R4140 psdiff_2.buff_d8_1.VIN.n23 psdiff_2.buff_d8_1.VIN.n5 0.213625
R4141 psdiff_2.buff_d8_1.VIN.n15 psdiff_2.buff_d8_1.VIN.n12 0.213625
R4142 psdiff_2.buff_d8_1.VIN.n16 psdiff_2.buff_d8_1.VIN.n10 0.213625
R4143 psdiff_2.buff_d8_1.VIN.n17 psdiff_2.buff_d8_1.VIN.n8 0.213625
R4144 psdiff_2.buff_d8_1.VIN.n22 psdiff_2.buff_d8_1.VIN.n21 0.213625
R4145 psdiff_2.buff_d8_1.VIN.n25 psdiff_2.buff_d8_1.VIN.n1 0.213625
R4146 psdiff_2.buff_d8_1.VIN.n24 psdiff_2.buff_d8_1.VIN.n3 0.213625
R4147 psdiff_2.buff_d8_1.VIN.n22 psdiff_2.buff_d8_1.VIN.n19 0.184703
R4148 psdiff_2.buff_d8_1.inv_0.VIN psdiff_2.buff_d8_1.VIN.n28 0.0151667
R4149 psdiff_2.buff_d8_0.VIN.n19 psdiff_2.buff_d8_0.VIN.n18 36.6537
R4150 psdiff_2.buff_d8_0.VIN.n29 psdiff_2.buff_d8_0.VIN.n28 19.5243
R4151 psdiff_2.buff_d8_0.VIN.n4 psdiff_2.buff_d8_0.VIN.t2 17.3511
R4152 psdiff_2.buff_d8_0.VIN.n6 psdiff_2.buff_d8_0.VIN.t18 17.3511
R4153 psdiff_2.buff_d8_0.VIN.n7 psdiff_2.buff_d8_0.VIN.t21 17.3511
R4154 psdiff_2.buff_d8_0.VIN.n9 psdiff_2.buff_d8_0.VIN.t17 17.3511
R4155 psdiff_2.buff_d8_0.VIN.n11 psdiff_2.buff_d8_0.VIN.t20 17.3511
R4156 psdiff_2.buff_d8_0.VIN.n13 psdiff_2.buff_d8_0.VIN.t22 17.3511
R4157 psdiff_2.buff_d8_0.VIN.n20 psdiff_2.buff_d8_0.VIN.t9 17.3511
R4158 psdiff_2.buff_d8_0.VIN.n2 psdiff_2.buff_d8_0.VIN.t15 17.3511
R4159 psdiff_2.buff_d8_0.VIN.n0 psdiff_2.buff_d8_0.VIN.t12 17.3511
R4160 psdiff_2.buff_d8_0.VIN.n23 psdiff_2.buff_d8_0.VIN.t1 17.2171
R4161 psdiff_2.buff_d8_0.VIN.n4 psdiff_2.buff_d8_0.VIN.t13 17.0005
R4162 psdiff_2.buff_d8_0.VIN.n5 psdiff_2.buff_d8_0.VIN.t5 17.0005
R4163 psdiff_2.buff_d8_0.VIN.n6 psdiff_2.buff_d8_0.VIN.t24 17.0005
R4164 psdiff_2.buff_d8_0.VIN.n8 psdiff_2.buff_d8_0.VIN.t28 17.0005
R4165 psdiff_2.buff_d8_0.VIN.n7 psdiff_2.buff_d8_0.VIN.t25 17.0005
R4166 psdiff_2.buff_d8_0.VIN.n10 psdiff_2.buff_d8_0.VIN.t29 17.0005
R4167 psdiff_2.buff_d8_0.VIN.n9 psdiff_2.buff_d8_0.VIN.t23 17.0005
R4168 psdiff_2.buff_d8_0.VIN.n12 psdiff_2.buff_d8_0.VIN.t31 17.0005
R4169 psdiff_2.buff_d8_0.VIN.n11 psdiff_2.buff_d8_0.VIN.t19 17.0005
R4170 psdiff_2.buff_d8_0.VIN.n14 psdiff_2.buff_d8_0.VIN.t27 17.0005
R4171 psdiff_2.buff_d8_0.VIN.n13 psdiff_2.buff_d8_0.VIN.t26 17.0005
R4172 psdiff_2.buff_d8_0.VIN.n18 psdiff_2.buff_d8_0.VIN.t30 17.0005
R4173 psdiff_2.buff_d8_0.VIN.n19 psdiff_2.buff_d8_0.VIN.t0 17.0005
R4174 psdiff_2.buff_d8_0.VIN.n20 psdiff_2.buff_d8_0.VIN.t3 17.0005
R4175 psdiff_2.buff_d8_0.VIN.n21 psdiff_2.buff_d8_0.VIN.t8 17.0005
R4176 psdiff_2.buff_d8_0.VIN.n2 psdiff_2.buff_d8_0.VIN.t10 17.0005
R4177 psdiff_2.buff_d8_0.VIN.n3 psdiff_2.buff_d8_0.VIN.t14 17.0005
R4178 psdiff_2.buff_d8_0.VIN.n0 psdiff_2.buff_d8_0.VIN.t4 17.0005
R4179 psdiff_2.buff_d8_0.VIN.n1 psdiff_2.buff_d8_0.VIN.t11 17.0005
R4180 psdiff_2.buff_d8_0.VIN.n28 psdiff_2.buff_d8_0.VIN.t7 17.0005
R4181 psdiff_2.buff_d8_0.VIN.n27 psdiff_2.buff_d8_0.VIN.t16 17.0005
R4182 psdiff_2.buff_d8_0.VIN.n26 psdiff_2.buff_d8_0.VIN.t6 17.0005
R4183 psdiff_2.buff_d8_0.VIN.n29 psdiff_2.buff_d8_0.VIN.t32 15.0005
R4184 psdiff_2.buff_d8_0.VIN.n15 psdiff_2.buff_d8_0.VIN.n14 0.997375
R4185 psdiff_2.buff_d8_0.VIN.n26 psdiff_2.buff_d8_0.VIN.n25 0.997375
R4186 psdiff_2.buff_d8_0.VIN.n18 psdiff_2.buff_d8_0.VIN.n17 0.965015
R4187 psdiff_2.buff_d8_0.VIN.n17 psdiff_2.buff_d8_0.VIN.n16 0.78425
R4188 psdiff_2.buff_d8_0.VIN.n16 psdiff_2.buff_d8_0.VIN.n15 0.78425
R4189 psdiff_2.buff_d8_0.VIN.n25 psdiff_2.buff_d8_0.VIN.n24 0.78425
R4190 psdiff_2.buff_d8_0.VIN.n24 psdiff_2.buff_d8_0.VIN.n23 0.78425
R4191 psdiff_2.buff_d8_0.VIN.n23 psdiff_2.buff_d8_0.VIN.n22 0.78425
R4192 psdiff_2.buff_d8_0.VIN.n8 psdiff_2.buff_d8_0.VIN.n7 0.622687
R4193 psdiff_2.buff_d8_0.VIN.n10 psdiff_2.buff_d8_0.VIN.n9 0.622687
R4194 psdiff_2.buff_d8_0.VIN.n12 psdiff_2.buff_d8_0.VIN.n11 0.622687
R4195 psdiff_2.buff_d8_0.VIN.n14 psdiff_2.buff_d8_0.VIN.n13 0.622687
R4196 psdiff_2.buff_d8_0.VIN.n18 psdiff_2.buff_d8_0.VIN.n6 0.590328
R4197 psdiff_2.buff_d8_0.VIN.n5 psdiff_2.buff_d8_0.VIN.n4 0.351125
R4198 psdiff_2.buff_d8_0.VIN.n21 psdiff_2.buff_d8_0.VIN.n20 0.351125
R4199 psdiff_2.buff_d8_0.VIN.n3 psdiff_2.buff_d8_0.VIN.n2 0.351125
R4200 psdiff_2.buff_d8_0.VIN.n1 psdiff_2.buff_d8_0.VIN.n0 0.351125
R4201 psdiff_2.buff_d8_0.VIN.n27 psdiff_2.buff_d8_0.VIN.n26 0.351125
R4202 psdiff_2.buff_d8_0.VIN.n28 psdiff_2.buff_d8_0.VIN.n27 0.318765
R4203 psdiff_2.buff_d8_0.VIN.n23 psdiff_2.buff_d8_0.VIN.n5 0.213625
R4204 psdiff_2.buff_d8_0.VIN.n17 psdiff_2.buff_d8_0.VIN.n8 0.213625
R4205 psdiff_2.buff_d8_0.VIN.n16 psdiff_2.buff_d8_0.VIN.n10 0.213625
R4206 psdiff_2.buff_d8_0.VIN.n15 psdiff_2.buff_d8_0.VIN.n12 0.213625
R4207 psdiff_2.buff_d8_0.VIN.n22 psdiff_2.buff_d8_0.VIN.n21 0.213625
R4208 psdiff_2.buff_d8_0.VIN.n24 psdiff_2.buff_d8_0.VIN.n3 0.213625
R4209 psdiff_2.buff_d8_0.VIN.n25 psdiff_2.buff_d8_0.VIN.n1 0.213625
R4210 psdiff_2.buff_d8_0.VIN.n22 psdiff_2.buff_d8_0.VIN.n19 0.184703
R4211 psdiff_2.buff_d8_0.inv_0.VIN psdiff_2.buff_d8_0.VIN.n29 0.0555
R4212 psdiff_2.buff_d8_0.VIN.n29 psdiff_2.buff_d8_0.inv_0.VIN 0.0151667
R4213 PH5.n17 PH5.n15 25.5168
R4214 PH5.n1 PH5.t7 17.0005
R4215 PH5.n3 PH5.t5 17.0005
R4216 PH5.n10 PH5.t8 17.0005
R4217 PH5.n12 PH5.t4 17.0005
R4218 PH5.n7 PH5.t6 17.0005
R4219 PH5.n9 PH5.t2 17.0005
R4220 PH5.n4 PH5.t9 17.0005
R4221 PH5.n6 PH5.t3 17.0005
R4222 PH5.n0 PH5.t1 17.0005
R4223 PH5.n22 PH5.t0 17.0005
R4224 PH5.n20 PH5.t11 15.0005
R4225 PH5.n18 PH5.t12 15.0005
R4226 PH5.n16 PH5.t10 15.0005
R4227 PH5.n22 PH5.n21 9.9157
R4228 PH5.n13 PH5.n12 9.91525
R4229 PH5.n15 PH5.n3 9.12325
R4230 PH5.n13 PH5.n9 9.12325
R4231 PH5.n14 PH5.n6 9.12325
R4232 PH5.n17 PH5.n16 9.0005
R4233 PH5.n19 PH5.n18 9.0005
R4234 PH5.n21 PH5.n20 9.0005
R4235 PH5.n19 PH5.n17 2.13427
R4236 PH5.n3 PH5 1.19877
R4237 PH5.n12 PH5 1.19877
R4238 PH5.n9 PH5 1.19877
R4239 PH5.n6 PH5 1.19877
R4240 PH5.n22 PH5 1.19877
R4241 PH5.n15 PH5.n14 0.771233
R4242 PH5.n2 PH5 0.559983
R4243 PH5.n11 PH5 0.559983
R4244 PH5.n8 PH5 0.559983
R4245 PH5.n5 PH5 0.559983
R4246 PH5 PH5.n23 0.559983
R4247 PH5.n21 PH5.n19 0.4405
R4248 PH5.n14 PH5 0.4273
R4249 PH5 PH5.n13 0.3657
R4250 PH5.n2 PH5 0.292688
R4251 PH5.n11 PH5 0.292688
R4252 PH5.n8 PH5 0.292688
R4253 PH5.n5 PH5 0.292688
R4254 PH5.n23 PH5 0.292688
R4255 PH5 PH5.n1 0.282375
R4256 PH5 PH5.n10 0.282375
R4257 PH5 PH5.n7 0.282375
R4258 PH5 PH5.n4 0.282375
R4259 PH5 PH5.n0 0.282375
R4260 PH5.n1 PH5 0.089875
R4261 PH5.n10 PH5 0.089875
R4262 PH5.n7 PH5 0.089875
R4263 PH5.n4 PH5 0.089875
R4264 PH5.n0 PH5 0.089875
R4265 PH5.n18 PH5 0.0555
R4266 PH5.n3 PH5.n2 0.0403276
R4267 PH5.n12 PH5.n11 0.0403276
R4268 PH5.n9 PH5.n8 0.0403276
R4269 PH5.n6 PH5.n5 0.0403276
R4270 PH5.n23 PH5.n22 0.0403276
R4271 PH5.n16 PH5 0.017
R4272 PH5.n20 PH5 0.0151667
R4273 PH5.n18 PH5 0.0115
R4274 psdiff_0.buff_d8_0.VIN.n19 psdiff_0.buff_d8_0.VIN.n18 36.6537
R4275 psdiff_0.buff_d8_0.VIN.n29 psdiff_0.buff_d8_0.VIN.n28 19.5243
R4276 psdiff_0.buff_d8_0.VIN.n4 psdiff_0.buff_d8_0.VIN.t18 17.3511
R4277 psdiff_0.buff_d8_0.VIN.n6 psdiff_0.buff_d8_0.VIN.t23 17.3511
R4278 psdiff_0.buff_d8_0.VIN.n7 psdiff_0.buff_d8_0.VIN.t22 17.3511
R4279 psdiff_0.buff_d8_0.VIN.n9 psdiff_0.buff_d8_0.VIN.t25 17.3511
R4280 psdiff_0.buff_d8_0.VIN.n11 psdiff_0.buff_d8_0.VIN.t29 17.3511
R4281 psdiff_0.buff_d8_0.VIN.n13 psdiff_0.buff_d8_0.VIN.t31 17.3511
R4282 psdiff_0.buff_d8_0.VIN.n20 psdiff_0.buff_d8_0.VIN.t12 17.3511
R4283 psdiff_0.buff_d8_0.VIN.n2 psdiff_0.buff_d8_0.VIN.t16 17.3511
R4284 psdiff_0.buff_d8_0.VIN.n0 psdiff_0.buff_d8_0.VIN.t7 17.3511
R4285 psdiff_0.buff_d8_0.VIN.n23 psdiff_0.buff_d8_0.VIN.t1 17.2171
R4286 psdiff_0.buff_d8_0.VIN.n4 psdiff_0.buff_d8_0.VIN.t14 17.0005
R4287 psdiff_0.buff_d8_0.VIN.n5 psdiff_0.buff_d8_0.VIN.t17 17.0005
R4288 psdiff_0.buff_d8_0.VIN.n6 psdiff_0.buff_d8_0.VIN.t26 17.0005
R4289 psdiff_0.buff_d8_0.VIN.n8 psdiff_0.buff_d8_0.VIN.t2 17.0005
R4290 psdiff_0.buff_d8_0.VIN.n7 psdiff_0.buff_d8_0.VIN.t30 17.0005
R4291 psdiff_0.buff_d8_0.VIN.n10 psdiff_0.buff_d8_0.VIN.t6 17.0005
R4292 psdiff_0.buff_d8_0.VIN.n9 psdiff_0.buff_d8_0.VIN.t28 17.0005
R4293 psdiff_0.buff_d8_0.VIN.n12 psdiff_0.buff_d8_0.VIN.t3 17.0005
R4294 psdiff_0.buff_d8_0.VIN.n11 psdiff_0.buff_d8_0.VIN.t24 17.0005
R4295 psdiff_0.buff_d8_0.VIN.n14 psdiff_0.buff_d8_0.VIN.t4 17.0005
R4296 psdiff_0.buff_d8_0.VIN.n13 psdiff_0.buff_d8_0.VIN.t27 17.0005
R4297 psdiff_0.buff_d8_0.VIN.n18 psdiff_0.buff_d8_0.VIN.t5 17.0005
R4298 psdiff_0.buff_d8_0.VIN.n19 psdiff_0.buff_d8_0.VIN.t0 17.0005
R4299 psdiff_0.buff_d8_0.VIN.n20 psdiff_0.buff_d8_0.VIN.t21 17.0005
R4300 psdiff_0.buff_d8_0.VIN.n21 psdiff_0.buff_d8_0.VIN.t9 17.0005
R4301 psdiff_0.buff_d8_0.VIN.n2 psdiff_0.buff_d8_0.VIN.t8 17.0005
R4302 psdiff_0.buff_d8_0.VIN.n3 psdiff_0.buff_d8_0.VIN.t15 17.0005
R4303 psdiff_0.buff_d8_0.VIN.n0 psdiff_0.buff_d8_0.VIN.t20 17.0005
R4304 psdiff_0.buff_d8_0.VIN.n1 psdiff_0.buff_d8_0.VIN.t11 17.0005
R4305 psdiff_0.buff_d8_0.VIN.n28 psdiff_0.buff_d8_0.VIN.t13 17.0005
R4306 psdiff_0.buff_d8_0.VIN.n27 psdiff_0.buff_d8_0.VIN.t19 17.0005
R4307 psdiff_0.buff_d8_0.VIN.n26 psdiff_0.buff_d8_0.VIN.t10 17.0005
R4308 psdiff_0.buff_d8_0.VIN.n29 psdiff_0.buff_d8_0.VIN.t32 15.0005
R4309 psdiff_0.buff_d8_0.VIN.n15 psdiff_0.buff_d8_0.VIN.n14 0.997375
R4310 psdiff_0.buff_d8_0.VIN.n26 psdiff_0.buff_d8_0.VIN.n25 0.997375
R4311 psdiff_0.buff_d8_0.VIN.n18 psdiff_0.buff_d8_0.VIN.n17 0.965015
R4312 psdiff_0.buff_d8_0.VIN.n17 psdiff_0.buff_d8_0.VIN.n16 0.78425
R4313 psdiff_0.buff_d8_0.VIN.n16 psdiff_0.buff_d8_0.VIN.n15 0.78425
R4314 psdiff_0.buff_d8_0.VIN.n25 psdiff_0.buff_d8_0.VIN.n24 0.78425
R4315 psdiff_0.buff_d8_0.VIN.n24 psdiff_0.buff_d8_0.VIN.n23 0.78425
R4316 psdiff_0.buff_d8_0.VIN.n23 psdiff_0.buff_d8_0.VIN.n22 0.78425
R4317 psdiff_0.buff_d8_0.VIN.n8 psdiff_0.buff_d8_0.VIN.n7 0.622687
R4318 psdiff_0.buff_d8_0.VIN.n10 psdiff_0.buff_d8_0.VIN.n9 0.622687
R4319 psdiff_0.buff_d8_0.VIN.n12 psdiff_0.buff_d8_0.VIN.n11 0.622687
R4320 psdiff_0.buff_d8_0.VIN.n14 psdiff_0.buff_d8_0.VIN.n13 0.622687
R4321 psdiff_0.buff_d8_0.VIN.n18 psdiff_0.buff_d8_0.VIN.n6 0.590328
R4322 psdiff_0.buff_d8_0.VIN.n5 psdiff_0.buff_d8_0.VIN.n4 0.351125
R4323 psdiff_0.buff_d8_0.VIN.n21 psdiff_0.buff_d8_0.VIN.n20 0.351125
R4324 psdiff_0.buff_d8_0.VIN.n3 psdiff_0.buff_d8_0.VIN.n2 0.351125
R4325 psdiff_0.buff_d8_0.VIN.n1 psdiff_0.buff_d8_0.VIN.n0 0.351125
R4326 psdiff_0.buff_d8_0.VIN.n27 psdiff_0.buff_d8_0.VIN.n26 0.351125
R4327 psdiff_0.buff_d8_0.VIN.n28 psdiff_0.buff_d8_0.VIN.n27 0.318765
R4328 psdiff_0.buff_d8_0.VIN.n23 psdiff_0.buff_d8_0.VIN.n5 0.213625
R4329 psdiff_0.buff_d8_0.VIN.n17 psdiff_0.buff_d8_0.VIN.n8 0.213625
R4330 psdiff_0.buff_d8_0.VIN.n16 psdiff_0.buff_d8_0.VIN.n10 0.213625
R4331 psdiff_0.buff_d8_0.VIN.n15 psdiff_0.buff_d8_0.VIN.n12 0.213625
R4332 psdiff_0.buff_d8_0.VIN.n22 psdiff_0.buff_d8_0.VIN.n21 0.213625
R4333 psdiff_0.buff_d8_0.VIN.n24 psdiff_0.buff_d8_0.VIN.n3 0.213625
R4334 psdiff_0.buff_d8_0.VIN.n25 psdiff_0.buff_d8_0.VIN.n1 0.213625
R4335 psdiff_0.buff_d8_0.VIN.n22 psdiff_0.buff_d8_0.VIN.n19 0.184703
R4336 psdiff_0.buff_d8_0.inv_0.VIN psdiff_0.buff_d8_0.VIN.n29 0.0555
R4337 psdiff_0.buff_d8_0.VIN.n29 psdiff_0.buff_d8_0.inv_0.VIN 0.0151667
R4338 psdiff_0.buff_d8_1.VIN.n28 psdiff_0.buff_d8_1.VIN.n27 20.4895
R4339 psdiff_0.buff_d8_1.VIN.n17 psdiff_0.buff_d8_1.VIN.n16 18.6537
R4340 psdiff_0.buff_d8_1.VIN.n4 psdiff_0.buff_d8_1.VIN.t18 17.3511
R4341 psdiff_0.buff_d8_1.VIN.n11 psdiff_0.buff_d8_1.VIN.t21 17.3511
R4342 psdiff_0.buff_d8_1.VIN.n9 psdiff_0.buff_d8_1.VIN.t26 17.3511
R4343 psdiff_0.buff_d8_1.VIN.n7 psdiff_0.buff_d8_1.VIN.t17 17.3511
R4344 psdiff_0.buff_d8_1.VIN.n5 psdiff_0.buff_d8_1.VIN.t22 17.3511
R4345 psdiff_0.buff_d8_1.VIN.n18 psdiff_0.buff_d8_1.VIN.t9 17.3511
R4346 psdiff_0.buff_d8_1.VIN.n2 psdiff_0.buff_d8_1.VIN.t11 17.3511
R4347 psdiff_0.buff_d8_1.VIN.n26 psdiff_0.buff_d8_1.VIN.t13 17.3511
R4348 psdiff_0.buff_d8_1.VIN.n0 psdiff_0.buff_d8_1.VIN.t8 17.3511
R4349 psdiff_0.buff_d8_1.VIN.n22 psdiff_0.buff_d8_1.VIN.t4 17.3511
R4350 psdiff_0.buff_d8_1.VIN.n21 psdiff_0.buff_d8_1.VIN.t16 17.2171
R4351 psdiff_0.buff_d8_1.VIN.n4 psdiff_0.buff_d8_1.VIN.t24 17.0005
R4352 psdiff_0.buff_d8_1.VIN.n12 psdiff_0.buff_d8_1.VIN.t30 17.0005
R4353 psdiff_0.buff_d8_1.VIN.n11 psdiff_0.buff_d8_1.VIN.t19 17.0005
R4354 psdiff_0.buff_d8_1.VIN.n10 psdiff_0.buff_d8_1.VIN.t29 17.0005
R4355 psdiff_0.buff_d8_1.VIN.n9 psdiff_0.buff_d8_1.VIN.t23 17.0005
R4356 psdiff_0.buff_d8_1.VIN.n8 psdiff_0.buff_d8_1.VIN.t31 17.0005
R4357 psdiff_0.buff_d8_1.VIN.n7 psdiff_0.buff_d8_1.VIN.t20 17.0005
R4358 psdiff_0.buff_d8_1.VIN.n6 psdiff_0.buff_d8_1.VIN.t27 17.0005
R4359 psdiff_0.buff_d8_1.VIN.n5 psdiff_0.buff_d8_1.VIN.t25 17.0005
R4360 psdiff_0.buff_d8_1.VIN.n16 psdiff_0.buff_d8_1.VIN.t28 17.0005
R4361 psdiff_0.buff_d8_1.VIN.n17 psdiff_0.buff_d8_1.VIN.t15 17.0005
R4362 psdiff_0.buff_d8_1.VIN.n18 psdiff_0.buff_d8_1.VIN.t0 17.0005
R4363 psdiff_0.buff_d8_1.VIN.n19 psdiff_0.buff_d8_1.VIN.t7 17.0005
R4364 psdiff_0.buff_d8_1.VIN.n2 psdiff_0.buff_d8_1.VIN.t3 17.0005
R4365 psdiff_0.buff_d8_1.VIN.n3 psdiff_0.buff_d8_1.VIN.t10 17.0005
R4366 psdiff_0.buff_d8_1.VIN.n26 psdiff_0.buff_d8_1.VIN.t5 17.0005
R4367 psdiff_0.buff_d8_1.VIN.n27 psdiff_0.buff_d8_1.VIN.t12 17.0005
R4368 psdiff_0.buff_d8_1.VIN.n0 psdiff_0.buff_d8_1.VIN.t1 17.0005
R4369 psdiff_0.buff_d8_1.VIN.n1 psdiff_0.buff_d8_1.VIN.t6 17.0005
R4370 psdiff_0.buff_d8_1.VIN.n22 psdiff_0.buff_d8_1.VIN.t14 17.0005
R4371 psdiff_0.buff_d8_1.VIN.n23 psdiff_0.buff_d8_1.VIN.t2 17.0005
R4372 psdiff_0.buff_d8_1.VIN.n28 psdiff_0.buff_d8_1.VIN.t32 15.0005
R4373 psdiff_0.buff_d8_1.VIN.n13 psdiff_0.buff_d8_1.VIN.n12 0.997375
R4374 psdiff_0.buff_d8_1.VIN.n16 psdiff_0.buff_d8_1.VIN.n15 0.965015
R4375 psdiff_0.buff_d8_1.VIN.n27 psdiff_0.buff_d8_1.VIN.n25 0.965015
R4376 psdiff_0.buff_d8_1.VIN.n14 psdiff_0.buff_d8_1.VIN.n13 0.78425
R4377 psdiff_0.buff_d8_1.VIN.n15 psdiff_0.buff_d8_1.VIN.n14 0.78425
R4378 psdiff_0.buff_d8_1.VIN.n21 psdiff_0.buff_d8_1.VIN.n20 0.78425
R4379 psdiff_0.buff_d8_1.VIN.n24 psdiff_0.buff_d8_1.VIN.n21 0.78425
R4380 psdiff_0.buff_d8_1.VIN.n25 psdiff_0.buff_d8_1.VIN.n24 0.78425
R4381 psdiff_0.buff_d8_1.VIN.n12 psdiff_0.buff_d8_1.VIN.n11 0.622687
R4382 psdiff_0.buff_d8_1.VIN.n10 psdiff_0.buff_d8_1.VIN.n9 0.622687
R4383 psdiff_0.buff_d8_1.VIN.n8 psdiff_0.buff_d8_1.VIN.n7 0.622687
R4384 psdiff_0.buff_d8_1.VIN.n6 psdiff_0.buff_d8_1.VIN.n5 0.622687
R4385 psdiff_0.buff_d8_1.VIN.n16 psdiff_0.buff_d8_1.VIN.n4 0.590328
R4386 psdiff_0.buff_d8_1.VIN.n19 psdiff_0.buff_d8_1.VIN.n18 0.351125
R4387 psdiff_0.buff_d8_1.VIN.n3 psdiff_0.buff_d8_1.VIN.n2 0.351125
R4388 psdiff_0.buff_d8_1.VIN.n1 psdiff_0.buff_d8_1.VIN.n0 0.351125
R4389 psdiff_0.buff_d8_1.VIN.n23 psdiff_0.buff_d8_1.VIN.n22 0.351125
R4390 psdiff_0.buff_d8_1.VIN.n27 psdiff_0.buff_d8_1.VIN.n26 0.318765
R4391 psdiff_0.buff_d8_1.VIN.n13 psdiff_0.buff_d8_1.VIN.n10 0.213625
R4392 psdiff_0.buff_d8_1.VIN.n14 psdiff_0.buff_d8_1.VIN.n8 0.213625
R4393 psdiff_0.buff_d8_1.VIN.n15 psdiff_0.buff_d8_1.VIN.n6 0.213625
R4394 psdiff_0.buff_d8_1.VIN.n20 psdiff_0.buff_d8_1.VIN.n19 0.213625
R4395 psdiff_0.buff_d8_1.VIN.n21 psdiff_0.buff_d8_1.VIN.n3 0.213625
R4396 psdiff_0.buff_d8_1.VIN.n25 psdiff_0.buff_d8_1.VIN.n1 0.213625
R4397 psdiff_0.buff_d8_1.VIN.n24 psdiff_0.buff_d8_1.VIN.n23 0.213625
R4398 psdiff_0.buff_d8_1.VIN.n20 psdiff_0.buff_d8_1.VIN.n17 0.184703
R4399 psdiff_0.buff_d8_1.inv_0.VIN psdiff_0.buff_d8_1.VIN.n28 0.0151667
R4400 PH3.n17 PH3.n15 25.5471
R4401 PH3.n1 PH3.t7 17.0005
R4402 PH3.n3 PH3.t2 17.0005
R4403 PH3.n10 PH3.t6 17.0005
R4404 PH3.n12 PH3.t4 17.0005
R4405 PH3.n7 PH3.t8 17.0005
R4406 PH3.n9 PH3.t3 17.0005
R4407 PH3.n4 PH3.t9 17.0005
R4408 PH3.n6 PH3.t5 17.0005
R4409 PH3.n0 PH3.t1 17.0005
R4410 PH3.n22 PH3.t0 17.0005
R4411 PH3.n20 PH3.t11 15.0005
R4412 PH3.n18 PH3.t12 15.0005
R4413 PH3.n16 PH3.t10 15.0005
R4414 PH3.n22 PH3.n21 9.9157
R4415 PH3.n13 PH3.n12 9.91525
R4416 PH3.n15 PH3.n3 9.12325
R4417 PH3.n13 PH3.n9 9.12325
R4418 PH3.n14 PH3.n6 9.12325
R4419 PH3.n17 PH3.n16 9.0005
R4420 PH3.n19 PH3.n18 9.0005
R4421 PH3.n21 PH3.n20 9.0005
R4422 PH3.n19 PH3.n17 2.13427
R4423 PH3.n3 PH3 1.19877
R4424 PH3.n12 PH3 1.19877
R4425 PH3.n9 PH3 1.19877
R4426 PH3.n6 PH3 1.19877
R4427 PH3.n22 PH3 1.19877
R4428 PH3.n15 PH3.n14 0.7925
R4429 PH3.n2 PH3 0.559983
R4430 PH3.n11 PH3 0.559983
R4431 PH3.n8 PH3 0.559983
R4432 PH3.n5 PH3 0.559983
R4433 PH3 PH3.n23 0.559983
R4434 PH3.n21 PH3.n19 0.4405
R4435 PH3.n14 PH3 0.4273
R4436 PH3 PH3.n13 0.3657
R4437 PH3.n2 PH3 0.292688
R4438 PH3.n11 PH3 0.292688
R4439 PH3.n8 PH3 0.292688
R4440 PH3.n5 PH3 0.292688
R4441 PH3.n23 PH3 0.292688
R4442 PH3 PH3.n1 0.282375
R4443 PH3 PH3.n10 0.282375
R4444 PH3 PH3.n7 0.282375
R4445 PH3 PH3.n4 0.282375
R4446 PH3 PH3.n0 0.282375
R4447 PH3.n1 PH3 0.089875
R4448 PH3.n10 PH3 0.089875
R4449 PH3.n7 PH3 0.089875
R4450 PH3.n4 PH3 0.089875
R4451 PH3.n0 PH3 0.089875
R4452 PH3.n18 PH3 0.0555
R4453 PH3.n3 PH3.n2 0.0403276
R4454 PH3.n12 PH3.n11 0.0403276
R4455 PH3.n9 PH3.n8 0.0403276
R4456 PH3.n6 PH3.n5 0.0403276
R4457 PH3.n23 PH3.n22 0.0403276
R4458 PH3.n20 PH3 0.0151667
R4459 PH3.n18 PH3 0.0115
R4460 PH3.n16 PH3 0.0115
R4461 PH2 PH2.t0 17.3649
R4462 PH2.n1 PH2.t7 17.0005
R4463 PH2.n3 PH2.t3 17.0005
R4464 PH2.n4 PH2.t8 17.0005
R4465 PH2.n6 PH2.t2 17.0005
R4466 PH2.n7 PH2.t6 17.0005
R4467 PH2.n9 PH2.t5 17.0005
R4468 PH2.n10 PH2.t9 17.0005
R4469 PH2.n12 PH2.t4 17.0005
R4470 PH2.n21 PH2.t1 17.0005
R4471 PH2.n17 PH2.t12 15.0005
R4472 PH2.n0 PH2.t11 15.0005
R4473 PH2 PH2.t10 15.0005
R4474 PH2.n21 PH2.n19 9.9201
R4475 PH2.n13 PH2.n12 9.91525
R4476 PH2.n15 PH2.n3 9.12325
R4477 PH2.n14 PH2.n6 9.12325
R4478 PH2.n13 PH2.n9 9.12325
R4479 PH2.n16 PH2 9.0005
R4480 PH2.n19 PH2.n0 9.0005
R4481 PH2.n18 PH2.n17 9.0005
R4482 PH2.n16 PH2.n15 3.2455
R4483 PH2.n18 PH2.n16 2.13427
R4484 PH2.n3 PH2 1.19877
R4485 PH2.n6 PH2 1.19877
R4486 PH2.n9 PH2 1.19877
R4487 PH2.n12 PH2 1.19877
R4488 PH2.n15 PH2.n14 0.7925
R4489 PH2.n2 PH2 0.559983
R4490 PH2.n5 PH2 0.559983
R4491 PH2.n8 PH2 0.559983
R4492 PH2.n11 PH2 0.559983
R4493 PH2.n19 PH2.n18 0.4405
R4494 PH2.n14 PH2 0.4273
R4495 PH2 PH2.n13 0.3657
R4496 PH2.n20 PH2 0.3525
R4497 PH2.n2 PH2 0.292688
R4498 PH2.n5 PH2 0.292688
R4499 PH2.n8 PH2 0.292688
R4500 PH2.n11 PH2 0.292688
R4501 PH2 PH2.n1 0.282375
R4502 PH2 PH2.n4 0.282375
R4503 PH2 PH2.n7 0.282375
R4504 PH2 PH2.n10 0.282375
R4505 PH2.n22 PH2 0.210188
R4506 PH2 PH2.n22 0.162063
R4507 PH2.n1 PH2 0.089875
R4508 PH2.n4 PH2 0.089875
R4509 PH2.n7 PH2 0.089875
R4510 PH2.n10 PH2 0.089875
R4511 PH2.n0 PH2 0.0555
R4512 PH2.n3 PH2.n2 0.0403276
R4513 PH2.n6 PH2.n5 0.0403276
R4514 PH2.n9 PH2.n8 0.0403276
R4515 PH2.n12 PH2.n11 0.0403276
R4516 PH2.n22 PH2.n21 0.0403276
R4517 PH2.n21 PH2.n20 0.0403276
R4518 PH2.n17 PH2 0.0151667
R4519 PH2.n0 PH2 0.0115
R4520 PH2.n20 PH2 0.00998276
R4521 psdiff_1.buff_d8_0.VIN.n19 psdiff_1.buff_d8_0.VIN.n18 36.6537
R4522 psdiff_1.buff_d8_0.VIN.n29 psdiff_1.buff_d8_0.VIN.n28 19.5243
R4523 psdiff_1.buff_d8_0.VIN.n6 psdiff_1.buff_d8_0.VIN.t30 17.3511
R4524 psdiff_1.buff_d8_0.VIN.n7 psdiff_1.buff_d8_0.VIN.t28 17.3511
R4525 psdiff_1.buff_d8_0.VIN.n9 psdiff_1.buff_d8_0.VIN.t29 17.3511
R4526 psdiff_1.buff_d8_0.VIN.n11 psdiff_1.buff_d8_0.VIN.t31 17.3511
R4527 psdiff_1.buff_d8_0.VIN.n13 psdiff_1.buff_d8_0.VIN.t24 17.3511
R4528 psdiff_1.buff_d8_0.VIN.n4 psdiff_1.buff_d8_0.VIN.t6 17.3511
R4529 psdiff_1.buff_d8_0.VIN.n2 psdiff_1.buff_d8_0.VIN.t0 17.3511
R4530 psdiff_1.buff_d8_0.VIN.n0 psdiff_1.buff_d8_0.VIN.t14 17.3511
R4531 psdiff_1.buff_d8_0.VIN.n20 psdiff_1.buff_d8_0.VIN.t11 17.3511
R4532 psdiff_1.buff_d8_0.VIN.n23 psdiff_1.buff_d8_0.VIN.t16 17.2171
R4533 psdiff_1.buff_d8_0.VIN.n6 psdiff_1.buff_d8_0.VIN.t25 17.0005
R4534 psdiff_1.buff_d8_0.VIN.n8 psdiff_1.buff_d8_0.VIN.t19 17.0005
R4535 psdiff_1.buff_d8_0.VIN.n7 psdiff_1.buff_d8_0.VIN.t22 17.0005
R4536 psdiff_1.buff_d8_0.VIN.n10 psdiff_1.buff_d8_0.VIN.t17 17.0005
R4537 psdiff_1.buff_d8_0.VIN.n9 psdiff_1.buff_d8_0.VIN.t26 17.0005
R4538 psdiff_1.buff_d8_0.VIN.n12 psdiff_1.buff_d8_0.VIN.t20 17.0005
R4539 psdiff_1.buff_d8_0.VIN.n11 psdiff_1.buff_d8_0.VIN.t23 17.0005
R4540 psdiff_1.buff_d8_0.VIN.n14 psdiff_1.buff_d8_0.VIN.t21 17.0005
R4541 psdiff_1.buff_d8_0.VIN.n13 psdiff_1.buff_d8_0.VIN.t27 17.0005
R4542 psdiff_1.buff_d8_0.VIN.n18 psdiff_1.buff_d8_0.VIN.t18 17.0005
R4543 psdiff_1.buff_d8_0.VIN.n19 psdiff_1.buff_d8_0.VIN.t15 17.0005
R4544 psdiff_1.buff_d8_0.VIN.n4 psdiff_1.buff_d8_0.VIN.t1 17.0005
R4545 psdiff_1.buff_d8_0.VIN.n5 psdiff_1.buff_d8_0.VIN.t5 17.0005
R4546 psdiff_1.buff_d8_0.VIN.n2 psdiff_1.buff_d8_0.VIN.t12 17.0005
R4547 psdiff_1.buff_d8_0.VIN.n3 psdiff_1.buff_d8_0.VIN.t3 17.0005
R4548 psdiff_1.buff_d8_0.VIN.n0 psdiff_1.buff_d8_0.VIN.t7 17.0005
R4549 psdiff_1.buff_d8_0.VIN.n1 psdiff_1.buff_d8_0.VIN.t13 17.0005
R4550 psdiff_1.buff_d8_0.VIN.n28 psdiff_1.buff_d8_0.VIN.t9 17.0005
R4551 psdiff_1.buff_d8_0.VIN.n27 psdiff_1.buff_d8_0.VIN.t2 17.0005
R4552 psdiff_1.buff_d8_0.VIN.n26 psdiff_1.buff_d8_0.VIN.t8 17.0005
R4553 psdiff_1.buff_d8_0.VIN.n20 psdiff_1.buff_d8_0.VIN.t4 17.0005
R4554 psdiff_1.buff_d8_0.VIN.n21 psdiff_1.buff_d8_0.VIN.t10 17.0005
R4555 psdiff_1.buff_d8_0.VIN.n29 psdiff_1.buff_d8_0.VIN.t32 15.0005
R4556 psdiff_1.buff_d8_0.VIN.n15 psdiff_1.buff_d8_0.VIN.n14 0.997375
R4557 psdiff_1.buff_d8_0.VIN.n26 psdiff_1.buff_d8_0.VIN.n25 0.997375
R4558 psdiff_1.buff_d8_0.VIN.n18 psdiff_1.buff_d8_0.VIN.n17 0.965015
R4559 psdiff_1.buff_d8_0.VIN.n17 psdiff_1.buff_d8_0.VIN.n16 0.78425
R4560 psdiff_1.buff_d8_0.VIN.n16 psdiff_1.buff_d8_0.VIN.n15 0.78425
R4561 psdiff_1.buff_d8_0.VIN.n25 psdiff_1.buff_d8_0.VIN.n24 0.78425
R4562 psdiff_1.buff_d8_0.VIN.n24 psdiff_1.buff_d8_0.VIN.n23 0.78425
R4563 psdiff_1.buff_d8_0.VIN.n23 psdiff_1.buff_d8_0.VIN.n22 0.78425
R4564 psdiff_1.buff_d8_0.VIN.n8 psdiff_1.buff_d8_0.VIN.n7 0.622687
R4565 psdiff_1.buff_d8_0.VIN.n10 psdiff_1.buff_d8_0.VIN.n9 0.622687
R4566 psdiff_1.buff_d8_0.VIN.n12 psdiff_1.buff_d8_0.VIN.n11 0.622687
R4567 psdiff_1.buff_d8_0.VIN.n14 psdiff_1.buff_d8_0.VIN.n13 0.622687
R4568 psdiff_1.buff_d8_0.VIN.n18 psdiff_1.buff_d8_0.VIN.n6 0.590328
R4569 psdiff_1.buff_d8_0.VIN.n5 psdiff_1.buff_d8_0.VIN.n4 0.351125
R4570 psdiff_1.buff_d8_0.VIN.n3 psdiff_1.buff_d8_0.VIN.n2 0.351125
R4571 psdiff_1.buff_d8_0.VIN.n1 psdiff_1.buff_d8_0.VIN.n0 0.351125
R4572 psdiff_1.buff_d8_0.VIN.n27 psdiff_1.buff_d8_0.VIN.n26 0.351125
R4573 psdiff_1.buff_d8_0.VIN.n21 psdiff_1.buff_d8_0.VIN.n20 0.351125
R4574 psdiff_1.buff_d8_0.VIN.n28 psdiff_1.buff_d8_0.VIN.n27 0.318765
R4575 psdiff_1.buff_d8_0.VIN.n17 psdiff_1.buff_d8_0.VIN.n8 0.213625
R4576 psdiff_1.buff_d8_0.VIN.n16 psdiff_1.buff_d8_0.VIN.n10 0.213625
R4577 psdiff_1.buff_d8_0.VIN.n15 psdiff_1.buff_d8_0.VIN.n12 0.213625
R4578 psdiff_1.buff_d8_0.VIN.n23 psdiff_1.buff_d8_0.VIN.n5 0.213625
R4579 psdiff_1.buff_d8_0.VIN.n24 psdiff_1.buff_d8_0.VIN.n3 0.213625
R4580 psdiff_1.buff_d8_0.VIN.n25 psdiff_1.buff_d8_0.VIN.n1 0.213625
R4581 psdiff_1.buff_d8_0.VIN.n22 psdiff_1.buff_d8_0.VIN.n21 0.213625
R4582 psdiff_1.buff_d8_0.VIN.n22 psdiff_1.buff_d8_0.VIN.n19 0.184703
R4583 psdiff_1.buff_d8_0.inv_0.VIN psdiff_1.buff_d8_0.VIN.n29 0.0555
R4584 psdiff_1.buff_d8_0.VIN.n29 psdiff_1.buff_d8_0.inv_0.VIN 0.0151667
R4585 psdiff_1.buff_d8_1.VIN.n28 psdiff_1.buff_d8_1.VIN.n27 20.4895
R4586 psdiff_1.buff_d8_1.VIN.n21 psdiff_1.buff_d8_1.VIN.n20 18.6537
R4587 psdiff_1.buff_d8_1.VIN.n8 psdiff_1.buff_d8_1.VIN.t23 17.3511
R4588 psdiff_1.buff_d8_1.VIN.n15 psdiff_1.buff_d8_1.VIN.t26 17.3511
R4589 psdiff_1.buff_d8_1.VIN.n13 psdiff_1.buff_d8_1.VIN.t19 17.3511
R4590 psdiff_1.buff_d8_1.VIN.n11 psdiff_1.buff_d8_1.VIN.t22 17.3511
R4591 psdiff_1.buff_d8_1.VIN.n9 psdiff_1.buff_d8_1.VIN.t25 17.3511
R4592 psdiff_1.buff_d8_1.VIN.n6 psdiff_1.buff_d8_1.VIN.t5 17.3511
R4593 psdiff_1.buff_d8_1.VIN.n4 psdiff_1.buff_d8_1.VIN.t9 17.3511
R4594 psdiff_1.buff_d8_1.VIN.n26 psdiff_1.buff_d8_1.VIN.t11 17.3511
R4595 psdiff_1.buff_d8_1.VIN.n0 psdiff_1.buff_d8_1.VIN.t3 17.3511
R4596 psdiff_1.buff_d8_1.VIN.n2 psdiff_1.buff_d8_1.VIN.t13 17.3511
R4597 psdiff_1.buff_d8_1.VIN.n23 psdiff_1.buff_d8_1.VIN.t0 17.2171
R4598 psdiff_1.buff_d8_1.VIN.n8 psdiff_1.buff_d8_1.VIN.t20 17.0005
R4599 psdiff_1.buff_d8_1.VIN.n16 psdiff_1.buff_d8_1.VIN.t30 17.0005
R4600 psdiff_1.buff_d8_1.VIN.n15 psdiff_1.buff_d8_1.VIN.t24 17.0005
R4601 psdiff_1.buff_d8_1.VIN.n14 psdiff_1.buff_d8_1.VIN.t31 17.0005
R4602 psdiff_1.buff_d8_1.VIN.n13 psdiff_1.buff_d8_1.VIN.t18 17.0005
R4603 psdiff_1.buff_d8_1.VIN.n12 psdiff_1.buff_d8_1.VIN.t27 17.0005
R4604 psdiff_1.buff_d8_1.VIN.n11 psdiff_1.buff_d8_1.VIN.t21 17.0005
R4605 psdiff_1.buff_d8_1.VIN.n10 psdiff_1.buff_d8_1.VIN.t29 17.0005
R4606 psdiff_1.buff_d8_1.VIN.n9 psdiff_1.buff_d8_1.VIN.t17 17.0005
R4607 psdiff_1.buff_d8_1.VIN.n20 psdiff_1.buff_d8_1.VIN.t28 17.0005
R4608 psdiff_1.buff_d8_1.VIN.n6 psdiff_1.buff_d8_1.VIN.t15 17.0005
R4609 psdiff_1.buff_d8_1.VIN.n7 psdiff_1.buff_d8_1.VIN.t2 17.0005
R4610 psdiff_1.buff_d8_1.VIN.n4 psdiff_1.buff_d8_1.VIN.t16 17.0005
R4611 psdiff_1.buff_d8_1.VIN.n5 psdiff_1.buff_d8_1.VIN.t8 17.0005
R4612 psdiff_1.buff_d8_1.VIN.n26 psdiff_1.buff_d8_1.VIN.t4 17.0005
R4613 psdiff_1.buff_d8_1.VIN.n27 psdiff_1.buff_d8_1.VIN.t10 17.0005
R4614 psdiff_1.buff_d8_1.VIN.n0 psdiff_1.buff_d8_1.VIN.t14 17.0005
R4615 psdiff_1.buff_d8_1.VIN.n1 psdiff_1.buff_d8_1.VIN.t7 17.0005
R4616 psdiff_1.buff_d8_1.VIN.n2 psdiff_1.buff_d8_1.VIN.t6 17.0005
R4617 psdiff_1.buff_d8_1.VIN.n3 psdiff_1.buff_d8_1.VIN.t12 17.0005
R4618 psdiff_1.buff_d8_1.VIN.n21 psdiff_1.buff_d8_1.VIN.t1 17.0005
R4619 psdiff_1.buff_d8_1.VIN.n28 psdiff_1.buff_d8_1.VIN.t32 15.0005
R4620 psdiff_1.buff_d8_1.VIN.n17 psdiff_1.buff_d8_1.VIN.n16 0.997375
R4621 psdiff_1.buff_d8_1.VIN.n20 psdiff_1.buff_d8_1.VIN.n19 0.965015
R4622 psdiff_1.buff_d8_1.VIN.n27 psdiff_1.buff_d8_1.VIN.n25 0.965015
R4623 psdiff_1.buff_d8_1.VIN.n18 psdiff_1.buff_d8_1.VIN.n17 0.78425
R4624 psdiff_1.buff_d8_1.VIN.n19 psdiff_1.buff_d8_1.VIN.n18 0.78425
R4625 psdiff_1.buff_d8_1.VIN.n23 psdiff_1.buff_d8_1.VIN.n22 0.78425
R4626 psdiff_1.buff_d8_1.VIN.n24 psdiff_1.buff_d8_1.VIN.n23 0.78425
R4627 psdiff_1.buff_d8_1.VIN.n25 psdiff_1.buff_d8_1.VIN.n24 0.78425
R4628 psdiff_1.buff_d8_1.VIN.n16 psdiff_1.buff_d8_1.VIN.n15 0.622687
R4629 psdiff_1.buff_d8_1.VIN.n14 psdiff_1.buff_d8_1.VIN.n13 0.622687
R4630 psdiff_1.buff_d8_1.VIN.n12 psdiff_1.buff_d8_1.VIN.n11 0.622687
R4631 psdiff_1.buff_d8_1.VIN.n10 psdiff_1.buff_d8_1.VIN.n9 0.622687
R4632 psdiff_1.buff_d8_1.VIN.n20 psdiff_1.buff_d8_1.VIN.n8 0.590328
R4633 psdiff_1.buff_d8_1.VIN.n7 psdiff_1.buff_d8_1.VIN.n6 0.351125
R4634 psdiff_1.buff_d8_1.VIN.n5 psdiff_1.buff_d8_1.VIN.n4 0.351125
R4635 psdiff_1.buff_d8_1.VIN.n1 psdiff_1.buff_d8_1.VIN.n0 0.351125
R4636 psdiff_1.buff_d8_1.VIN.n3 psdiff_1.buff_d8_1.VIN.n2 0.351125
R4637 psdiff_1.buff_d8_1.VIN.n27 psdiff_1.buff_d8_1.VIN.n26 0.318765
R4638 psdiff_1.buff_d8_1.VIN.n17 psdiff_1.buff_d8_1.VIN.n14 0.213625
R4639 psdiff_1.buff_d8_1.VIN.n18 psdiff_1.buff_d8_1.VIN.n12 0.213625
R4640 psdiff_1.buff_d8_1.VIN.n19 psdiff_1.buff_d8_1.VIN.n10 0.213625
R4641 psdiff_1.buff_d8_1.VIN.n22 psdiff_1.buff_d8_1.VIN.n7 0.213625
R4642 psdiff_1.buff_d8_1.VIN.n23 psdiff_1.buff_d8_1.VIN.n5 0.213625
R4643 psdiff_1.buff_d8_1.VIN.n25 psdiff_1.buff_d8_1.VIN.n1 0.213625
R4644 psdiff_1.buff_d8_1.VIN.n24 psdiff_1.buff_d8_1.VIN.n3 0.213625
R4645 psdiff_1.buff_d8_1.VIN.n22 psdiff_1.buff_d8_1.VIN.n21 0.184703
R4646 psdiff_1.buff_d8_1.inv_0.VIN psdiff_1.buff_d8_1.VIN.n28 0.0151667
R4647 PH0 PH0.t0 17.3649
R4648 PH0.n1 PH0.t8 17.0005
R4649 PH0.n3 PH0.t3 17.0005
R4650 PH0.n4 PH0.t7 17.0005
R4651 PH0.n6 PH0.t2 17.0005
R4652 PH0.n7 PH0.t9 17.0005
R4653 PH0.n9 PH0.t5 17.0005
R4654 PH0.n10 PH0.t6 17.0005
R4655 PH0.n12 PH0.t4 17.0005
R4656 PH0.n21 PH0.t1 17.0005
R4657 PH0.n17 PH0.t11 15.0005
R4658 PH0.n0 PH0.t12 15.0005
R4659 PH0 PH0.t10 15.0005
R4660 PH0.n21 PH0.n19 9.9201
R4661 PH0.n13 PH0.n12 9.91525
R4662 PH0.n15 PH0.n3 9.12325
R4663 PH0.n14 PH0.n6 9.12325
R4664 PH0.n13 PH0.n9 9.12325
R4665 PH0.n16 PH0 9.0005
R4666 PH0.n19 PH0.n0 9.0005
R4667 PH0.n18 PH0.n17 9.0005
R4668 PH0.n16 PH0.n15 3.2455
R4669 PH0.n18 PH0.n16 2.13427
R4670 PH0.n3 PH0 1.19877
R4671 PH0.n6 PH0 1.19877
R4672 PH0.n9 PH0 1.19877
R4673 PH0.n12 PH0 1.19877
R4674 PH0.n15 PH0.n14 0.7925
R4675 PH0.n2 PH0 0.559983
R4676 PH0.n5 PH0 0.559983
R4677 PH0.n8 PH0 0.559983
R4678 PH0.n11 PH0 0.559983
R4679 PH0.n19 PH0.n18 0.4405
R4680 PH0.n14 PH0 0.4273
R4681 PH0 PH0.n13 0.3657
R4682 PH0.n20 PH0 0.3525
R4683 PH0.n2 PH0 0.292688
R4684 PH0.n5 PH0 0.292688
R4685 PH0.n8 PH0 0.292688
R4686 PH0.n11 PH0 0.292688
R4687 PH0 PH0.n1 0.282375
R4688 PH0 PH0.n4 0.282375
R4689 PH0 PH0.n7 0.282375
R4690 PH0 PH0.n10 0.282375
R4691 PH0.n22 PH0 0.210188
R4692 PH0 PH0.n22 0.162063
R4693 PH0.n1 PH0 0.089875
R4694 PH0.n4 PH0 0.089875
R4695 PH0.n7 PH0 0.089875
R4696 PH0.n10 PH0 0.089875
R4697 PH0.n0 PH0 0.0555
R4698 PH0.n3 PH0.n2 0.0403276
R4699 PH0.n6 PH0.n5 0.0403276
R4700 PH0.n9 PH0.n8 0.0403276
R4701 PH0.n12 PH0.n11 0.0403276
R4702 PH0.n22 PH0.n21 0.0403276
R4703 PH0.n21 PH0.n20 0.0403276
R4704 PH0.n17 PH0 0.0151667
R4705 PH0.n0 PH0 0.0115
R4706 PH0.n20 PH0 0.00998276
R4707 PH1.n17 PH1.n15 25.5471
R4708 PH1.n7 PH1.t6 17.0005
R4709 PH1.n9 PH1.t3 17.0005
R4710 PH1.n4 PH1.t9 17.0005
R4711 PH1.n6 PH1.t5 17.0005
R4712 PH1.n1 PH1.t7 17.0005
R4713 PH1.n3 PH1.t2 17.0005
R4714 PH1.n12 PH1.t8 17.0005
R4715 PH1.n14 PH1.t4 17.0005
R4716 PH1.n0 PH1.t1 17.0005
R4717 PH1.n22 PH1.t0 17.0005
R4718 PH1.n20 PH1.t12 15.0005
R4719 PH1.n18 PH1.t10 15.0005
R4720 PH1.n16 PH1.t11 15.0005
R4721 PH1.n22 PH1.n21 9.9157
R4722 PH1.n10 PH1.n9 9.91525
R4723 PH1.n15 PH1.n14 9.15359
R4724 PH1.n10 PH1.n6 9.12325
R4725 PH1.n11 PH1.n3 9.12325
R4726 PH1.n17 PH1.n16 9.0005
R4727 PH1.n19 PH1.n18 9.0005
R4728 PH1.n21 PH1.n20 9.0005
R4729 PH1.n19 PH1.n17 2.13427
R4730 PH1.n9 PH1 1.19877
R4731 PH1.n6 PH1 1.19877
R4732 PH1.n3 PH1 1.19877
R4733 PH1.n14 PH1 1.19877
R4734 PH1.n22 PH1 1.19877
R4735 PH1.n15 PH1.n11 0.7287
R4736 PH1.n8 PH1 0.559983
R4737 PH1.n5 PH1 0.559983
R4738 PH1.n2 PH1 0.559983
R4739 PH1.n13 PH1 0.559983
R4740 PH1 PH1.n23 0.559983
R4741 PH1.n21 PH1.n19 0.4405
R4742 PH1.n11 PH1 0.4273
R4743 PH1 PH1.n10 0.3657
R4744 PH1.n8 PH1 0.292688
R4745 PH1.n5 PH1 0.292688
R4746 PH1.n2 PH1 0.292688
R4747 PH1.n13 PH1 0.292688
R4748 PH1.n23 PH1 0.292688
R4749 PH1 PH1.n7 0.282375
R4750 PH1 PH1.n4 0.282375
R4751 PH1 PH1.n1 0.282375
R4752 PH1 PH1.n12 0.282375
R4753 PH1 PH1.n0 0.282375
R4754 PH1.n7 PH1 0.089875
R4755 PH1.n4 PH1 0.089875
R4756 PH1.n1 PH1 0.089875
R4757 PH1.n12 PH1 0.089875
R4758 PH1.n0 PH1 0.089875
R4759 PH1.n18 PH1 0.0555
R4760 PH1.n9 PH1.n8 0.0403276
R4761 PH1.n6 PH1.n5 0.0403276
R4762 PH1.n3 PH1.n2 0.0403276
R4763 PH1.n14 PH1.n13 0.0403276
R4764 PH1.n23 PH1.n22 0.0403276
R4765 PH1.n16 PH1 0.0316667
R4766 PH1.n20 PH1 0.0151667
R4767 PH1.n18 PH1 0.0115
R4768 PH1.n16 PH1 0.0115
C0 psdiff_2.buff_d8_1.inv_d2_0.VIN psdiff_2.buff_d8_1.inv_d8_0.VIN 0
C1 psdiff_2.CLKN buff_d8_3.inv_d4_0.VIN 0.01442f
C2 psdiff_1.VOUTDN psdiff_0.buff_d8_1.inv_d2_0.VIN 0.02057f
C3 psdiff_2.CLKN a_2299_n61# -0
C4 PH1 psdiff_2.VOUTDP 0.12986f
C5 psdiff_2.buff_d8_0.inv_d4_0.VIN buff_d8_4.inv_d8_0.VIN 0.00869f
C6 psdiff_1.buff_d8_1.inv_d8_0.VIN a_4188_1266# 0.02805f
C7 CTRL buff_d8_5.inv_d4_0.VIN 0.01928f
C8 PH3 buff_d8_3.inv_d2_0.VIN 0.01292f
C9 CTRL psdiff_1.VOUTDN 0.13404f
C10 psdiff_0.buff_d8_1.inv_d2_0.VIN VDD 0.34786f
C11 psdiff_2.CLKP a_4878_2568# -0
C12 buff_d8_5.inv_d8_0.VIN buff_d8_2.inv_d8_0.VIN 0
C13 PH4 buff_d8_2.inv_d4_0.VIN 0
C14 PH0 PH3 0.53359f
C15 PH5 psdiff_0.buff_d8_0.inv_d2_0.VIN 0.06582f
C16 CTRL VDD 8.15832f
C17 psdiff_1.buff_d8_0.inv_d2_0.VIN psdiff_0.buff_d8_0.inv_d8_0.VIN 0
C18 buff_d8_0.inv_d4_0.VIN psdiff_2.CLKP 0.04552f
C19 PH3 a_3031_1122# 0.00121f
C20 psdiff_2.CLKN buff_d8_3.inv_d2_0.VIN 0.01748f
C21 PH5 VDD 3.11881f
C22 a_7162_1266# psdiff_1.VOUTDP 0.08242f
C23 psdiff_2.buff_d8_1.inv_d2_0.VIN a_57_1122# 0.00545f
C24 psdiff_2.CLKP psdiff_1.VOUTDP 0.0727f
C25 psdiff_1.buff_d8_0.inv_d8_0.VIN VDD 1.46753f
C26 buff_d8_2.inv_d8_0.VIN psdiff_1.buff_d8_1.inv_d2_0.VIN 0.01857f
C27 psdiff_2.VOUTDP buff_d8_1.inv_d8_0.VIN 0
C28 PH2 buff_d8_2.inv_d8_0.VIN 0.00313f
C29 psdiff_2.VOUTDN psdiff_1.buff_d8_1.inv_d4_0.VIN 0.01001f
C30 CTRL buff_d8_2.inv_d2_0.VIN 0.00555f
C31 a_1544_2568# VDD -0
C32 CTRL buff_d8_1.inv_d4_0.VIN 0
C33 buff_d8_5.inv_d4_0.VIN psdiff_2.buff_d8_1.inv_d8_0.VIN 0.00782f
C34 a_4106_2568# VDD 0
C35 psdiff_2.CLKP a_4188_1266# 0.00743f
C36 a_6720_2568# VDD -0
C37 PH5 buff_d8_1.inv_d4_0.VIN 0
C38 psdiff_2.VOUTDN a_3386_2568# -0
C39 psdiff_1.buff_d8_1.inv_d8_0.VIN psdiff_0.buff_d8_1.inv_d2_0.VIN 0
C40 buff_d8_0.inv_d4_0.VIN buff_d8_0.inv_d2_0.VIN 0.25118f
C41 PH2 psdiff_0.buff_d8_1.inv_d8_0.VIN 0.00123f
C42 psdiff_0.buff_d8_0.inv_d4_0.VIN buff_d8_1.inv_d8_0.VIN 0.00869f
C43 psdiff_2.buff_d8_0.inv_d4_0.VIN psdiff_2.buff_d8_0.inv_d2_0.VIN 0.25118f
C44 psdiff_1.VOUTDN psdiff_2.VOUTDP 0.05107f
C45 psdiff_2.buff_d8_1.inv_d8_0.VIN VDD 1.41281f
C46 CTRL psdiff_1.buff_d8_1.inv_d8_0.VIN 0.00518f
C47 psdiff_1.VOUTDP psdiff_1.buff_d8_0.inv_d4_0.VIN 0.00265f
C48 buff_d8_5.inv_d8_0.VIN psdiff_2.buff_d8_1.inv_d4_0.VIN 0.02575f
C49 PH3 psdiff_2.VOUTDN 0.1399f
C50 CTRL buff_d8_1.inv_d2_0.VIN 0
C51 psdiff_2.VOUTDP VDD 1.50625f
C52 CTRL psdiff_2.buff_d8_0.inv_d8_0.VIN 0.03636f
C53 a_1214_1266# VDD 0.58802f
C54 a_4188_1266# psdiff_1.buff_d8_0.inv_d4_0.VIN 0.01515f
C55 a_7070_1867# VDD 0
C56 PH3 psdiff_2.buff_d8_0.inv_d4_0.VIN 0.04895f
C57 psdiff_0.buff_d8_0.inv_d4_0.VIN psdiff_0.buff_d8_0.inv_d2_0.VIN 0.25118f
C58 PH0 buff_d8_5.inv_d8_0.VIN 0.94899f
C59 a_57_1122# VDD 0.62345f
C60 psdiff_2.VOUTDN psdiff_2.CLKN 0.05199f
C61 PH1 a_6000_2568# 0
C62 buff_d8_4.inv_d8_0.VIN VDD 1.19774f
C63 psdiff_2.VOUTDP buff_d8_1.inv_d4_0.VIN 0.00155f
C64 psdiff_2.CLKP psdiff_0.buff_d8_1.inv_d2_0.VIN 0
C65 psdiff_0.buff_d8_0.inv_d4_0.VIN VDD 0.59837f
C66 CTRL a_3324_1867# -0
C67 psdiff_1.buff_d8_0.inv_d2_0.VIN buff_d8_3.inv_d8_0.VIN 0.00147f
C68 PH3 buff_d8_5.inv_d2_0.VIN 0.04119f
C69 CTRL buff_d8_2.inv_d4_0.VIN 0.01928f
C70 psdiff_0.buff_d8_1.inv_d8_0.VIN a_6005_1122# 0
C71 CTRL a_7162_1266# 0.08681f
C72 CTRL psdiff_2.CLKP 2.19073f
C73 psdiff_2.CLKN psdiff_2.buff_d8_0.inv_d4_0.VIN 0.01108f
C74 PH5 a_7162_1266# 0.00874f
C75 PH5 psdiff_2.CLKP 0.18066f
C76 psdiff_1.buff_d8_1.inv_d8_0.VIN psdiff_2.VOUTDP 0.00273f
C77 psdiff_2.CLKP psdiff_1.buff_d8_0.inv_d8_0.VIN 0
C78 psdiff_1.buff_d8_1.inv_d2_0.VIN a_3031_1122# 0.00545f
C79 buff_d8_3.inv_d4_0.VIN buff_d8_3.inv_d8_0.VIN 0.49436f
C80 psdiff_2.VOUTDP buff_d8_1.inv_d2_0.VIN 0.00628f
C81 psdiff_2.VOUTDP psdiff_2.buff_d8_0.inv_d8_0.VIN 1.00502f
C82 PH1 psdiff_2.CLKN 0.02397f
C83 PH2 buff_d8_0.inv_d8_0.VIN 0.94899f
C84 a_1214_1266# psdiff_2.buff_d8_0.inv_d8_0.VIN 0.01471f
C85 psdiff_1.VOUTDN psdiff_1.buff_d8_1.inv_d4_0.VIN 0
C86 a_4096_4532# VDD 0
C87 psdiff_0.buff_d8_1.inv_d2_0.VIN psdiff_0.buff_d8_1.inv_d4_0.VIN 0.25118f
C88 CTRL psdiff_1.buff_d8_0.inv_d4_0.VIN 0.00498f
C89 PH5 buff_d8_0.inv_d2_0.VIN 0.04119f
C90 buff_d8_5.inv_d8_0.VIN psdiff_2.VOUTDN 0.00179f
C91 psdiff_2.CLKP psdiff_2.buff_d8_1.inv_d8_0.VIN 0.00464f
C92 psdiff_1.buff_d8_1.inv_d4_0.VIN VDD 0.6697f
C93 CTRL psdiff_0.buff_d8_1.inv_d4_0.VIN 0.0038f
C94 buff_d8_3.inv_d2_0.VIN buff_d8_3.inv_d8_0.VIN 0
C95 psdiff_2.buff_d8_0.inv_d8_0.VIN buff_d8_4.inv_d8_0.VIN 0.04306f
C96 psdiff_1.buff_d8_0.inv_d8_0.VIN psdiff_1.buff_d8_0.inv_d4_0.VIN 0.49436f
C97 psdiff_2.buff_d8_0.inv_d2_0.VIN VDD 0.25757f
C98 psdiff_2.CLKP psdiff_2.VOUTDP 0.01585f
C99 psdiff_2.VOUTDN psdiff_1.buff_d8_1.inv_d2_0.VIN 0.02057f
C100 psdiff_2.CLKN buff_d8_1.inv_d8_0.VIN 0.00515f
C101 buff_d8_4.inv_d4_0.VIN VDD 0.52326f
C102 psdiff_2.CLKP a_1214_1266# 0.00743f
C103 PH3 buff_d8_5.inv_d4_0.VIN 0.02225f
C104 a_6000_2568# VDD 0
C105 buff_d8_5.inv_d8_0.VIN buff_d8_5.inv_d2_0.VIN 0
C106 PH1 psdiff_0.buff_d8_0.inv_d8_0.VIN 0.00429f
C107 psdiff_2.CLKP a_57_1122# 0.08404f
C108 psdiff_2.CLKP buff_d8_4.inv_d8_0.VIN 0
C109 PH3 VDD 3.53353f
C110 a_7162_1266# psdiff_0.buff_d8_0.inv_d4_0.VIN 0.01515f
C111 psdiff_2.CLKP psdiff_0.buff_d8_0.inv_d4_0.VIN 0.00398f
C112 psdiff_1.buff_d8_1.inv_d4_0.VIN psdiff_1.buff_d8_1.inv_d8_0.VIN 0.49436f
C113 psdiff_1.VOUTDN psdiff_2.CLKN 0.00398f
C114 buff_d8_4.inv_d2_0.VIN VDD 0.24588f
C115 buff_d8_5.inv_d8_0.VIN psdiff_2.buff_d8_1.inv_d2_0.VIN 0.01857f
C116 a_1122_1867# VDD 0
C117 PH4 CTRL 0.86537f
C118 psdiff_2.VOUTDP psdiff_1.buff_d8_0.inv_d4_0.VIN 0.01111f
C119 CTRL buff_d8_0.inv_d4_0.VIN 0.01437f
C120 PH1 PH2 0.05643f
C121 psdiff_2.CLKN VDD 1.6217f
C122 CTRL psdiff_1.VOUTDP 0.15174f
C123 psdiff_0.buff_d8_0.inv_d8_0.VIN buff_d8_1.inv_d8_0.VIN 0.04306f
C124 PH5 buff_d8_0.inv_d4_0.VIN 0.02225f
C125 psdiff_2.buff_d8_0.inv_d8_0.VIN psdiff_2.buff_d8_0.inv_d2_0.VIN 0
C126 PH5 psdiff_1.VOUTDP 0.13629f
C127 buff_d8_2.inv_d8_0.VIN buff_d8_0.inv_d8_0.VIN 0
C128 PH1 a_5571_n61# 0
C129 psdiff_1.VOUTDP psdiff_1.buff_d8_0.inv_d8_0.VIN 1.00829f
C130 psdiff_2.VOUTDN buff_d8_3.inv_d8_0.VIN 0
C131 buff_d8_3.inv_d2_0.VIN buff_d8_3.inv_d4_0.VIN 0.25118f
C132 psdiff_2.buff_d8_0.inv_d8_0.VIN buff_d8_4.inv_d4_0.VIN 0.02576f
C133 CTRL a_4188_1266# 0.08994f
C134 a_7475_n61# VDD 0
C135 psdiff_2.CLKN buff_d8_1.inv_d4_0.VIN 0.01516f
C136 PH3 a_3026_2568# 0
C137 a_4188_1266# psdiff_1.buff_d8_0.inv_d8_0.VIN 0.01471f
C138 buff_d8_0.inv_d8_0.VIN psdiff_0.buff_d8_1.inv_d8_0.VIN 0.04417f
C139 psdiff_2.CLKP psdiff_1.buff_d8_1.inv_d4_0.VIN 0.00179f
C140 psdiff_1.VOUTDN psdiff_0.buff_d8_0.inv_d8_0.VIN 0.01332f
C141 PH3 psdiff_2.buff_d8_0.inv_d8_0.VIN 0
C142 psdiff_0.buff_d8_0.inv_d8_0.VIN psdiff_0.buff_d8_0.inv_d2_0.VIN 0
C143 psdiff_2.CLKP psdiff_2.buff_d8_0.inv_d2_0.VIN 0
C144 buff_d8_5.inv_d8_0.VIN buff_d8_5.inv_d4_0.VIN 0.49436f
C145 psdiff_2.VOUTDN buff_d8_2.inv_d8_0.VIN 0.04405f
C146 PH0 psdiff_2.buff_d8_1.inv_d4_0.VIN 0
C147 psdiff_2.buff_d8_0.inv_d8_0.VIN buff_d8_4.inv_d2_0.VIN 0.01564f
C148 psdiff_0.buff_d8_0.inv_d8_0.VIN VDD 1.46755f
C149 psdiff_2.CLKP buff_d8_4.inv_d4_0.VIN 0
C150 PH1 a_6005_1122# 0.00121f
C151 a_6703_n61# VDD 0
C152 PH1 buff_d8_3.inv_d8_0.VIN 0.93117f
C153 buff_d8_5.inv_d8_0.VIN VDD 1.5213f
C154 psdiff_2.CLKN buff_d8_1.inv_d2_0.VIN 0.15482f
C155 psdiff_2.CLKN psdiff_2.buff_d8_0.inv_d8_0.VIN 0.00542f
C156 psdiff_2.VOUTDP psdiff_1.VOUTDP 0.30802f
C157 PH2 psdiff_1.VOUTDN 0.0042f
C158 PH3 psdiff_2.CLKP 0.018f
C159 psdiff_0.buff_d8_0.inv_d8_0.VIN buff_d8_1.inv_d4_0.VIN 0.02576f
C160 buff_d8_5.inv_d2_0.VIN buff_d8_2.inv_d8_0.VIN 0
C161 psdiff_1.buff_d8_1.inv_d2_0.VIN VDD 0.34786f
C162 psdiff_1.VOUTDN a_5290_2568# -0
C163 CTRL psdiff_0.buff_d8_1.inv_d2_0.VIN 0.01288f
C164 PH2 VDD 3.19734f
C165 a_4188_1266# psdiff_2.VOUTDP 0.08242f
C166 psdiff_2.CLKP buff_d8_4.inv_d2_0.VIN 0.0012f
C167 psdiff_2.VOUTDN buff_d8_3.inv_d4_0.VIN 0
C168 psdiff_1.VOUTDP buff_d8_4.inv_d8_0.VIN 0.01948f
C169 PH1 buff_d8_2.inv_d8_0.VIN 0.01375f
C170 psdiff_1.VOUTDP psdiff_0.buff_d8_0.inv_d4_0.VIN 0.01299f
C171 PH5 CTRL 0.51865f
C172 psdiff_2.CLKP psdiff_2.CLKN 0.04542f
C173 CTRL psdiff_1.buff_d8_0.inv_d8_0.VIN 0.03646f
C174 a_7852_2568# VDD -0
C175 PH2 buff_d8_2.inv_d2_0.VIN 0.01457f
C176 psdiff_2.VOUTDN psdiff_2.buff_d8_1.inv_d4_0.VIN 0
C177 PH1 psdiff_1.buff_d8_0.inv_d2_0.VIN 0.06582f
C178 psdiff_0.buff_d8_0.inv_d8_0.VIN buff_d8_1.inv_d2_0.VIN 0.01564f
C179 psdiff_2.VOUTDN buff_d8_3.inv_d2_0.VIN 0.00112f
C180 psdiff_1.VOUTDN a_6005_1122# 0.0785f
C181 psdiff_1.VOUTDN a_5588_1867# -0
C182 psdiff_1.buff_d8_1.inv_d2_0.VIN psdiff_1.buff_d8_1.inv_d8_0.VIN 0
C183 PH1 buff_d8_3.inv_d4_0.VIN 0
C184 PH0 psdiff_2.VOUTDN 0
C185 CTRL psdiff_2.buff_d8_1.inv_d8_0.VIN 0.00496f
C186 a_6005_1122# VDD 0.62396f
C187 a_4501_n61# VDD 0
C188 PH4 psdiff_1.buff_d8_1.inv_d4_0.VIN 0
C189 buff_d8_3.inv_d8_0.VIN VDD 1.21792f
C190 psdiff_2.CLKN psdiff_1.buff_d8_0.inv_d4_0.VIN 0.00378f
C191 psdiff_2.VOUTDN a_3031_1122# 0.0785f
C192 psdiff_2.VOUTDP a_6281_n762# -0
C193 a_7162_1266# psdiff_0.buff_d8_0.inv_d8_0.VIN 0.01471f
C194 psdiff_2.CLKP psdiff_0.buff_d8_0.inv_d8_0.VIN 0.00696f
C195 CTRL psdiff_2.VOUTDP 0.18984f
C196 psdiff_1.VOUTDP psdiff_2.buff_d8_0.inv_d2_0.VIN 0.01386f
C197 buff_d8_5.inv_d4_0.VIN buff_d8_2.inv_d8_0.VIN 0
C198 buff_d8_5.inv_d8_0.VIN psdiff_2.CLKP 0
C199 buff_d8_2.inv_d8_0.VIN psdiff_1.VOUTDN 0.00179f
C200 CTRL a_1214_1266# 0.08994f
C201 psdiff_2.VOUTDP psdiff_1.buff_d8_0.inv_d8_0.VIN 0.00561f
C202 a_3729_n61# VDD 0
C203 psdiff_2.buff_d8_1.inv_d2_0.VIN psdiff_2.buff_d8_1.inv_d4_0.VIN 0.25118f
C204 CTRL a_57_1122# 0.22352f
C205 buff_d8_2.inv_d8_0.VIN VDD 1.52683f
C206 psdiff_2.VOUTDP a_n79_n762# -0
C207 PH2 buff_d8_2.inv_d4_0.VIN 0.00282f
C208 psdiff_2.CLKP psdiff_1.buff_d8_1.inv_d2_0.VIN 0
C209 CTRL buff_d8_4.inv_d8_0.VIN 0.00546f
C210 PH3 PH4 0.05643f
C211 PH2 psdiff_2.CLKP 0
C212 psdiff_1.VOUTDN psdiff_0.buff_d8_1.inv_d8_0.VIN 0.00391f
C213 PH3 psdiff_1.VOUTDP 0.01254f
C214 PH5 psdiff_0.buff_d8_0.inv_d4_0.VIN 0.04895f
C215 PH0 psdiff_2.buff_d8_1.inv_d2_0.VIN 0
C216 psdiff_1.buff_d8_0.inv_d2_0.VIN VDD 0.25752f
C217 buff_d8_2.inv_d8_0.VIN buff_d8_2.inv_d2_0.VIN 0
C218 psdiff_2.CLKP a_7852_2568# -0
C219 psdiff_0.buff_d8_1.inv_d8_0.VIN VDD 1.40639f
C220 buff_d8_3.inv_d8_0.VIN buff_d8_1.inv_d2_0.VIN 0
C221 PH1 buff_d8_0.inv_d8_0.VIN 0.00419f
C222 psdiff_2.buff_d8_1.inv_d8_0.VIN a_1214_1266# 0.02805f
C223 psdiff_2.CLKN psdiff_1.VOUTDP 0.81782f
C224 psdiff_1.VOUTDP a_8247_n61# -0
C225 buff_d8_3.inv_d4_0.VIN VDD 0.5268f
C226 psdiff_2.buff_d8_1.inv_d8_0.VIN a_57_1122# 0
C227 buff_d8_2.inv_d8_0.VIN psdiff_1.buff_d8_1.inv_d8_0.VIN 0.04417f
C228 a_1904_2568# VDD -0
C229 buff_d8_5.inv_d2_0.VIN psdiff_2.VOUTDN 0.17391f
C230 a_4518_2568# VDD -0
C231 PH2 psdiff_0.buff_d8_1.inv_d4_0.VIN 0
C232 a_6005_1122# a_7162_1266# 0.01277f
C233 psdiff_2.CLKP a_6005_1122# 0.00647f
C234 a_7080_2568# VDD 0
C235 CTRL psdiff_1.buff_d8_1.inv_d4_0.VIN 0.0038f
C236 psdiff_2.buff_d8_1.inv_d4_0.VIN VDD 0.66998f
C237 psdiff_2.VOUTDP buff_d8_4.inv_d8_0.VIN 0.15238f
C238 psdiff_2.CLKP buff_d8_3.inv_d8_0.VIN 0
C239 psdiff_2.VOUTDP psdiff_0.buff_d8_0.inv_d4_0.VIN 0
C240 a_57_1122# a_1214_1266# 0.01277f
C241 PH0 buff_d8_5.inv_d4_0.VIN 0
C242 CTRL psdiff_2.buff_d8_0.inv_d2_0.VIN 0.00172f
C243 a_1527_n61# VDD 0
C244 buff_d8_3.inv_d2_0.VIN VDD 0.24829f
C245 CTRL a_3386_2568# -0
C246 CTRL buff_d8_4.inv_d4_0.VIN 0.00274f
C247 psdiff_2.buff_d8_0.inv_d2_0.VIN psdiff_1.buff_d8_0.inv_d8_0.VIN 0
C248 psdiff_1.VOUTDN a_3031_1122# 0
C249 psdiff_1.VOUTDP psdiff_0.buff_d8_0.inv_d8_0.VIN 0.00881f
C250 psdiff_1.VOUTDP a_2237_n762# -0
C251 PH0 VDD 3.01912f
C252 PH4 buff_d8_5.inv_d8_0.VIN 0.00313f
C253 buff_d8_2.inv_d8_0.VIN buff_d8_2.inv_d4_0.VIN 0.49436f
C254 a_3031_1122# VDD 0.62396f
C255 a_755_n61# VDD 0
C256 psdiff_1.VOUTDN buff_d8_0.inv_d8_0.VIN 0.04405f
C257 PH3 CTRL 0.75034f
C258 PH4 psdiff_1.buff_d8_1.inv_d2_0.VIN 0
C259 psdiff_2.VOUTDP a_5571_n762# -0
C260 psdiff_1.buff_d8_0.inv_d4_0.VIN buff_d8_3.inv_d8_0.VIN 0.00869f
C261 psdiff_0.buff_d8_1.inv_d4_0.VIN a_6005_1122# 0.01613f
C262 CTRL buff_d8_4.inv_d2_0.VIN 0.00241f
C263 PH3 psdiff_1.buff_d8_0.inv_d8_0.VIN 0.00429f
C264 buff_d8_0.inv_d8_0.VIN VDD 1.52624f
C265 PH2 buff_d8_0.inv_d4_0.VIN 0
C266 psdiff_2.CLKP psdiff_1.buff_d8_0.inv_d2_0.VIN 0
C267 psdiff_0.buff_d8_1.inv_d8_0.VIN a_7162_1266# 0.02805f
C268 psdiff_2.CLKP psdiff_0.buff_d8_1.inv_d8_0.VIN 1.01673f
C269 CTRL psdiff_2.CLKN 0.31851f
C270 CTRL a_6298_1867# -0
C271 psdiff_2.VOUTDP psdiff_2.buff_d8_0.inv_d2_0.VIN 0
C272 buff_d8_5.inv_d4_0.VIN psdiff_2.VOUTDN 0.04552f
C273 buff_d8_2.inv_d2_0.VIN buff_d8_0.inv_d8_0.VIN 0
C274 PH5 psdiff_2.CLKN 0
C275 psdiff_2.CLKN psdiff_1.buff_d8_0.inv_d8_0.VIN 0.05771f
C276 psdiff_2.VOUTDP buff_d8_4.inv_d4_0.VIN 0.09061f
C277 psdiff_2.CLKP buff_d8_3.inv_d4_0.VIN 0
C278 psdiff_1.buff_d8_1.inv_d8_0.VIN a_3031_1122# 0
C279 PH1 buff_d8_1.inv_d8_0.VIN 0
C280 PH3 psdiff_2.buff_d8_1.inv_d8_0.VIN 0.03874f
C281 psdiff_2.CLKP a_1904_2568# -0
C282 psdiff_2.VOUTDN VDD 1.28481f
C283 psdiff_2.buff_d8_0.inv_d2_0.VIN buff_d8_4.inv_d8_0.VIN 0.00147f
C284 buff_d8_0.inv_d2_0.VIN psdiff_0.buff_d8_1.inv_d8_0.VIN 0.00139f
C285 psdiff_1.buff_d8_0.inv_d4_0.VIN psdiff_1.buff_d8_0.inv_d2_0.VIN 0.25118f
C286 psdiff_2.CLKP psdiff_2.buff_d8_1.inv_d4_0.VIN 0.00194f
C287 PH3 psdiff_2.VOUTDP 0.00391f
C288 buff_d8_5.inv_d4_0.VIN buff_d8_5.inv_d2_0.VIN 0.25118f
C289 a_7070_4532# VDD 0
C290 buff_d8_4.inv_d4_0.VIN buff_d8_4.inv_d8_0.VIN 0.49436f
C291 psdiff_2.buff_d8_0.inv_d4_0.VIN VDD 0.5982f
C292 PH3 a_1214_1266# 0.00874f
C293 psdiff_2.buff_d8_1.inv_d8_0.VIN psdiff_2.CLKN 0.00273f
C294 psdiff_0.buff_d8_1.inv_d4_0.VIN psdiff_0.buff_d8_1.inv_d8_0.VIN 0.49436f
C295 psdiff_2.VOUTDP buff_d8_4.inv_d2_0.VIN 0.20899f
C296 psdiff_2.CLKP buff_d8_3.inv_d2_0.VIN 0
C297 CTRL psdiff_0.buff_d8_0.inv_d8_0.VIN 0.02782f
C298 psdiff_1.VOUTDP buff_d8_3.inv_d8_0.VIN 0.02378f
C299 PH1 psdiff_1.VOUTDN 0.1399f
C300 buff_d8_5.inv_d2_0.VIN VDD 0.26044f
C301 PH5 psdiff_0.buff_d8_0.inv_d8_0.VIN 0
C302 psdiff_1.VOUTDN a_6360_2568# -0
C303 a_1132_2568# VDD 0
C304 CTRL buff_d8_5.inv_d8_0.VIN 0.04515f
C305 psdiff_2.CLKN psdiff_2.VOUTDP 0.62558f
C306 PH3 buff_d8_4.inv_d8_0.VIN 0.93132f
C307 a_3746_2568# VDD -0
C308 PH1 VDD 3.55773f
C309 a_1214_1266# psdiff_2.CLKN 0.08242f
C310 a_4188_1266# a_6005_1122# 0.00571f
C311 psdiff_2.CLKP a_3031_1122# 0.00645f
C312 psdiff_2.VOUTDN psdiff_1.buff_d8_1.inv_d8_0.VIN 0.00391f
C313 PH2 psdiff_0.buff_d8_1.inv_d2_0.VIN 0
C314 a_772_2568# VDD -0
C315 buff_d8_4.inv_d2_0.VIN buff_d8_4.inv_d8_0.VIN 0
C316 PH4 buff_d8_2.inv_d8_0.VIN 0.94899f
C317 psdiff_2.buff_d8_1.inv_d2_0.VIN VDD 0.34536f
C318 CTRL psdiff_1.buff_d8_1.inv_d2_0.VIN 0.01288f
C319 buff_d8_2.inv_d4_0.VIN buff_d8_0.inv_d8_0.VIN 0
C320 PH2 CTRL 0.86522f
C321 buff_d8_0.inv_d8_0.VIN psdiff_2.CLKP 0.00179f
C322 PH1 buff_d8_2.inv_d2_0.VIN 0.04119f
C323 psdiff_2.CLKN buff_d8_4.inv_d8_0.VIN 0.13522f
C324 psdiff_1.VOUTDP a_3369_n61# 0
C325 psdiff_1.VOUTDN buff_d8_1.inv_d8_0.VIN 0
C326 psdiff_2.CLKN psdiff_0.buff_d8_0.inv_d4_0.VIN 0
C327 PH2 PH5 0.53359f
C328 psdiff_0.buff_d8_0.inv_d2_0.VIN buff_d8_1.inv_d8_0.VIN 0.00147f
C329 a_52_2568# VDD 0
C330 psdiff_1.VOUTDP a_3009_n61# -0
C331 psdiff_1.VOUTDP psdiff_1.buff_d8_0.inv_d2_0.VIN 0
C332 buff_d8_1.inv_d8_0.VIN VDD 1.21278f
C333 psdiff_2.buff_d8_0.inv_d8_0.VIN psdiff_2.buff_d8_0.inv_d4_0.VIN 0.49436f
C334 buff_d8_5.inv_d8_0.VIN psdiff_2.buff_d8_1.inv_d8_0.VIN 0.04417f
C335 buff_d8_0.inv_d4_0.VIN psdiff_0.buff_d8_1.inv_d8_0.VIN 0.00782f
C336 a_4096_1867# VDD 0
C337 psdiff_2.VOUTDP psdiff_0.buff_d8_0.inv_d8_0.VIN 0.05035f
C338 psdiff_0.buff_d8_1.inv_d8_0.VIN psdiff_1.VOUTDP 0.00273f
C339 PH1 psdiff_1.buff_d8_1.inv_d8_0.VIN 0.03874f
C340 buff_d8_0.inv_d8_0.VIN buff_d8_0.inv_d2_0.VIN 0
C341 psdiff_2.VOUTDN psdiff_2.CLKP 0.01698f
C342 psdiff_2.buff_d8_1.inv_d8_0.VIN psdiff_1.buff_d8_1.inv_d2_0.VIN 0
C343 psdiff_0.buff_d8_1.inv_d2_0.VIN a_6005_1122# 0.00545f
C344 psdiff_1.VOUTDP buff_d8_3.inv_d4_0.VIN 0.0253f
C345 PH1 buff_d8_1.inv_d2_0.VIN 0.01386f
C346 PH3 psdiff_2.buff_d8_0.inv_d2_0.VIN 0.06557f
C347 buff_d8_1.inv_d4_0.VIN buff_d8_1.inv_d8_0.VIN 0.49436f
C348 buff_d8_5.inv_d4_0.VIN VDD 0.62468f
C349 buff_d8_0.inv_d8_0.VIN psdiff_0.buff_d8_1.inv_d4_0.VIN 0.02575f
C350 CTRL a_6005_1122# 0.2274f
C351 psdiff_1.VOUTDN VDD 1.28481f
C352 PH3 buff_d8_4.inv_d4_0.VIN 0
C353 psdiff_0.buff_d8_0.inv_d8_0.VIN psdiff_0.buff_d8_0.inv_d4_0.VIN 0.49436f
C354 CTRL buff_d8_3.inv_d8_0.VIN 0.00276f
C355 psdiff_2.CLKP psdiff_2.buff_d8_0.inv_d4_0.VIN 0
C356 psdiff_0.buff_d8_0.inv_d2_0.VIN VDD 0.25495f
C357 buff_d8_4.inv_d2_0.VIN buff_d8_4.inv_d4_0.VIN 0.25118f
C358 psdiff_1.buff_d8_0.inv_d8_0.VIN buff_d8_3.inv_d8_0.VIN 0.04306f
C359 psdiff_2.CLKN psdiff_2.buff_d8_0.inv_d2_0.VIN 0.00993f
C360 buff_d8_2.inv_d2_0.VIN psdiff_1.VOUTDN 0.17391f
C361 psdiff_1.VOUTDP buff_d8_3.inv_d2_0.VIN 0.15757f
C362 PH1 buff_d8_2.inv_d4_0.VIN 0.02225f
C363 psdiff_2.CLKN buff_d8_4.inv_d4_0.VIN 0
C364 buff_d8_1.inv_d2_0.VIN buff_d8_1.inv_d8_0.VIN 0
C365 psdiff_1.VOUTDN buff_d8_1.inv_d4_0.VIN 0
C366 PH1 psdiff_2.CLKP 0.018f
C367 psdiff_2.VOUTDP a_5273_n61# -0
C368 buff_d8_2.inv_d2_0.VIN VDD 0.26044f
C369 CTRL buff_d8_2.inv_d8_0.VIN 0.06594f
C370 a_1122_4532# VDD 0
C371 psdiff_2.CLKP psdiff_2.buff_d8_1.inv_d2_0.VIN 0.00167f
C372 buff_d8_1.inv_d4_0.VIN VDD 0.52648f
C373 psdiff_1.VOUTDN psdiff_1.buff_d8_1.inv_d8_0.VIN 1.01209f
C374 PH3 psdiff_2.CLKN 0.11974f
C375 psdiff_0.buff_d8_1.inv_d2_0.VIN psdiff_0.buff_d8_1.inv_d8_0.VIN 0
C376 CTRL psdiff_1.buff_d8_0.inv_d2_0.VIN 0.00172f
C377 buff_d8_0.inv_d8_0.VIN buff_d8_0.inv_d4_0.VIN 0.49436f
C378 psdiff_1.VOUTDN buff_d8_1.inv_d2_0.VIN 0.00112f
C379 psdiff_1.buff_d8_1.inv_d8_0.VIN VDD 1.41268f
C380 CTRL psdiff_0.buff_d8_1.inv_d8_0.VIN 0
C381 psdiff_2.VOUTDP buff_d8_3.inv_d8_0.VIN 0.19927f
C382 a_3026_2568# VDD 0
C383 psdiff_2.CLKP buff_d8_1.inv_d8_0.VIN 0.00396f
C384 psdiff_1.buff_d8_0.inv_d8_0.VIN psdiff_1.buff_d8_0.inv_d2_0.VIN 0
C385 a_3031_1122# a_4188_1266# 0.01277f
C386 PH5 psdiff_0.buff_d8_1.inv_d8_0.VIN 0.03875f
C387 psdiff_2.VOUTDN a_2316_2568# -0
C388 PH1 psdiff_1.buff_d8_0.inv_d4_0.VIN 0.04895f
C389 psdiff_2.buff_d8_0.inv_d8_0.VIN VDD 1.46194f
C390 buff_d8_1.inv_d2_0.VIN VDD 0.24844f
C391 CTRL buff_d8_3.inv_d4_0.VIN 0.00135f
C392 buff_d8_2.inv_d2_0.VIN psdiff_1.buff_d8_1.inv_d8_0.VIN 0.00139f
C393 PH4 psdiff_2.VOUTDN 0.0042f
C394 psdiff_1.buff_d8_0.inv_d8_0.VIN buff_d8_3.inv_d4_0.VIN 0.02568f
C395 psdiff_1.buff_d8_1.inv_d2_0.VIN psdiff_1.buff_d8_1.inv_d4_0.VIN 0.25118f
C396 buff_d8_2.inv_d4_0.VIN psdiff_1.VOUTDN 0.04552f
C397 psdiff_2.VOUTDN psdiff_1.VOUTDP 0.00405f
C398 psdiff_1.VOUTDN psdiff_2.CLKP 0.01805f
C399 CTRL psdiff_2.buff_d8_1.inv_d4_0.VIN 0.00193f
C400 buff_d8_1.inv_d2_0.VIN buff_d8_1.inv_d4_0.VIN 0.25118f
C401 psdiff_2.CLKP psdiff_0.buff_d8_0.inv_d2_0.VIN 0.00138f
C402 buff_d8_2.inv_d4_0.VIN VDD 0.62468f
C403 PH3 buff_d8_5.inv_d8_0.VIN 0.01375f
C404 a_7162_1266# VDD 0.58751f
C405 CTRL buff_d8_3.inv_d2_0.VIN 0.00109f
C406 psdiff_2.CLKP VDD 1.79398f
C407 psdiff_2.VOUTDN a_2614_1867# -0
C408 psdiff_2.VOUTDP psdiff_1.buff_d8_0.inv_d2_0.VIN 0.01f
C409 PH4 buff_d8_5.inv_d2_0.VIN 0.01457f
C410 psdiff_2.CLKN psdiff_0.buff_d8_0.inv_d8_0.VIN 1.00591f
C411 psdiff_1.buff_d8_0.inv_d8_0.VIN buff_d8_3.inv_d2_0.VIN 0.01571f
C412 PH0 CTRL 0.58067f
C413 buff_d8_2.inv_d4_0.VIN buff_d8_2.inv_d2_0.VIN 0.25118f
C414 PH3 psdiff_1.buff_d8_1.inv_d2_0.VIN 0.00297f
C415 PH4 PH1 0.53359f
C416 CTRL a_3031_1122# 0.2274f
C417 psdiff_2.CLKP buff_d8_1.inv_d4_0.VIN 0.00195f
C418 psdiff_2.VOUTDP buff_d8_3.inv_d4_0.VIN 0.07546f
C419 buff_d8_0.inv_d8_0.VIN psdiff_0.buff_d8_1.inv_d2_0.VIN 0.01857f
C420 psdiff_2.CLKN a_6343_n61# 0
C421 PH1 psdiff_1.VOUTDP 0.01068f
C422 psdiff_2.buff_d8_1.inv_d4_0.VIN psdiff_2.buff_d8_1.inv_d8_0.VIN 0.49436f
C423 buff_d8_0.inv_d2_0.VIN VDD 0.25754f
C424 psdiff_1.VOUTDN psdiff_0.buff_d8_1.inv_d4_0.VIN 0.01001f
C425 CTRL buff_d8_0.inv_d8_0.VIN 0.06517f
C426 psdiff_1.buff_d8_0.inv_d4_0.VIN VDD 0.59837f
C427 psdiff_2.CLKN a_5983_n61# -0
C428 buff_d8_2.inv_d4_0.VIN psdiff_1.buff_d8_1.inv_d8_0.VIN 0.00782f
C429 PH5 buff_d8_0.inv_d8_0.VIN 0.01375f
C430 psdiff_2.CLKP psdiff_1.buff_d8_1.inv_d8_0.VIN 0.00464f
C431 psdiff_0.buff_d8_1.inv_d4_0.VIN VDD 0.6697f
C432 PH1 a_4188_1266# 0.00874f
C433 psdiff_2.CLKN a_5571_n61# 0
C434 PH0 psdiff_2.buff_d8_1.inv_d8_0.VIN 0.00123f
C435 psdiff_2.VOUTDP buff_d8_3.inv_d2_0.VIN 0.05924f
C436 psdiff_2.CLKP buff_d8_1.inv_d2_0.VIN 0
C437 psdiff_2.CLKP psdiff_2.buff_d8_0.inv_d8_0.VIN 0.01465f
C438 psdiff_2.CLKP a_8264_2568# -0
C439 psdiff_1.VOUTDP buff_d8_1.inv_d8_0.VIN 0.07631f
C440 psdiff_2.buff_d8_1.inv_d4_0.VIN a_57_1122# 0.01613f
C441 buff_d8_2.inv_d8_0.VIN psdiff_1.buff_d8_1.inv_d4_0.VIN 0.02575f
C442 CTRL psdiff_2.VOUTDN 0.13703f
C443 PH3 buff_d8_3.inv_d8_0.VIN 0
C444 PH4 buff_d8_5.inv_d4_0.VIN 0.00282f
C445 psdiff_2.VOUTDN psdiff_1.buff_d8_0.inv_d8_0.VIN 0.01332f
C446 buff_d8_4.inv_d8_0.VIN buff_d8_3.inv_d2_0.VIN 0
C447 PH4 psdiff_1.VOUTDN 0
C448 a_1214_1266# a_3031_1122# 0.00571f
C449 a_4878_2568# VDD -0
C450 CTRL psdiff_2.buff_d8_0.inv_d4_0.VIN 0.00498f
C451 psdiff_2.CLKP a_7162_1266# 0.01643f
C452 psdiff_2.VOUTDP a_395_n61# 0
C453 psdiff_1.VOUTDN psdiff_1.VOUTDP 0.03297f
C454 a_7492_2568# VDD -0
C455 psdiff_2.CLKN buff_d8_3.inv_d8_0.VIN 0.06484f
C456 psdiff_1.VOUTDP psdiff_0.buff_d8_0.inv_d2_0.VIN 0.01074f
C457 PH4 VDD 3.19734f
C458 CTRL buff_d8_5.inv_d2_0.VIN 0.00555f
C459 PH1 psdiff_0.buff_d8_1.inv_d2_0.VIN 0.00297f
C460 buff_d8_0.inv_d4_0.VIN VDD 0.62357f
C461 psdiff_2.VOUTDP a_35_n61# -0
C462 PH3 buff_d8_2.inv_d8_0.VIN 0.00419f
C463 psdiff_1.VOUTDP VDD 1.57846f
C464 PH1 CTRL 0.75062f
C465 psdiff_1.VOUTDN a_4188_1266# 0.009f
C466 psdiff_2.VOUTDN psdiff_2.buff_d8_1.inv_d8_0.VIN 1.01209f
C467 CTRL a_6360_2568# -0
C468 CTRL psdiff_2.buff_d8_1.inv_d2_0.VIN 0.00105f
C469 PH1 psdiff_1.buff_d8_0.inv_d8_0.VIN 0
C470 buff_d8_0.inv_d2_0.VIN psdiff_2.CLKP 0.17391f
C471 psdiff_2.VOUTDN psdiff_2.VOUTDP 0.03282f
C472 a_4188_1266# VDD 0.58802f
C473 psdiff_1.VOUTDP buff_d8_1.inv_d4_0.VIN 0.01273f
C474 PH3 a_2597_n61# 0
C475 psdiff_2.CLKP psdiff_1.buff_d8_0.inv_d4_0.VIN 0
C476 psdiff_2.VOUTDN a_1214_1266# 0.009f
C477 psdiff_2.CLKP psdiff_0.buff_d8_1.inv_d4_0.VIN 0.0025f
C478 PH4 psdiff_1.buff_d8_1.inv_d8_0.VIN 0.00123f
C479 psdiff_2.CLKN psdiff_1.buff_d8_0.inv_d2_0.VIN 0.01541f
C480 CTRL buff_d8_1.inv_d8_0.VIN 0
C481 psdiff_2.VOUTDP psdiff_2.buff_d8_0.inv_d4_0.VIN 0
C482 buff_d8_5.inv_d2_0.VIN psdiff_2.buff_d8_1.inv_d8_0.VIN 0.00139f
C483 psdiff_2.VOUTDN a_57_1122# 0
C484 PH5 buff_d8_1.inv_d8_0.VIN 0.93117f
C485 a_1214_1266# psdiff_2.buff_d8_0.inv_d4_0.VIN 0.01515f
C486 psdiff_1.buff_d8_1.inv_d4_0.VIN a_3031_1122# 0.01613f
C487 psdiff_1.VOUTDP buff_d8_1.inv_d2_0.VIN 0.00942f
C488 VDD VSS 56.63144f
C489 a_8185_n762# VSS 0.00384f $ **FLOATING
C490 a_7825_n762# VSS 0.00384f $ **FLOATING
C491 a_7465_n762# VSS 0.00384f $ **FLOATING
C492 a_7053_n762# VSS 0.00838f $ **FLOATING
C493 a_6693_n762# VSS 0.00384f $ **FLOATING
C494 a_6281_n762# VSS 0.00838f $ **FLOATING
C495 a_5869_n762# VSS 0.00838f $ **FLOATING
C496 a_5571_n762# VSS 0.00838f $ **FLOATING
C497 a_5211_n762# VSS 0.00384f $ **FLOATING
C498 a_4851_n762# VSS 0.00384f $ **FLOATING
C499 a_4491_n762# VSS 0.00384f $ **FLOATING
C500 a_4079_n762# VSS 0.00838f $ **FLOATING
C501 a_3719_n762# VSS 0.00384f $ **FLOATING
C502 a_3307_n762# VSS 0.00838f $ **FLOATING
C503 a_2895_n762# VSS 0.00838f $ **FLOATING
C504 a_2597_n762# VSS 0.00838f $ **FLOATING
C505 a_2237_n762# VSS 0.00384f $ **FLOATING
C506 a_1877_n762# VSS 0.00384f $ **FLOATING
C507 a_1517_n762# VSS 0.00384f $ **FLOATING
C508 a_1105_n762# VSS 0.00838f $ **FLOATING
C509 a_745_n762# VSS 0.00384f $ **FLOATING
C510 a_333_n762# VSS 0.00838f $ **FLOATING
C511 a_n79_n762# VSS 0.00838f $ **FLOATING
C512 buff_d8_1.inv_d8_0.VIN VSS 1.97807f
C513 buff_d8_1.inv_d4_0.VIN VSS 0.96003f
C514 buff_d8_1.inv_d2_0.VIN VSS 0.52799f
C515 buff_d8_3.inv_d8_0.VIN VSS 1.81629f
C516 buff_d8_3.inv_d4_0.VIN VSS 0.89366f
C517 buff_d8_3.inv_d2_0.VIN VSS 0.47661f
C518 buff_d8_4.inv_d8_0.VIN VSS 1.81332f
C519 buff_d8_4.inv_d4_0.VIN VSS 0.89218f
C520 buff_d8_4.inv_d2_0.VIN VSS 0.4933f
C521 a_8247_n61# VSS 0.00838f $ **FLOATING
C522 a_7835_n61# VSS 0.00838f $ **FLOATING
C523 a_7475_n61# VSS 0.00384f $ **FLOATING
C524 a_7063_n61# VSS 0.00838f $ **FLOATING
C525 a_6703_n61# VSS 0.00384f $ **FLOATING
C526 a_6343_n61# VSS 0.00384f $ **FLOATING
C527 a_5983_n61# VSS 0.00384f $ **FLOATING
C528 a_5571_n61# VSS 0.00838f $ **FLOATING
C529 a_5273_n61# VSS 0.00838f $ **FLOATING
C530 a_4861_n61# VSS 0.00838f $ **FLOATING
C531 a_4501_n61# VSS 0.00384f $ **FLOATING
C532 a_4089_n61# VSS 0.00838f $ **FLOATING
C533 a_3729_n61# VSS 0.00384f $ **FLOATING
C534 a_3369_n61# VSS 0.00384f $ **FLOATING
C535 a_3009_n61# VSS 0.00384f $ **FLOATING
C536 a_2597_n61# VSS 0.00838f $ **FLOATING
C537 a_2299_n61# VSS 0.00838f $ **FLOATING
C538 a_1887_n61# VSS 0.00838f $ **FLOATING
C539 a_1527_n61# VSS 0.00384f $ **FLOATING
C540 a_1115_n61# VSS 0.00838f $ **FLOATING
C541 a_755_n61# VSS 0.00384f $ **FLOATING
C542 a_395_n61# VSS 0.00384f $ **FLOATING
C543 a_35_n61# VSS 0.00384f $ **FLOATING
C544 psdiff_0.buff_d8_0.inv_d2_0.VIN VSS 0.51435f
C545 psdiff_0.buff_d8_0.inv_d4_0.VIN VSS 0.90438f
C546 psdiff_0.buff_d8_0.inv_d8_0.VIN VSS 1.72946f
C547 psdiff_1.buff_d8_0.inv_d2_0.VIN VSS 0.49734f
C548 psdiff_1.buff_d8_0.inv_d4_0.VIN VSS 0.90484f
C549 psdiff_1.buff_d8_0.inv_d8_0.VIN VSS 1.7295f
C550 psdiff_2.buff_d8_0.inv_d2_0.VIN VSS 0.49744f
C551 psdiff_2.buff_d8_0.inv_d4_0.VIN VSS 0.9049f
C552 psdiff_2.buff_d8_0.inv_d8_0.VIN VSS 1.77133f
C553 psdiff_1.VOUTDP VSS 5.37814f
C554 psdiff_2.VOUTDP VSS 5.74392f
C555 psdiff_2.CLKN VSS 3.6778f
C556 a_7162_1266# VSS 0.63563f
C557 a_6005_1122# VSS 0.57129f
C558 a_4188_1266# VSS 0.62775f
C559 a_3031_1122# VSS 0.57129f
C560 a_1214_1266# VSS 0.62775f
C561 a_57_1122# VSS 0.57917f
C562 a_8202_1867# VSS 0.00384f $ **FLOATING
C563 a_7842_1867# VSS 0.00384f $ **FLOATING
C564 a_7482_1867# VSS 0.00384f $ **FLOATING
C565 a_7070_1867# VSS 0.00838f $ **FLOATING
C566 a_6710_1867# VSS 0.00384f $ **FLOATING
C567 a_6298_1867# VSS 0.00838f $ **FLOATING
C568 a_5886_1867# VSS 0.00838f $ **FLOATING
C569 a_5588_1867# VSS 0.00838f $ **FLOATING
C570 a_5228_1867# VSS 0.00384f $ **FLOATING
C571 a_4868_1867# VSS 0.00384f $ **FLOATING
C572 a_4508_1867# VSS 0.00384f $ **FLOATING
C573 a_4096_1867# VSS 0.00838f $ **FLOATING
C574 a_3736_1867# VSS 0.00384f $ **FLOATING
C575 a_3324_1867# VSS 0.00838f $ **FLOATING
C576 a_2912_1867# VSS 0.00838f $ **FLOATING
C577 a_2614_1867# VSS 0.00838f $ **FLOATING
C578 a_2254_1867# VSS 0.00384f $ **FLOATING
C579 a_1894_1867# VSS 0.00384f $ **FLOATING
C580 a_1534_1867# VSS 0.00384f $ **FLOATING
C581 a_1122_1867# VSS 0.00838f $ **FLOATING
C582 a_762_1867# VSS 0.00384f $ **FLOATING
C583 a_350_1867# VSS 0.00838f $ **FLOATING
C584 a_n62_1867# VSS 0.00838f $ **FLOATING
C585 psdiff_0.buff_d8_1.inv_d8_0.VIN VSS 1.83954f
C586 psdiff_0.buff_d8_1.inv_d4_0.VIN VSS 0.88395f
C587 psdiff_0.buff_d8_1.inv_d2_0.VIN VSS 0.47558f
C588 psdiff_1.buff_d8_1.inv_d8_0.VIN VSS 1.80591f
C589 psdiff_1.buff_d8_1.inv_d4_0.VIN VSS 0.88395f
C590 psdiff_1.buff_d8_1.inv_d2_0.VIN VSS 0.47558f
C591 psdiff_2.buff_d8_1.inv_d8_0.VIN VSS 1.81091f
C592 psdiff_2.buff_d8_1.inv_d4_0.VIN VSS 0.89478f
C593 psdiff_2.buff_d8_1.inv_d2_0.VIN VSS 0.49469f
C594 a_8264_2568# VSS 0.00838f $ **FLOATING
C595 a_7852_2568# VSS 0.00838f $ **FLOATING
C596 a_7492_2568# VSS 0.00384f $ **FLOATING
C597 a_7080_2568# VSS 0.00838f $ **FLOATING
C598 a_6720_2568# VSS 0.00384f $ **FLOATING
C599 a_6360_2568# VSS 0.00384f $ **FLOATING
C600 a_6000_2568# VSS 0.00384f $ **FLOATING
C601 a_5588_2568# VSS 0.00838f $ **FLOATING
C602 a_5290_2568# VSS 0.00838f $ **FLOATING
C603 a_4878_2568# VSS 0.00838f $ **FLOATING
C604 a_4518_2568# VSS 0.00384f $ **FLOATING
C605 a_4106_2568# VSS 0.00838f $ **FLOATING
C606 a_3746_2568# VSS 0.00384f $ **FLOATING
C607 a_3386_2568# VSS 0.00384f $ **FLOATING
C608 a_3026_2568# VSS 0.00384f $ **FLOATING
C609 a_2614_2568# VSS 0.00838f $ **FLOATING
C610 a_2316_2568# VSS 0.00838f $ **FLOATING
C611 a_1904_2568# VSS 0.00838f $ **FLOATING
C612 a_1544_2568# VSS 0.00384f $ **FLOATING
C613 a_1132_2568# VSS 0.00838f $ **FLOATING
C614 a_772_2568# VSS 0.00384f $ **FLOATING
C615 a_412_2568# VSS 0.00384f $ **FLOATING
C616 a_52_2568# VSS 0.00384f $ **FLOATING
C617 psdiff_2.CLKP VSS 5.82364f
C618 buff_d8_0.inv_d2_0.VIN VSS 0.51277f
C619 buff_d8_0.inv_d4_0.VIN VSS 0.85434f
C620 buff_d8_0.inv_d8_0.VIN VSS 1.65497f
C621 psdiff_1.VOUTDN VSS 2.94651f
C622 buff_d8_2.inv_d2_0.VIN VSS 0.49211f
C623 buff_d8_2.inv_d4_0.VIN VSS 0.84667f
C624 buff_d8_2.inv_d8_0.VIN VSS 1.64991f
C625 psdiff_2.VOUTDN VSS 2.94641f
C626 buff_d8_5.inv_d2_0.VIN VSS 0.49211f
C627 buff_d8_5.inv_d4_0.VIN VSS 0.84667f
C628 buff_d8_5.inv_d8_0.VIN VSS 1.69074f
C629 CTRL VSS 8.46052f
C630 a_7070_4532# VSS 0.00838f $ **FLOATING
C631 a_4096_4532# VSS 0.00838f $ **FLOATING
C632 a_1122_4532# VSS 0.00838f $ **FLOATING
C633 PH5 VSS 5.65417f
C634 PH2 VSS 4.76115f
C635 PH1 VSS 5.08217f
C636 PH4 VSS 4.76108f
C637 PH3 VSS 5.08554f
C638 PH0 VSS 4.94766f
C639 PH1.t1 VSS 0.02015f
C640 PH1.n0 VSS 0.00784f
C641 PH1.t2 VSS 0.02015f
C642 PH1.t7 VSS 0.02015f
C643 PH1.n1 VSS 0.00784f
C644 PH1.n2 VSS 0.04776f
C645 PH1.n3 VSS 0.03273f
C646 PH1.t5 VSS 0.02015f
C647 PH1.t9 VSS 0.02015f
C648 PH1.n4 VSS 0.00784f
C649 PH1.n5 VSS 0.04776f
C650 PH1.n6 VSS 0.03273f
C651 PH1.t3 VSS 0.02015f
C652 PH1.t6 VSS 0.02015f
C653 PH1.n7 VSS 0.00784f
C654 PH1.n8 VSS 0.04776f
C655 PH1.n9 VSS 0.03706f
C656 PH1.n10 VSS 0.11567f
C657 PH1.n11 VSS 0.06563f
C658 PH1.t4 VSS 0.02015f
C659 PH1.t8 VSS 0.02015f
C660 PH1.n12 VSS 0.00784f
C661 PH1.n13 VSS 0.04776f
C662 PH1.n14 VSS 0.0328f
C663 PH1.n15 VSS 0.67904f
C664 PH1.t11 VSS 1.05721f
C665 PH1.n16 VSS 0.00313f
C666 PH1.n17 VSS 0.80003f
C667 PH1.t10 VSS 0.0456f
C668 PH1.n18 VSS 0.0049f
C669 PH1.n19 VSS 0.12206f
C670 PH1.t12 VSS 0.0456f
C671 PH1.n20 VSS 0.00926f
C672 PH1.n21 VSS 0.10377f
C673 PH1.t0 VSS 0.02015f
C674 PH1.n22 VSS 0.03661f
C675 PH1.n23 VSS 0.04776f
C676 PH0.t12 VSS 0.0525f
C677 PH0.n0 VSS 0.00564f
C678 PH0.t3 VSS 0.0232f
C679 PH0.t8 VSS 0.0232f
C680 PH0.n1 VSS 0.00903f
C681 PH0.n2 VSS 0.05499f
C682 PH0.n3 VSS 0.03768f
C683 PH0.t2 VSS 0.0232f
C684 PH0.t7 VSS 0.0232f
C685 PH0.n4 VSS 0.00903f
C686 PH0.n5 VSS 0.05499f
C687 PH0.n6 VSS 0.03768f
C688 PH0.t5 VSS 0.0232f
C689 PH0.t9 VSS 0.0232f
C690 PH0.n7 VSS 0.00903f
C691 PH0.n8 VSS 0.05499f
C692 PH0.n9 VSS 0.03768f
C693 PH0.t4 VSS 0.0232f
C694 PH0.t6 VSS 0.0232f
C695 PH0.n10 VSS 0.00903f
C696 PH0.n11 VSS 0.05499f
C697 PH0.n12 VSS 0.04267f
C698 PH0.n13 VSS 0.13317f
C699 PH0.n14 VSS 0.07859f
C700 PH0.n15 VSS 0.21751f
C701 PH0.t10 VSS 1.21723f
C702 PH0.n16 VSS 0.33716f
C703 PH0.t11 VSS 0.0525f
C704 PH0.n17 VSS 0.01066f
C705 PH0.n18 VSS 0.14053f
C706 PH0.n19 VSS 0.11985f
C707 PH0.n20 VSS 0.00457f
C708 PH0.t1 VSS 0.0232f
C709 PH0.n21 VSS 0.01107f
C710 PH0.t0 VSS 0.02348f
C711 PH0.n22 VSS 0.01221f
C712 psdiff_1.buff_d8_1.VIN.t32 VSS 0.05063f
C713 psdiff_1.buff_d8_1.VIN.t3 VSS 0.02262f
C714 psdiff_1.buff_d8_1.VIN.t14 VSS 0.02237f
C715 psdiff_1.buff_d8_1.VIN.n0 VSS 0.02861f
C716 psdiff_1.buff_d8_1.VIN.t7 VSS 0.02237f
C717 psdiff_1.buff_d8_1.VIN.n1 VSS 0.01322f
C718 psdiff_1.buff_d8_1.VIN.t13 VSS 0.02262f
C719 psdiff_1.buff_d8_1.VIN.t6 VSS 0.02237f
C720 psdiff_1.buff_d8_1.VIN.n2 VSS 0.02861f
C721 psdiff_1.buff_d8_1.VIN.t12 VSS 0.02237f
C722 psdiff_1.buff_d8_1.VIN.n3 VSS 0.01322f
C723 psdiff_1.buff_d8_1.VIN.t0 VSS 0.02037f
C724 psdiff_1.buff_d8_1.VIN.t9 VSS 0.02262f
C725 psdiff_1.buff_d8_1.VIN.t16 VSS 0.02237f
C726 psdiff_1.buff_d8_1.VIN.n4 VSS 0.02861f
C727 psdiff_1.buff_d8_1.VIN.t8 VSS 0.02237f
C728 psdiff_1.buff_d8_1.VIN.n5 VSS 0.01322f
C729 psdiff_1.buff_d8_1.VIN.t5 VSS 0.02262f
C730 psdiff_1.buff_d8_1.VIN.t15 VSS 0.02237f
C731 psdiff_1.buff_d8_1.VIN.n6 VSS 0.02861f
C732 psdiff_1.buff_d8_1.VIN.t2 VSS 0.02237f
C733 psdiff_1.buff_d8_1.VIN.n7 VSS 0.01322f
C734 psdiff_1.buff_d8_1.VIN.t23 VSS 0.02262f
C735 psdiff_1.buff_d8_1.VIN.t20 VSS 0.02237f
C736 psdiff_1.buff_d8_1.VIN.n8 VSS 0.03437f
C737 psdiff_1.buff_d8_1.VIN.t28 VSS 0.02237f
C738 psdiff_1.buff_d8_1.VIN.t25 VSS 0.02262f
C739 psdiff_1.buff_d8_1.VIN.t17 VSS 0.02237f
C740 psdiff_1.buff_d8_1.VIN.n9 VSS 0.03498f
C741 psdiff_1.buff_d8_1.VIN.t29 VSS 0.02237f
C742 psdiff_1.buff_d8_1.VIN.n10 VSS 0.01959f
C743 psdiff_1.buff_d8_1.VIN.t22 VSS 0.02262f
C744 psdiff_1.buff_d8_1.VIN.t21 VSS 0.02237f
C745 psdiff_1.buff_d8_1.VIN.n11 VSS 0.03498f
C746 psdiff_1.buff_d8_1.VIN.t27 VSS 0.02237f
C747 psdiff_1.buff_d8_1.VIN.n12 VSS 0.01959f
C748 psdiff_1.buff_d8_1.VIN.t19 VSS 0.02262f
C749 psdiff_1.buff_d8_1.VIN.t18 VSS 0.02237f
C750 psdiff_1.buff_d8_1.VIN.n13 VSS 0.03498f
C751 psdiff_1.buff_d8_1.VIN.t31 VSS 0.02237f
C752 psdiff_1.buff_d8_1.VIN.n14 VSS 0.01959f
C753 psdiff_1.buff_d8_1.VIN.t26 VSS 0.02262f
C754 psdiff_1.buff_d8_1.VIN.t24 VSS 0.02237f
C755 psdiff_1.buff_d8_1.VIN.n15 VSS 0.03498f
C756 psdiff_1.buff_d8_1.VIN.t30 VSS 0.02237f
C757 psdiff_1.buff_d8_1.VIN.n16 VSS 0.04f
C758 psdiff_1.buff_d8_1.VIN.n17 VSS 0.04731f
C759 psdiff_1.buff_d8_1.VIN.n18 VSS 0.04176f
C760 psdiff_1.buff_d8_1.VIN.n19 VSS 0.04657f
C761 psdiff_1.buff_d8_1.VIN.n20 VSS 0.10258f
C762 psdiff_1.buff_d8_1.VIN.t1 VSS 0.02026f
C763 psdiff_1.buff_d8_1.VIN.n21 VSS 0.06915f
C764 psdiff_1.buff_d8_1.VIN.n22 VSS 0.03074f
C765 psdiff_1.buff_d8_1.VIN.n23 VSS 0.05599f
C766 psdiff_1.buff_d8_1.VIN.n24 VSS 0.04176f
C767 psdiff_1.buff_d8_1.VIN.n25 VSS 0.04657f
C768 psdiff_1.buff_d8_1.VIN.t10 VSS 0.02237f
C769 psdiff_1.buff_d8_1.VIN.t11 VSS 0.02262f
C770 psdiff_1.buff_d8_1.VIN.t4 VSS 0.02237f
C771 psdiff_1.buff_d8_1.VIN.n26 VSS 0.02812f
C772 psdiff_1.buff_d8_1.VIN.n27 VSS 0.25023f
C773 psdiff_1.buff_d8_1.VIN.n28 VSS 0.22604f
C774 psdiff_1.buff_d8_1.inv_0.VIN VSS 0.00786f
C775 psdiff_1.buff_d8_0.inv_0.VIN VSS 0.01372f
C776 psdiff_1.buff_d8_0.VIN.t32 VSS 0.05604f
C777 psdiff_1.buff_d8_0.VIN.t14 VSS 0.02504f
C778 psdiff_1.buff_d8_0.VIN.t7 VSS 0.02476f
C779 psdiff_1.buff_d8_0.VIN.n0 VSS 0.03167f
C780 psdiff_1.buff_d8_0.VIN.t13 VSS 0.02476f
C781 psdiff_1.buff_d8_0.VIN.n1 VSS 0.01463f
C782 psdiff_1.buff_d8_0.VIN.t0 VSS 0.02504f
C783 psdiff_1.buff_d8_0.VIN.t12 VSS 0.02476f
C784 psdiff_1.buff_d8_0.VIN.n2 VSS 0.03167f
C785 psdiff_1.buff_d8_0.VIN.t3 VSS 0.02476f
C786 psdiff_1.buff_d8_0.VIN.n3 VSS 0.01463f
C787 psdiff_1.buff_d8_0.VIN.t16 VSS 0.02255f
C788 psdiff_1.buff_d8_0.VIN.t6 VSS 0.02504f
C789 psdiff_1.buff_d8_0.VIN.t1 VSS 0.02476f
C790 psdiff_1.buff_d8_0.VIN.n4 VSS 0.03167f
C791 psdiff_1.buff_d8_0.VIN.t5 VSS 0.02476f
C792 psdiff_1.buff_d8_0.VIN.n5 VSS 0.01463f
C793 psdiff_1.buff_d8_0.VIN.t30 VSS 0.02504f
C794 psdiff_1.buff_d8_0.VIN.t25 VSS 0.02476f
C795 psdiff_1.buff_d8_0.VIN.n6 VSS 0.03804f
C796 psdiff_1.buff_d8_0.VIN.t18 VSS 0.02476f
C797 psdiff_1.buff_d8_0.VIN.t28 VSS 0.02504f
C798 psdiff_1.buff_d8_0.VIN.t22 VSS 0.02476f
C799 psdiff_1.buff_d8_0.VIN.n7 VSS 0.03872f
C800 psdiff_1.buff_d8_0.VIN.t19 VSS 0.02476f
C801 psdiff_1.buff_d8_0.VIN.n8 VSS 0.02168f
C802 psdiff_1.buff_d8_0.VIN.t29 VSS 0.02504f
C803 psdiff_1.buff_d8_0.VIN.t26 VSS 0.02476f
C804 psdiff_1.buff_d8_0.VIN.n9 VSS 0.03872f
C805 psdiff_1.buff_d8_0.VIN.t17 VSS 0.02476f
C806 psdiff_1.buff_d8_0.VIN.n10 VSS 0.02168f
C807 psdiff_1.buff_d8_0.VIN.t31 VSS 0.02504f
C808 psdiff_1.buff_d8_0.VIN.t23 VSS 0.02476f
C809 psdiff_1.buff_d8_0.VIN.n11 VSS 0.03872f
C810 psdiff_1.buff_d8_0.VIN.t20 VSS 0.02476f
C811 psdiff_1.buff_d8_0.VIN.n12 VSS 0.02168f
C812 psdiff_1.buff_d8_0.VIN.t24 VSS 0.02504f
C813 psdiff_1.buff_d8_0.VIN.t27 VSS 0.02476f
C814 psdiff_1.buff_d8_0.VIN.n13 VSS 0.03872f
C815 psdiff_1.buff_d8_0.VIN.t21 VSS 0.02476f
C816 psdiff_1.buff_d8_0.VIN.n14 VSS 0.04427f
C817 psdiff_1.buff_d8_0.VIN.n15 VSS 0.05236f
C818 psdiff_1.buff_d8_0.VIN.n16 VSS 0.04622f
C819 psdiff_1.buff_d8_0.VIN.n17 VSS 0.05155f
C820 psdiff_1.buff_d8_0.VIN.n18 VSS 0.14936f
C821 psdiff_1.buff_d8_0.VIN.t15 VSS 0.02242f
C822 psdiff_1.buff_d8_0.VIN.n19 VSS 0.11155f
C823 psdiff_1.buff_d8_0.VIN.t11 VSS 0.02504f
C824 psdiff_1.buff_d8_0.VIN.t4 VSS 0.02476f
C825 psdiff_1.buff_d8_0.VIN.n20 VSS 0.03167f
C826 psdiff_1.buff_d8_0.VIN.t10 VSS 0.02476f
C827 psdiff_1.buff_d8_0.VIN.n21 VSS 0.01463f
C828 psdiff_1.buff_d8_0.VIN.n22 VSS 0.03402f
C829 psdiff_1.buff_d8_0.VIN.n23 VSS 0.06198f
C830 psdiff_1.buff_d8_0.VIN.n24 VSS 0.04622f
C831 psdiff_1.buff_d8_0.VIN.n25 VSS 0.05236f
C832 psdiff_1.buff_d8_0.VIN.t8 VSS 0.02476f
C833 psdiff_1.buff_d8_0.VIN.n26 VSS 0.03722f
C834 psdiff_1.buff_d8_0.VIN.t2 VSS 0.02476f
C835 psdiff_1.buff_d8_0.VIN.n27 VSS 0.01766f
C836 psdiff_1.buff_d8_0.VIN.t9 VSS 0.02476f
C837 psdiff_1.buff_d8_0.VIN.n28 VSS 0.15048f
C838 psdiff_1.buff_d8_0.VIN.n29 VSS 0.1415f
C839 PH2.t11 VSS 0.056f
C840 PH2.n0 VSS 0.00602f
C841 PH2.t3 VSS 0.02474f
C842 PH2.t7 VSS 0.02474f
C843 PH2.n1 VSS 0.00963f
C844 PH2.n2 VSS 0.05865f
C845 PH2.n3 VSS 0.04019f
C846 PH2.t2 VSS 0.02474f
C847 PH2.t8 VSS 0.02474f
C848 PH2.n4 VSS 0.00963f
C849 PH2.n5 VSS 0.05865f
C850 PH2.n6 VSS 0.04019f
C851 PH2.t5 VSS 0.02474f
C852 PH2.t6 VSS 0.02474f
C853 PH2.n7 VSS 0.00963f
C854 PH2.n8 VSS 0.05865f
C855 PH2.n9 VSS 0.04019f
C856 PH2.t4 VSS 0.02474f
C857 PH2.t9 VSS 0.02474f
C858 PH2.n10 VSS 0.00963f
C859 PH2.n11 VSS 0.05865f
C860 PH2.n12 VSS 0.04552f
C861 PH2.n13 VSS 0.14205f
C862 PH2.n14 VSS 0.08383f
C863 PH2.n15 VSS 0.23201f
C864 PH2.t10 VSS 1.29838f
C865 PH2.n16 VSS 0.35964f
C866 PH2.t12 VSS 0.056f
C867 PH2.n17 VSS 0.01137f
C868 PH2.n18 VSS 0.1499f
C869 PH2.n19 VSS 0.12784f
C870 PH2.n20 VSS 0.00487f
C871 PH2.t1 VSS 0.02474f
C872 PH2.n21 VSS 0.01181f
C873 PH2.t0 VSS 0.02504f
C874 PH2.n22 VSS 0.01302f
C875 PH3.t1 VSS 0.01959f
C876 PH3.n0 VSS 0.00762f
C877 PH3.t2 VSS 0.01959f
C878 PH3.t7 VSS 0.01959f
C879 PH3.n1 VSS 0.00762f
C880 PH3.n2 VSS 0.04643f
C881 PH3.n3 VSS 0.03182f
C882 PH3.t5 VSS 0.01959f
C883 PH3.t9 VSS 0.01959f
C884 PH3.n4 VSS 0.00762f
C885 PH3.n5 VSS 0.04643f
C886 PH3.n6 VSS 0.03182f
C887 PH3.t3 VSS 0.01959f
C888 PH3.t8 VSS 0.01959f
C889 PH3.n7 VSS 0.00762f
C890 PH3.n8 VSS 0.04643f
C891 PH3.n9 VSS 0.03182f
C892 PH3.t4 VSS 0.01959f
C893 PH3.t6 VSS 0.01959f
C894 PH3.n10 VSS 0.00762f
C895 PH3.n11 VSS 0.04643f
C896 PH3.n12 VSS 0.03603f
C897 PH3.n13 VSS 0.11245f
C898 PH3.n14 VSS 0.06636f
C899 PH3.n15 VSS 0.65589f
C900 PH3.t10 VSS 1.02785f
C901 PH3.n16 VSS 0.00874f
C902 PH3.n17 VSS 0.7796f
C903 PH3.t12 VSS 0.04433f
C904 PH3.n18 VSS 0.00476f
C905 PH3.n19 VSS 0.11867f
C906 PH3.t11 VSS 0.04433f
C907 PH3.n20 VSS 0.009f
C908 PH3.n21 VSS 0.10088f
C909 PH3.t0 VSS 0.01959f
C910 PH3.n22 VSS 0.03559f
C911 PH3.n23 VSS 0.04643f
C912 psdiff_0.buff_d8_1.VIN.t32 VSS 0.05063f
C913 psdiff_0.buff_d8_1.VIN.t8 VSS 0.02262f
C914 psdiff_0.buff_d8_1.VIN.t1 VSS 0.02237f
C915 psdiff_0.buff_d8_1.VIN.n0 VSS 0.02861f
C916 psdiff_0.buff_d8_1.VIN.t6 VSS 0.02237f
C917 psdiff_0.buff_d8_1.VIN.n1 VSS 0.01322f
C918 psdiff_0.buff_d8_1.VIN.t16 VSS 0.02037f
C919 psdiff_0.buff_d8_1.VIN.t11 VSS 0.02262f
C920 psdiff_0.buff_d8_1.VIN.t3 VSS 0.02237f
C921 psdiff_0.buff_d8_1.VIN.n2 VSS 0.02861f
C922 psdiff_0.buff_d8_1.VIN.t10 VSS 0.02237f
C923 psdiff_0.buff_d8_1.VIN.n3 VSS 0.01322f
C924 psdiff_0.buff_d8_1.VIN.t18 VSS 0.02262f
C925 psdiff_0.buff_d8_1.VIN.t24 VSS 0.02237f
C926 psdiff_0.buff_d8_1.VIN.n4 VSS 0.03437f
C927 psdiff_0.buff_d8_1.VIN.t28 VSS 0.02237f
C928 psdiff_0.buff_d8_1.VIN.t22 VSS 0.02262f
C929 psdiff_0.buff_d8_1.VIN.t25 VSS 0.02237f
C930 psdiff_0.buff_d8_1.VIN.n5 VSS 0.03498f
C931 psdiff_0.buff_d8_1.VIN.t27 VSS 0.02237f
C932 psdiff_0.buff_d8_1.VIN.n6 VSS 0.01959f
C933 psdiff_0.buff_d8_1.VIN.t17 VSS 0.02262f
C934 psdiff_0.buff_d8_1.VIN.t20 VSS 0.02237f
C935 psdiff_0.buff_d8_1.VIN.n7 VSS 0.03498f
C936 psdiff_0.buff_d8_1.VIN.t31 VSS 0.02237f
C937 psdiff_0.buff_d8_1.VIN.n8 VSS 0.01959f
C938 psdiff_0.buff_d8_1.VIN.t26 VSS 0.02262f
C939 psdiff_0.buff_d8_1.VIN.t23 VSS 0.02237f
C940 psdiff_0.buff_d8_1.VIN.n9 VSS 0.03498f
C941 psdiff_0.buff_d8_1.VIN.t29 VSS 0.02237f
C942 psdiff_0.buff_d8_1.VIN.n10 VSS 0.01959f
C943 psdiff_0.buff_d8_1.VIN.t21 VSS 0.02262f
C944 psdiff_0.buff_d8_1.VIN.t19 VSS 0.02237f
C945 psdiff_0.buff_d8_1.VIN.n11 VSS 0.03498f
C946 psdiff_0.buff_d8_1.VIN.t30 VSS 0.02237f
C947 psdiff_0.buff_d8_1.VIN.n12 VSS 0.04f
C948 psdiff_0.buff_d8_1.VIN.n13 VSS 0.04731f
C949 psdiff_0.buff_d8_1.VIN.n14 VSS 0.04176f
C950 psdiff_0.buff_d8_1.VIN.n15 VSS 0.04657f
C951 psdiff_0.buff_d8_1.VIN.n16 VSS 0.10258f
C952 psdiff_0.buff_d8_1.VIN.t15 VSS 0.02026f
C953 psdiff_0.buff_d8_1.VIN.n17 VSS 0.06915f
C954 psdiff_0.buff_d8_1.VIN.t9 VSS 0.02262f
C955 psdiff_0.buff_d8_1.VIN.t0 VSS 0.02237f
C956 psdiff_0.buff_d8_1.VIN.n18 VSS 0.02861f
C957 psdiff_0.buff_d8_1.VIN.t7 VSS 0.02237f
C958 psdiff_0.buff_d8_1.VIN.n19 VSS 0.01322f
C959 psdiff_0.buff_d8_1.VIN.n20 VSS 0.03074f
C960 psdiff_0.buff_d8_1.VIN.n21 VSS 0.05599f
C961 psdiff_0.buff_d8_1.VIN.t4 VSS 0.02262f
C962 psdiff_0.buff_d8_1.VIN.t14 VSS 0.02237f
C963 psdiff_0.buff_d8_1.VIN.n22 VSS 0.02861f
C964 psdiff_0.buff_d8_1.VIN.t2 VSS 0.02237f
C965 psdiff_0.buff_d8_1.VIN.n23 VSS 0.01322f
C966 psdiff_0.buff_d8_1.VIN.n24 VSS 0.04176f
C967 psdiff_0.buff_d8_1.VIN.n25 VSS 0.04657f
C968 psdiff_0.buff_d8_1.VIN.t12 VSS 0.02237f
C969 psdiff_0.buff_d8_1.VIN.t13 VSS 0.02262f
C970 psdiff_0.buff_d8_1.VIN.t5 VSS 0.02237f
C971 psdiff_0.buff_d8_1.VIN.n26 VSS 0.02812f
C972 psdiff_0.buff_d8_1.VIN.n27 VSS 0.25023f
C973 psdiff_0.buff_d8_1.VIN.n28 VSS 0.22604f
C974 psdiff_0.buff_d8_1.inv_0.VIN VSS 0.00786f
C975 psdiff_0.buff_d8_0.inv_0.VIN VSS 0.01372f
C976 psdiff_0.buff_d8_0.VIN.t32 VSS 0.05604f
C977 psdiff_0.buff_d8_0.VIN.t7 VSS 0.02504f
C978 psdiff_0.buff_d8_0.VIN.t20 VSS 0.02476f
C979 psdiff_0.buff_d8_0.VIN.n0 VSS 0.03167f
C980 psdiff_0.buff_d8_0.VIN.t11 VSS 0.02476f
C981 psdiff_0.buff_d8_0.VIN.n1 VSS 0.01463f
C982 psdiff_0.buff_d8_0.VIN.t16 VSS 0.02504f
C983 psdiff_0.buff_d8_0.VIN.t8 VSS 0.02476f
C984 psdiff_0.buff_d8_0.VIN.n2 VSS 0.03167f
C985 psdiff_0.buff_d8_0.VIN.t15 VSS 0.02476f
C986 psdiff_0.buff_d8_0.VIN.n3 VSS 0.01463f
C987 psdiff_0.buff_d8_0.VIN.t18 VSS 0.02504f
C988 psdiff_0.buff_d8_0.VIN.t14 VSS 0.02476f
C989 psdiff_0.buff_d8_0.VIN.n4 VSS 0.03167f
C990 psdiff_0.buff_d8_0.VIN.t17 VSS 0.02476f
C991 psdiff_0.buff_d8_0.VIN.n5 VSS 0.01463f
C992 psdiff_0.buff_d8_0.VIN.t23 VSS 0.02504f
C993 psdiff_0.buff_d8_0.VIN.t26 VSS 0.02476f
C994 psdiff_0.buff_d8_0.VIN.n6 VSS 0.03804f
C995 psdiff_0.buff_d8_0.VIN.t5 VSS 0.02476f
C996 psdiff_0.buff_d8_0.VIN.t22 VSS 0.02504f
C997 psdiff_0.buff_d8_0.VIN.t30 VSS 0.02476f
C998 psdiff_0.buff_d8_0.VIN.n7 VSS 0.03872f
C999 psdiff_0.buff_d8_0.VIN.t2 VSS 0.02476f
C1000 psdiff_0.buff_d8_0.VIN.n8 VSS 0.02168f
C1001 psdiff_0.buff_d8_0.VIN.t25 VSS 0.02504f
C1002 psdiff_0.buff_d8_0.VIN.t28 VSS 0.02476f
C1003 psdiff_0.buff_d8_0.VIN.n9 VSS 0.03872f
C1004 psdiff_0.buff_d8_0.VIN.t6 VSS 0.02476f
C1005 psdiff_0.buff_d8_0.VIN.n10 VSS 0.02168f
C1006 psdiff_0.buff_d8_0.VIN.t29 VSS 0.02504f
C1007 psdiff_0.buff_d8_0.VIN.t24 VSS 0.02476f
C1008 psdiff_0.buff_d8_0.VIN.n11 VSS 0.03872f
C1009 psdiff_0.buff_d8_0.VIN.t3 VSS 0.02476f
C1010 psdiff_0.buff_d8_0.VIN.n12 VSS 0.02168f
C1011 psdiff_0.buff_d8_0.VIN.t31 VSS 0.02504f
C1012 psdiff_0.buff_d8_0.VIN.t27 VSS 0.02476f
C1013 psdiff_0.buff_d8_0.VIN.n13 VSS 0.03872f
C1014 psdiff_0.buff_d8_0.VIN.t4 VSS 0.02476f
C1015 psdiff_0.buff_d8_0.VIN.n14 VSS 0.04427f
C1016 psdiff_0.buff_d8_0.VIN.n15 VSS 0.05236f
C1017 psdiff_0.buff_d8_0.VIN.n16 VSS 0.04622f
C1018 psdiff_0.buff_d8_0.VIN.n17 VSS 0.05155f
C1019 psdiff_0.buff_d8_0.VIN.n18 VSS 0.14936f
C1020 psdiff_0.buff_d8_0.VIN.t0 VSS 0.02242f
C1021 psdiff_0.buff_d8_0.VIN.n19 VSS 0.11155f
C1022 psdiff_0.buff_d8_0.VIN.t12 VSS 0.02504f
C1023 psdiff_0.buff_d8_0.VIN.t21 VSS 0.02476f
C1024 psdiff_0.buff_d8_0.VIN.n20 VSS 0.03167f
C1025 psdiff_0.buff_d8_0.VIN.t9 VSS 0.02476f
C1026 psdiff_0.buff_d8_0.VIN.n21 VSS 0.01463f
C1027 psdiff_0.buff_d8_0.VIN.n22 VSS 0.03402f
C1028 psdiff_0.buff_d8_0.VIN.t1 VSS 0.02255f
C1029 psdiff_0.buff_d8_0.VIN.n23 VSS 0.06198f
C1030 psdiff_0.buff_d8_0.VIN.n24 VSS 0.04622f
C1031 psdiff_0.buff_d8_0.VIN.n25 VSS 0.05236f
C1032 psdiff_0.buff_d8_0.VIN.t10 VSS 0.02476f
C1033 psdiff_0.buff_d8_0.VIN.n26 VSS 0.03722f
C1034 psdiff_0.buff_d8_0.VIN.t19 VSS 0.02476f
C1035 psdiff_0.buff_d8_0.VIN.n27 VSS 0.01766f
C1036 psdiff_0.buff_d8_0.VIN.t13 VSS 0.02476f
C1037 psdiff_0.buff_d8_0.VIN.n28 VSS 0.15048f
C1038 psdiff_0.buff_d8_0.VIN.n29 VSS 0.1415f
C1039 PH5.t1 VSS 0.01737f
C1040 PH5.n0 VSS 0.00676f
C1041 PH5.t5 VSS 0.01737f
C1042 PH5.t7 VSS 0.01737f
C1043 PH5.n1 VSS 0.00676f
C1044 PH5.n2 VSS 0.04117f
C1045 PH5.n3 VSS 0.02821f
C1046 PH5.t3 VSS 0.01737f
C1047 PH5.t9 VSS 0.01737f
C1048 PH5.n4 VSS 0.00676f
C1049 PH5.n5 VSS 0.04117f
C1050 PH5.n6 VSS 0.02821f
C1051 PH5.t2 VSS 0.01737f
C1052 PH5.t6 VSS 0.01737f
C1053 PH5.n7 VSS 0.00676f
C1054 PH5.n8 VSS 0.04117f
C1055 PH5.n9 VSS 0.02821f
C1056 PH5.t4 VSS 0.01737f
C1057 PH5.t8 VSS 0.01737f
C1058 PH5.n10 VSS 0.00676f
C1059 PH5.n11 VSS 0.04117f
C1060 PH5.n12 VSS 0.03195f
C1061 PH5.n13 VSS 0.09972f
C1062 PH5.n14 VSS 0.05819f
C1063 PH5.n15 VSS 0.58095f
C1064 PH5.t10 VSS 0.91141f
C1065 PH5.n16 VSS 0.0081f
C1066 PH5.n17 VSS 0.68906f
C1067 PH5.t12 VSS 0.03931f
C1068 PH5.n18 VSS 0.00423f
C1069 PH5.n19 VSS 0.10522f
C1070 PH5.t11 VSS 0.03931f
C1071 PH5.n20 VSS 0.00798f
C1072 PH5.n21 VSS 0.08946f
C1073 PH5.t0 VSS 0.01737f
C1074 PH5.n22 VSS 0.03156f
C1075 PH5.n23 VSS 0.04117f
C1076 psdiff_2.buff_d8_0.inv_0.VIN VSS 0.01372f
C1077 psdiff_2.buff_d8_0.VIN.t32 VSS 0.05604f
C1078 psdiff_2.buff_d8_0.VIN.t12 VSS 0.02504f
C1079 psdiff_2.buff_d8_0.VIN.t4 VSS 0.02476f
C1080 psdiff_2.buff_d8_0.VIN.n0 VSS 0.03167f
C1081 psdiff_2.buff_d8_0.VIN.t11 VSS 0.02476f
C1082 psdiff_2.buff_d8_0.VIN.n1 VSS 0.01463f
C1083 psdiff_2.buff_d8_0.VIN.t15 VSS 0.02504f
C1084 psdiff_2.buff_d8_0.VIN.t10 VSS 0.02476f
C1085 psdiff_2.buff_d8_0.VIN.n2 VSS 0.03167f
C1086 psdiff_2.buff_d8_0.VIN.t14 VSS 0.02476f
C1087 psdiff_2.buff_d8_0.VIN.n3 VSS 0.01463f
C1088 psdiff_2.buff_d8_0.VIN.t2 VSS 0.02504f
C1089 psdiff_2.buff_d8_0.VIN.t13 VSS 0.02476f
C1090 psdiff_2.buff_d8_0.VIN.n4 VSS 0.03167f
C1091 psdiff_2.buff_d8_0.VIN.t5 VSS 0.02476f
C1092 psdiff_2.buff_d8_0.VIN.n5 VSS 0.01463f
C1093 psdiff_2.buff_d8_0.VIN.t18 VSS 0.02504f
C1094 psdiff_2.buff_d8_0.VIN.t24 VSS 0.02476f
C1095 psdiff_2.buff_d8_0.VIN.n6 VSS 0.03804f
C1096 psdiff_2.buff_d8_0.VIN.t30 VSS 0.02476f
C1097 psdiff_2.buff_d8_0.VIN.t21 VSS 0.02504f
C1098 psdiff_2.buff_d8_0.VIN.t25 VSS 0.02476f
C1099 psdiff_2.buff_d8_0.VIN.n7 VSS 0.03872f
C1100 psdiff_2.buff_d8_0.VIN.t28 VSS 0.02476f
C1101 psdiff_2.buff_d8_0.VIN.n8 VSS 0.02168f
C1102 psdiff_2.buff_d8_0.VIN.t17 VSS 0.02504f
C1103 psdiff_2.buff_d8_0.VIN.t23 VSS 0.02476f
C1104 psdiff_2.buff_d8_0.VIN.n9 VSS 0.03872f
C1105 psdiff_2.buff_d8_0.VIN.t29 VSS 0.02476f
C1106 psdiff_2.buff_d8_0.VIN.n10 VSS 0.02168f
C1107 psdiff_2.buff_d8_0.VIN.t20 VSS 0.02504f
C1108 psdiff_2.buff_d8_0.VIN.t19 VSS 0.02476f
C1109 psdiff_2.buff_d8_0.VIN.n11 VSS 0.03872f
C1110 psdiff_2.buff_d8_0.VIN.t31 VSS 0.02476f
C1111 psdiff_2.buff_d8_0.VIN.n12 VSS 0.02168f
C1112 psdiff_2.buff_d8_0.VIN.t22 VSS 0.02504f
C1113 psdiff_2.buff_d8_0.VIN.t26 VSS 0.02476f
C1114 psdiff_2.buff_d8_0.VIN.n13 VSS 0.03872f
C1115 psdiff_2.buff_d8_0.VIN.t27 VSS 0.02476f
C1116 psdiff_2.buff_d8_0.VIN.n14 VSS 0.04427f
C1117 psdiff_2.buff_d8_0.VIN.n15 VSS 0.05236f
C1118 psdiff_2.buff_d8_0.VIN.n16 VSS 0.04622f
C1119 psdiff_2.buff_d8_0.VIN.n17 VSS 0.05155f
C1120 psdiff_2.buff_d8_0.VIN.n18 VSS 0.14936f
C1121 psdiff_2.buff_d8_0.VIN.t0 VSS 0.02242f
C1122 psdiff_2.buff_d8_0.VIN.n19 VSS 0.11155f
C1123 psdiff_2.buff_d8_0.VIN.t9 VSS 0.02504f
C1124 psdiff_2.buff_d8_0.VIN.t3 VSS 0.02476f
C1125 psdiff_2.buff_d8_0.VIN.n20 VSS 0.03167f
C1126 psdiff_2.buff_d8_0.VIN.t8 VSS 0.02476f
C1127 psdiff_2.buff_d8_0.VIN.n21 VSS 0.01463f
C1128 psdiff_2.buff_d8_0.VIN.n22 VSS 0.03402f
C1129 psdiff_2.buff_d8_0.VIN.t1 VSS 0.02255f
C1130 psdiff_2.buff_d8_0.VIN.n23 VSS 0.06198f
C1131 psdiff_2.buff_d8_0.VIN.n24 VSS 0.04622f
C1132 psdiff_2.buff_d8_0.VIN.n25 VSS 0.05236f
C1133 psdiff_2.buff_d8_0.VIN.t6 VSS 0.02476f
C1134 psdiff_2.buff_d8_0.VIN.n26 VSS 0.03722f
C1135 psdiff_2.buff_d8_0.VIN.t16 VSS 0.02476f
C1136 psdiff_2.buff_d8_0.VIN.n27 VSS 0.01766f
C1137 psdiff_2.buff_d8_0.VIN.t7 VSS 0.02476f
C1138 psdiff_2.buff_d8_0.VIN.n28 VSS 0.15048f
C1139 psdiff_2.buff_d8_0.VIN.n29 VSS 0.1415f
C1140 psdiff_2.buff_d8_1.VIN.t32 VSS 0.04833f
C1141 psdiff_2.buff_d8_1.VIN.t15 VSS 0.02159f
C1142 psdiff_2.buff_d8_1.VIN.t10 VSS 0.02136f
C1143 psdiff_2.buff_d8_1.VIN.n0 VSS 0.02731f
C1144 psdiff_2.buff_d8_1.VIN.t13 VSS 0.02136f
C1145 psdiff_2.buff_d8_1.VIN.n1 VSS 0.01262f
C1146 psdiff_2.buff_d8_1.VIN.t12 VSS 0.02159f
C1147 psdiff_2.buff_d8_1.VIN.t6 VSS 0.02136f
C1148 psdiff_2.buff_d8_1.VIN.n2 VSS 0.02731f
C1149 psdiff_2.buff_d8_1.VIN.t11 VSS 0.02136f
C1150 psdiff_2.buff_d8_1.VIN.n3 VSS 0.01262f
C1151 psdiff_2.buff_d8_1.VIN.t8 VSS 0.02159f
C1152 psdiff_2.buff_d8_1.VIN.t16 VSS 0.02136f
C1153 psdiff_2.buff_d8_1.VIN.n4 VSS 0.02731f
C1154 psdiff_2.buff_d8_1.VIN.t7 VSS 0.02136f
C1155 psdiff_2.buff_d8_1.VIN.n5 VSS 0.01262f
C1156 psdiff_2.buff_d8_1.VIN.t21 VSS 0.02159f
C1157 psdiff_2.buff_d8_1.VIN.t19 VSS 0.02136f
C1158 psdiff_2.buff_d8_1.VIN.n6 VSS 0.0328f
C1159 psdiff_2.buff_d8_1.VIN.t29 VSS 0.02136f
C1160 psdiff_2.buff_d8_1.VIN.t17 VSS 0.02159f
C1161 psdiff_2.buff_d8_1.VIN.t24 VSS 0.02136f
C1162 psdiff_2.buff_d8_1.VIN.n7 VSS 0.03339f
C1163 psdiff_2.buff_d8_1.VIN.t28 VSS 0.02136f
C1164 psdiff_2.buff_d8_1.VIN.n8 VSS 0.0187f
C1165 psdiff_2.buff_d8_1.VIN.t26 VSS 0.02159f
C1166 psdiff_2.buff_d8_1.VIN.t23 VSS 0.02136f
C1167 psdiff_2.buff_d8_1.VIN.n9 VSS 0.03339f
C1168 psdiff_2.buff_d8_1.VIN.t27 VSS 0.02136f
C1169 psdiff_2.buff_d8_1.VIN.n10 VSS 0.0187f
C1170 psdiff_2.buff_d8_1.VIN.t18 VSS 0.02159f
C1171 psdiff_2.buff_d8_1.VIN.t25 VSS 0.02136f
C1172 psdiff_2.buff_d8_1.VIN.n11 VSS 0.03339f
C1173 psdiff_2.buff_d8_1.VIN.t31 VSS 0.02136f
C1174 psdiff_2.buff_d8_1.VIN.n12 VSS 0.0187f
C1175 psdiff_2.buff_d8_1.VIN.t20 VSS 0.02159f
C1176 psdiff_2.buff_d8_1.VIN.t22 VSS 0.02136f
C1177 psdiff_2.buff_d8_1.VIN.n13 VSS 0.03339f
C1178 psdiff_2.buff_d8_1.VIN.t30 VSS 0.02136f
C1179 psdiff_2.buff_d8_1.VIN.n14 VSS 0.03818f
C1180 psdiff_2.buff_d8_1.VIN.n15 VSS 0.04516f
C1181 psdiff_2.buff_d8_1.VIN.n16 VSS 0.03986f
C1182 psdiff_2.buff_d8_1.VIN.n17 VSS 0.04446f
C1183 psdiff_2.buff_d8_1.VIN.n18 VSS 0.09792f
C1184 psdiff_2.buff_d8_1.VIN.t0 VSS 0.01933f
C1185 psdiff_2.buff_d8_1.VIN.n19 VSS 0.066f
C1186 psdiff_2.buff_d8_1.VIN.t3 VSS 0.02159f
C1187 psdiff_2.buff_d8_1.VIN.t9 VSS 0.02136f
C1188 psdiff_2.buff_d8_1.VIN.n20 VSS 0.02731f
C1189 psdiff_2.buff_d8_1.VIN.t2 VSS 0.02136f
C1190 psdiff_2.buff_d8_1.VIN.n21 VSS 0.01262f
C1191 psdiff_2.buff_d8_1.VIN.n22 VSS 0.02934f
C1192 psdiff_2.buff_d8_1.VIN.t1 VSS 0.01945f
C1193 psdiff_2.buff_d8_1.VIN.n23 VSS 0.05345f
C1194 psdiff_2.buff_d8_1.VIN.n24 VSS 0.03986f
C1195 psdiff_2.buff_d8_1.VIN.n25 VSS 0.04446f
C1196 psdiff_2.buff_d8_1.VIN.t4 VSS 0.02136f
C1197 psdiff_2.buff_d8_1.VIN.t5 VSS 0.02159f
C1198 psdiff_2.buff_d8_1.VIN.t14 VSS 0.02136f
C1199 psdiff_2.buff_d8_1.VIN.n26 VSS 0.02684f
C1200 psdiff_2.buff_d8_1.VIN.n27 VSS 0.23885f
C1201 psdiff_2.buff_d8_1.VIN.n28 VSS 0.21576f
C1202 psdiff_2.buff_d8_1.inv_0.VIN VSS 0.0075f
C1203 psdiff_2.CLKP.t6 VSS 0.01269f
C1204 psdiff_2.CLKP.n0 VSS 0.00494f
C1205 psdiff_2.CLKP.t2 VSS 0.01269f
C1206 psdiff_2.CLKP.t5 VSS 0.01269f
C1207 psdiff_2.CLKP.n1 VSS 0.00494f
C1208 psdiff_2.CLKP.n2 VSS 0.03008f
C1209 psdiff_2.CLKP.n3 VSS 0.02061f
C1210 psdiff_2.CLKP.t0 VSS 0.01269f
C1211 psdiff_2.CLKP.t7 VSS 0.01269f
C1212 psdiff_2.CLKP.n4 VSS 0.00494f
C1213 psdiff_2.CLKP.n5 VSS 0.03008f
C1214 psdiff_2.CLKP.n6 VSS 0.02061f
C1215 psdiff_2.CLKP.t1 VSS 0.01269f
C1216 psdiff_2.CLKP.t4 VSS 0.01269f
C1217 psdiff_2.CLKP.n7 VSS 0.00494f
C1218 psdiff_2.CLKP.n8 VSS 0.03008f
C1219 psdiff_2.CLKP.n9 VSS 0.02061f
C1220 psdiff_2.CLKP.t8 VSS 0.26728f
C1221 psdiff_2.CLKP.t9 VSS 0.02872f
C1222 psdiff_2.CLKP.n10 VSS 0.00642f
C1223 psdiff_2.CLKP.n11 VSS 0.90514f
C1224 psdiff_2.CLKP.n12 VSS 0.03596f
C1225 psdiff_2.CLKP.n13 VSS 0.04299f
C1226 psdiff_2.CLKP.n14 VSS 0.07285f
C1227 psdiff_2.CLKP.t3 VSS 0.01269f
C1228 psdiff_2.CLKP.n15 VSS 0.02334f
C1229 psdiff_2.CLKP.n16 VSS 0.03008f
C1230 CTRL.n0 VSS 0.00309f
C1231 CTRL.n1 VSS 0.00749f
C1232 CTRL.n2 VSS 0.00749f
C1233 CTRL.n3 VSS 0.00749f
C1234 CTRL.n4 VSS 0.00749f
C1235 CTRL.n5 VSS 0.00749f
C1236 CTRL.n6 VSS 0.00749f
C1237 CTRL.n7 VSS 0.00749f
C1238 CTRL.n8 VSS 0.00749f
C1239 CTRL.n9 VSS 0.00812f
C1240 CTRL.t3 VSS 0.3844f
C1241 CTRL.t2 VSS 0.3844f
C1242 CTRL.t1 VSS 0.3844f
C1243 CTRL.n10 VSS 0.02414f
C1244 CTRL.n11 VSS 0.02414f
C1245 CTRL.n12 VSS 0.02414f
C1246 CTRL.n13 VSS 0.02414f
C1247 CTRL.n14 VSS 0.02414f
C1248 CTRL.n15 VSS 0.00749f
C1249 CTRL.n16 VSS 0.01382f
C1250 CTRL.n17 VSS 0.02414f
C1251 CTRL.n18 VSS 0.01382f
C1252 CTRL.n19 VSS 0.02414f
C1253 CTRL.n20 VSS 0.01382f
C1254 CTRL.n21 VSS 0.02414f
C1255 CTRL.n22 VSS 0.01382f
C1256 CTRL.n23 VSS 0.02414f
C1257 CTRL.n24 VSS 0.01382f
C1258 CTRL.n25 VSS 0.02414f
C1259 CTRL.n26 VSS 0.01382f
C1260 CTRL.n27 VSS 0.02414f
C1261 CTRL.n28 VSS 0.01382f
C1262 CTRL.n29 VSS 0.02414f
C1263 CTRL.n30 VSS 0.01382f
C1264 CTRL.n31 VSS 0.02414f
C1265 CTRL.n32 VSS 0.08632f
C1266 CTRL.n33 VSS 0.00345f
C1267 CTRL.t23 VSS 0.02203f
C1268 CTRL.n34 VSS 0.05313f
C1269 CTRL.t17 VSS 0.02164f
C1270 CTRL.n35 VSS 0.00345f
C1271 CTRL.n36 VSS 0.04671f
C1272 CTRL.t21 VSS 0.02164f
C1273 CTRL.n37 VSS 0.00749f
C1274 CTRL.n38 VSS 0.00749f
C1275 CTRL.n39 VSS 0.00749f
C1276 CTRL.n40 VSS 0.00749f
C1277 CTRL.n41 VSS 0.00749f
C1278 CTRL.n42 VSS 0.00749f
C1279 CTRL.n43 VSS 0.00749f
C1280 CTRL.n44 VSS 0.00749f
C1281 CTRL.n45 VSS 0.00749f
C1282 CTRL.n46 VSS 0.00749f
C1283 CTRL.n47 VSS 0.00749f
C1284 CTRL.n48 VSS 0.00749f
C1285 CTRL.n49 VSS 0.00749f
C1286 CTRL.n50 VSS 0.00749f
C1287 CTRL.n51 VSS 0.00856f
C1288 CTRL.n52 VSS 0.02414f
C1289 CTRL.n53 VSS 0.01382f
C1290 CTRL.n54 VSS 0.01382f
C1291 CTRL.n55 VSS 0.01382f
C1292 CTRL.n56 VSS 0.01382f
C1293 CTRL.n57 VSS 0.01382f
C1294 CTRL.n58 VSS 0.01382f
C1295 CTRL.n59 VSS 0.01382f
C1296 CTRL.n60 VSS 0.01382f
C1297 CTRL.n61 VSS 0.01382f
C1298 CTRL.n62 VSS 0.01382f
C1299 CTRL.n63 VSS 0.01382f
C1300 CTRL.n64 VSS 0.01382f
C1301 CTRL.n65 VSS 0.01382f
C1302 CTRL.n66 VSS 0.01382f
C1303 CTRL.t16 VSS 0.3844f
C1304 CTRL.n67 VSS 0.02414f
C1305 CTRL.n68 VSS 0.02414f
C1306 CTRL.n69 VSS 0.02414f
C1307 CTRL.n70 VSS 0.02414f
C1308 CTRL.n71 VSS 0.02414f
C1309 CTRL.n72 VSS 0.02414f
C1310 CTRL.n73 VSS 0.02414f
C1311 CTRL.n74 VSS 0.02414f
C1312 CTRL.n75 VSS 0.02414f
C1313 CTRL.n76 VSS 0.02414f
C1314 CTRL.n77 VSS 0.02414f
C1315 CTRL.n78 VSS 0.02414f
C1316 CTRL.n79 VSS 0.02414f
C1317 CTRL.n80 VSS 0.02414f
C1318 CTRL.t22 VSS 0.41194f
C1319 CTRL.n81 VSS 0.02414f
C1320 CTRL.n82 VSS 0.01275f
C1321 CTRL.t18 VSS 0.3844f
C1322 CTRL.n83 VSS 0.01531f
C1323 CTRL.t20 VSS 0.3844f
C1324 CTRL.n84 VSS 0.0098f
C1325 CTRL.n85 VSS 0.01065f
C1326 CTRL.n86 VSS 0.00812f
C1327 CTRL.n87 VSS 0.00812f
C1328 CTRL.n88 VSS 0.00812f
C1329 CTRL.n89 VSS 0.00812f
C1330 CTRL.n90 VSS 0.00812f
C1331 CTRL.n91 VSS 0.00812f
C1332 CTRL.n92 VSS 0.00812f
C1333 CTRL.n93 VSS 0.00812f
C1334 CTRL.n94 VSS 0.00812f
C1335 CTRL.n95 VSS 0.00812f
C1336 CTRL.n96 VSS 0.00812f
C1337 CTRL.n97 VSS 0.00812f
C1338 CTRL.n98 VSS 0.00812f
C1339 CTRL.n99 VSS 0.00812f
C1340 CTRL.n100 VSS 0.00593f
C1341 CTRL.n101 VSS 0.0023f
C1342 CTRL.t19 VSS 0.02164f
C1343 CTRL.n102 VSS 0.00345f
C1344 CTRL.n103 VSS 0.04668f
C1345 CTRL.n104 VSS 0.04725f
C1346 CTRL.n105 VSS 0.0868f
C1347 CTRL.t25 VSS 0.03753f
C1348 CTRL.n106 VSS 0.01945f
C1349 CTRL.n107 VSS 0.16442f
C1350 CTRL.n108 VSS 0.09533f
C1351 CTRL.t4 VSS 0.02203f
C1352 CTRL.n109 VSS 0.05313f
C1353 CTRL.n110 VSS 0.00345f
C1354 CTRL.n111 VSS 0.02414f
C1355 CTRL.n112 VSS 0.02414f
C1356 CTRL.n113 VSS 0.02414f
C1357 CTRL.n114 VSS 0.02414f
C1358 CTRL.n115 VSS 0.02414f
C1359 CTRL.n116 VSS 0.02414f
C1360 CTRL.n117 VSS 0.02414f
C1361 CTRL.n118 VSS 0.02414f
C1362 CTRL.n119 VSS 0.02414f
C1363 CTRL.n120 VSS 0.02414f
C1364 CTRL.n121 VSS 0.02414f
C1365 CTRL.n122 VSS 0.02414f
C1366 CTRL.n123 VSS 0.02414f
C1367 CTRL.n124 VSS 0.02414f
C1368 CTRL.t9 VSS 0.3844f
C1369 CTRL.t11 VSS 0.3844f
C1370 CTRL.n125 VSS 0.01064f
C1371 CTRL.n126 VSS 0.01382f
C1372 CTRL.n127 VSS 0.00749f
C1373 CTRL.n128 VSS 0.01382f
C1374 CTRL.n129 VSS 0.00749f
C1375 CTRL.n130 VSS 0.01382f
C1376 CTRL.n131 VSS 0.00749f
C1377 CTRL.n132 VSS 0.01382f
C1378 CTRL.n133 VSS 0.00749f
C1379 CTRL.n134 VSS 0.01382f
C1380 CTRL.n135 VSS 0.00749f
C1381 CTRL.n136 VSS 0.01382f
C1382 CTRL.n137 VSS 0.00749f
C1383 CTRL.n138 VSS 0.01382f
C1384 CTRL.n139 VSS 0.00749f
C1385 CTRL.n140 VSS 0.01382f
C1386 CTRL.n141 VSS 0.00749f
C1387 CTRL.n142 VSS 0.01382f
C1388 CTRL.n143 VSS 0.00749f
C1389 CTRL.n144 VSS 0.01382f
C1390 CTRL.n145 VSS 0.00749f
C1391 CTRL.n146 VSS 0.01382f
C1392 CTRL.n147 VSS 0.00749f
C1393 CTRL.n148 VSS 0.01382f
C1394 CTRL.n149 VSS 0.00749f
C1395 CTRL.n150 VSS 0.01382f
C1396 CTRL.n151 VSS 0.00749f
C1397 CTRL.n152 VSS 0.01382f
C1398 CTRL.t14 VSS 0.02164f
C1399 CTRL.t15 VSS 0.02336f
C1400 CTRL.t10 VSS 0.02164f
C1401 CTRL.n153 VSS 0.02414f
C1402 CTRL.t12 VSS 0.02164f
C1403 CTRL.n154 VSS 0.01382f
C1404 CTRL.n155 VSS 0.00749f
C1405 CTRL.n156 VSS 0.00592f
C1406 CTRL.n157 VSS 0.00812f
C1407 CTRL.n158 VSS 0.00812f
C1408 CTRL.n159 VSS 0.00812f
C1409 CTRL.n160 VSS 0.00812f
C1410 CTRL.n161 VSS 0.00812f
C1411 CTRL.n162 VSS 0.00812f
C1412 CTRL.n163 VSS 0.00812f
C1413 CTRL.n164 VSS 0.00812f
C1414 CTRL.n165 VSS 0.00812f
C1415 CTRL.n166 VSS 0.00812f
C1416 CTRL.n167 VSS 0.00812f
C1417 CTRL.n168 VSS 0.00812f
C1418 CTRL.n169 VSS 0.00812f
C1419 CTRL.n170 VSS 0.00812f
C1420 CTRL.n171 VSS 0.00749f
C1421 CTRL.n172 VSS 0.00345f
C1422 CTRL.n173 VSS 0.01382f
C1423 CTRL.n174 VSS 0.00749f
C1424 CTRL.n175 VSS 0.01382f
C1425 CTRL.n176 VSS 0.00749f
C1426 CTRL.n177 VSS 0.01382f
C1427 CTRL.n178 VSS 0.00749f
C1428 CTRL.n179 VSS 0.01382f
C1429 CTRL.n180 VSS 0.00749f
C1430 CTRL.n181 VSS 0.01382f
C1431 CTRL.n182 VSS 0.00749f
C1432 CTRL.n183 VSS 0.00812f
C1433 CTRL.n184 VSS 0.00812f
C1434 CTRL.n185 VSS 0.00812f
C1435 CTRL.n186 VSS 0.00812f
C1436 CTRL.n187 VSS 0.01065f
C1437 CTRL.t7 VSS 0.02164f
C1438 CTRL.n188 VSS 0.0061f
C1439 CTRL.t5 VSS 0.02164f
C1440 CTRL.n189 VSS 0.00345f
C1441 CTRL.n190 VSS 0.04729f
C1442 CTRL.n191 VSS 0.08632f
C1443 CTRL.n192 VSS 0.04671f
C1444 CTRL.t6 VSS 0.02164f
C1445 CTRL.n193 VSS 0.00345f
C1446 CTRL.n194 VSS 0.04668f
C1447 CTRL.n195 VSS 0.0868f
C1448 CTRL.n196 VSS 0.04904f
C1449 CTRL.n197 VSS 0.00432f
C1450 CTRL.t13 VSS 0.3844f
C1451 CTRL.n198 VSS 0.00856f
C1452 CTRL.n199 VSS 0.01275f
C1453 CTRL.n200 VSS 0.02414f
C1454 CTRL.t8 VSS 0.41061f
C1455 CTRL.n201 VSS 0.05371f
C1456 CTRL.n202 VSS 0.08632f
C1457 CTRL.n203 VSS 0.16432f
C1458 CTRL.t24 VSS 0.03753f
C1459 CTRL.n204 VSS 0.10374f
C1460 CTRL.n205 VSS 0.18018f
C1461 CTRL.n206 VSS 0.33027f
C1462 CTRL.t26 VSS 0.03753f
C1463 CTRL.n207 VSS 0.10374f
C1464 CTRL.n208 VSS 0.22079f
C1465 CTRL.n209 VSS 0.16432f
C1466 CTRL.n210 VSS 0.09533f
C1467 CTRL.n211 VSS 0.08632f
C1468 CTRL.n212 VSS 0.04729f
C1469 CTRL.n213 VSS 0.00345f
C1470 CTRL.n214 VSS 0.05371f
C1471 CTRL.n215 VSS 0.01382f
C1472 CTRL.n216 VSS 0.02414f
C1473 CTRL.t0 VSS 0.41061f
C1474 CTRL.n217 VSS 0.02414f
C1475 CTRL.n218 VSS 0.01382f
C1476 CTRL.n219 VSS 0.00749f
C1477 CTRL.n220 VSS 0.00811f
C1478 CTRL.n221 VSS 0.00812f
C1479 CTRL.n222 VSS 0.00812f
C1480 CTRL.n223 VSS 0.00812f
C1481 CTRL.n224 VSS 0.00812f
C1482 CTRL.n225 VSS 0.00812f
C1483 CTRL.n226 VSS 0.00812f
C1484 CTRL.n227 VSS 0.00812f
C1485 CTRL.n228 VSS 0.00771f
C1486 PH4.t11 VSS 0.056f
C1487 PH4.n0 VSS 0.00602f
C1488 PH4.t2 VSS 0.02474f
C1489 PH4.t8 VSS 0.02474f
C1490 PH4.n1 VSS 0.00963f
C1491 PH4.n2 VSS 0.05865f
C1492 PH4.n3 VSS 0.04019f
C1493 PH4.t4 VSS 0.02474f
C1494 PH4.t7 VSS 0.02474f
C1495 PH4.n4 VSS 0.00963f
C1496 PH4.n5 VSS 0.05865f
C1497 PH4.n6 VSS 0.04019f
C1498 PH4.t5 VSS 0.02474f
C1499 PH4.t6 VSS 0.02474f
C1500 PH4.n7 VSS 0.00963f
C1501 PH4.n8 VSS 0.05865f
C1502 PH4.n9 VSS 0.04019f
C1503 PH4.t3 VSS 0.02474f
C1504 PH4.t9 VSS 0.02474f
C1505 PH4.n10 VSS 0.00963f
C1506 PH4.n11 VSS 0.05865f
C1507 PH4.n12 VSS 0.04552f
C1508 PH4.n13 VSS 0.14205f
C1509 PH4.n14 VSS 0.08383f
C1510 PH4.n15 VSS 0.23201f
C1511 PH4.t10 VSS 1.29838f
C1512 PH4.n16 VSS 0.35964f
C1513 PH4.t12 VSS 0.056f
C1514 PH4.n17 VSS 0.01137f
C1515 PH4.n18 VSS 0.1499f
C1516 PH4.n19 VSS 0.12784f
C1517 PH4.n20 VSS 0.00487f
C1518 PH4.t1 VSS 0.02474f
C1519 PH4.n21 VSS 0.01181f
C1520 PH4.t0 VSS 0.02504f
C1521 PH4.n22 VSS 0.01302f
C1522 VDD.t37 VSS 0.00421f
C1523 VDD.n0 VSS 0.01014f
C1524 VDD.t40 VSS 0.00421f
C1525 VDD.n1 VSS 0.00538f
C1526 VDD.t41 VSS 0.66098f
C1527 VDD.t230 VSS 0.00421f
C1528 VDD.n2 VSS 0.01014f
C1529 VDD.t55 VSS 0.79318f
C1530 VDD.t225 VSS 0.00421f
C1531 VDD.n3 VSS 0.00538f
C1532 VDD.t25 VSS 1.20501f
C1533 VDD.t229 VSS 0.00421f
C1534 VDD.n4 VSS 0.01014f
C1535 VDD.t223 VSS 0.00421f
C1536 VDD.n5 VSS 0.00538f
C1537 VDD.n6 VSS 0.00711f
C1538 VDD.t259 VSS 0.00421f
C1539 VDD.n7 VSS 0.01053f
C1540 VDD.t260 VSS 0.00421f
C1541 VDD.n9 VSS 0.00538f
C1542 VDD.t27 VSS 0.61907f
C1543 VDD.t31 VSS 0.00421f
C1544 VDD.n11 VSS 0.00538f
C1545 VDD.t154 VSS 0.00421f
C1546 VDD.n13 VSS 0.00538f
C1547 VDD.t61 VSS 1.01639f
C1548 VDD.t152 VSS 0.00421f
C1549 VDD.n15 VSS 0.00538f
C1550 VDD.t189 VSS 0.00421f
C1551 VDD.n16 VSS 0.01014f
C1552 VDD.t188 VSS 0.00421f
C1553 VDD.n17 VSS 0.00538f
C1554 VDD.t47 VSS 0.66098f
C1555 VDD.t195 VSS 0.00421f
C1556 VDD.n18 VSS 0.01014f
C1557 VDD.t46 VSS 0.9818f
C1558 VDD.t197 VSS 0.00421f
C1559 VDD.n19 VSS 0.00538f
C1560 VDD.t198 VSS 0.00421f
C1561 VDD.n20 VSS 0.01014f
C1562 VDD.t193 VSS 0.00421f
C1563 VDD.n21 VSS 0.00538f
C1564 VDD.t194 VSS 0.00421f
C1565 VDD.n22 VSS 0.00538f
C1566 VDD.t199 VSS 0.00421f
C1567 VDD.n23 VSS 0.01053f
C1568 VDD.t192 VSS 0.33337f
C1569 VDD.t200 VSS 0.00421f
C1570 VDD.n25 VSS 0.00538f
C1571 VDD.t196 VSS 0.00421f
C1572 VDD.n26 VSS 0.01053f
C1573 VDD.t190 VSS 0.00421f
C1574 VDD.n28 VSS 0.00538f
C1575 VDD.t191 VSS 0.00421f
C1576 VDD.n29 VSS 0.01053f
C1577 VDD.t60 VSS 0.61907f
C1578 VDD.t122 VSS 0.00421f
C1579 VDD.n31 VSS 0.00538f
C1580 VDD.t121 VSS 0.00421f
C1581 VDD.n33 VSS 0.01053f
C1582 VDD.t91 VSS 0.00421f
C1583 VDD.n34 VSS 0.01048f
C1584 VDD.n35 VSS 0.00711f
C1585 VDD.t155 VSS 0.00421f
C1586 VDD.t148 VSS 0.00421f
C1587 VDD.n36 VSS 0.01053f
C1588 VDD.n37 VSS 0.00538f
C1589 VDD.t151 VSS 0.00421f
C1590 VDD.n38 VSS 0.01014f
C1591 VDD.t150 VSS 0.00421f
C1592 VDD.t156 VSS 0.00421f
C1593 VDD.n39 VSS 0.01053f
C1594 VDD.n40 VSS 0.00538f
C1595 VDD.t149 VSS 0.9818f
C1596 VDD.t153 VSS 0.00421f
C1597 VDD.n41 VSS 0.01014f
C1598 VDD.t30 VSS 0.66098f
C1599 VDD.t28 VSS 0.00421f
C1600 VDD.t29 VSS 0.00421f
C1601 VDD.n42 VSS 0.01053f
C1602 VDD.n43 VSS 0.00538f
C1603 VDD.t32 VSS 0.00421f
C1604 VDD.n44 VSS 0.01014f
C1605 VDD.t228 VSS 0.00421f
C1606 VDD.t26 VSS 0.00421f
C1607 VDD.n45 VSS 0.01048f
C1608 VDD.n46 VSS 0.00538f
C1609 VDD.t224 VSS 0.00421f
C1610 VDD.n47 VSS 0.01053f
C1611 VDD.t227 VSS 0.00421f
C1612 VDD.n49 VSS 0.00538f
C1613 VDD.t226 VSS 0.00421f
C1614 VDD.n50 VSS 0.01053f
C1615 VDD.t42 VSS 0.00421f
C1616 VDD.n52 VSS 0.00538f
C1617 VDD.t39 VSS 0.00421f
C1618 VDD.n53 VSS 0.01053f
C1619 VDD.t38 VSS 0.61907f
C1620 VDD.t157 VSS 0.00421f
C1621 VDD.n55 VSS 0.00538f
C1622 VDD.n57 VSS 0.02574f
C1623 VDD.n59 VSS 0.05968f
C1624 VDD.n60 VSS 0.14275f
C1625 VDD.t167 VSS 0.00421f
C1626 VDD.t161 VSS 0.00421f
C1627 VDD.n62 VSS 0.00538f
C1628 VDD.t165 VSS 0.00421f
C1629 VDD.n63 VSS 0.01053f
C1630 VDD.t168 VSS 0.00421f
C1631 VDD.n65 VSS 0.00538f
C1632 VDD.t145 VSS 0.00421f
C1633 VDD.n67 VSS 0.00538f
C1634 VDD.n68 VSS 0.00711f
C1635 VDD.t80 VSS 0.00421f
C1636 VDD.t59 VSS 0.00421f
C1637 VDD.n69 VSS 0.01048f
C1638 VDD.n70 VSS 0.01053f
C1639 VDD.t75 VSS 0.00421f
C1640 VDD.n72 VSS 0.00538f
C1641 VDD.t81 VSS 0.00421f
C1642 VDD.n73 VSS 0.00734f
C1643 VDD.t76 VSS 0.00421f
C1644 VDD.n74 VSS 0.00538f
C1645 VDD.t71 VSS 0.00421f
C1646 VDD.n76 VSS 0.00538f
C1647 VDD.t35 VSS 0.00421f
C1648 VDD.n78 VSS 0.00538f
C1649 VDD.t85 VSS 0.00421f
C1650 VDD.n80 VSS 0.00538f
C1651 VDD.t86 VSS 0.00421f
C1652 VDD.n82 VSS 0.00538f
C1653 VDD.t218 VSS 0.00421f
C1654 VDD.n84 VSS 0.00538f
C1655 VDD.t68 VSS 0.00421f
C1656 VDD.n85 VSS 0.01048f
C1657 VDD.n86 VSS 0.00711f
C1658 VDD.t52 VSS 0.00421f
C1659 VDD.n87 VSS 0.00538f
C1660 VDD.t53 VSS 0.00421f
C1661 VDD.n88 VSS 0.01053f
C1662 VDD.t216 VSS 0.00421f
C1663 VDD.t217 VSS 0.00421f
C1664 VDD.n90 VSS 0.01053f
C1665 VDD.n91 VSS 0.00538f
C1666 VDD.t215 VSS 0.00421f
C1667 VDD.n92 VSS 0.01053f
C1668 VDD.t83 VSS 0.00421f
C1669 VDD.t89 VSS 0.00421f
C1670 VDD.n94 VSS 0.01053f
C1671 VDD.n95 VSS 0.00538f
C1672 VDD.t84 VSS 0.00421f
C1673 VDD.n96 VSS 0.00734f
C1674 VDD.t90 VSS 0.00421f
C1675 VDD.t88 VSS 0.00421f
C1676 VDD.n97 VSS 0.01053f
C1677 VDD.n98 VSS 0.00538f
C1678 VDD.t51 VSS 0.00421f
C1679 VDD.t87 VSS 0.00421f
C1680 VDD.n100 VSS 0.01053f
C1681 VDD.n101 VSS 0.01048f
C1682 VDD.n102 VSS 0.00711f
C1683 VDD.t73 VSS 0.00421f
C1684 VDD.t34 VSS 0.00421f
C1685 VDD.n103 VSS 0.01053f
C1686 VDD.n104 VSS 0.00538f
C1687 VDD.t74 VSS 0.00421f
C1688 VDD.n105 VSS 0.01053f
C1689 VDD.t78 VSS 0.00421f
C1690 VDD.t72 VSS 0.00421f
C1691 VDD.n107 VSS 0.01053f
C1692 VDD.n108 VSS 0.00538f
C1693 VDD.t82 VSS 0.00421f
C1694 VDD.n109 VSS 0.01053f
C1695 VDD.t79 VSS 0.00421f
C1696 VDD.n111 VSS 0.00538f
C1697 VDD.t77 VSS 0.00421f
C1698 VDD.n112 VSS 0.01053f
C1699 VDD.t142 VSS 0.00421f
C1700 VDD.n114 VSS 0.00538f
C1701 VDD.t141 VSS 0.00421f
C1702 VDD.n115 VSS 0.01053f
C1703 VDD.t144 VSS 0.00421f
C1704 VDD.t143 VSS 0.00421f
C1705 VDD.n117 VSS 0.01053f
C1706 VDD.n118 VSS 0.00538f
C1707 VDD.n119 VSS 0.00907f
C1708 VDD.n120 VSS 0.14428f
C1709 VDD.n121 VSS 0.19499f
C1710 VDD.t109 VSS 0.00474f
C1711 VDD.t365 VSS 0.0046f
C1712 VDD.n122 VSS 0.00842f
C1713 VDD.t369 VSS 0.0046f
C1714 VDD.n123 VSS 0.00322f
C1715 VDD.n124 VSS 0.01411f
C1716 VDD.t116 VSS 0.00474f
C1717 VDD.t373 VSS 0.0046f
C1718 VDD.n125 VSS 0.00842f
C1719 VDD.t357 VSS 0.0046f
C1720 VDD.n126 VSS 0.00322f
C1721 VDD.n127 VSS 0.01429f
C1722 VDD.t114 VSS 0.0043f
C1723 VDD.t366 VSS 0.00417f
C1724 VDD.n128 VSS 0.00842f
C1725 VDD.t391 VSS 0.00417f
C1726 VDD.n129 VSS 0.00605f
C1727 VDD.n130 VSS 0.01951f
C1728 VDD.t111 VSS 0.00474f
C1729 VDD.t362 VSS 0.0046f
C1730 VDD.n131 VSS 0.00842f
C1731 VDD.t376 VSS 0.0046f
C1732 VDD.n132 VSS 0.00322f
C1733 VDD.n133 VSS 0.01178f
C1734 VDD.n134 VSS 0.16312f
C1735 VDD.n135 VSS 0.01329f
C1736 VDD.t186 VSS 0.00421f
C1737 VDD.t5 VSS 0.00421f
C1738 VDD.n136 VSS 0.01014f
C1739 VDD.t6 VSS 0.00421f
C1740 VDD.n137 VSS 0.00538f
C1741 VDD.t182 VSS 0.00421f
C1742 VDD.n138 VSS 0.01014f
C1743 VDD.t184 VSS 0.00421f
C1744 VDD.n139 VSS 0.00538f
C1745 VDD.t185 VSS 0.00421f
C1746 VDD.n140 VSS 0.01014f
C1747 VDD.n141 VSS 0.00711f
C1748 VDD.t201 VSS 0.00421f
C1749 VDD.n142 VSS 0.01053f
C1750 VDD.t202 VSS 0.00421f
C1751 VDD.n144 VSS 0.00538f
C1752 VDD.t242 VSS 0.00421f
C1753 VDD.n146 VSS 0.00538f
C1754 VDD.t10 VSS 0.00421f
C1755 VDD.n148 VSS 0.00538f
C1756 VDD.t13 VSS 0.00421f
C1757 VDD.n150 VSS 0.00538f
C1758 VDD.t246 VSS 0.00421f
C1759 VDD.n151 VSS 0.01014f
C1760 VDD.t247 VSS 0.00421f
C1761 VDD.n152 VSS 0.00538f
C1762 VDD.t21 VSS 0.00421f
C1763 VDD.n153 VSS 0.01014f
C1764 VDD.t16 VSS 0.00421f
C1765 VDD.n154 VSS 0.00538f
C1766 VDD.t18 VSS 0.00421f
C1767 VDD.n155 VSS 0.01014f
C1768 VDD.t19 VSS 0.00421f
C1769 VDD.n156 VSS 0.00538f
C1770 VDD.t15 VSS 0.00421f
C1771 VDD.n157 VSS 0.00538f
C1772 VDD.t17 VSS 0.00421f
C1773 VDD.n158 VSS 0.01053f
C1774 VDD.t22 VSS 0.00421f
C1775 VDD.n160 VSS 0.00538f
C1776 VDD.t20 VSS 0.00421f
C1777 VDD.n161 VSS 0.01053f
C1778 VDD.t245 VSS 0.00421f
C1779 VDD.n163 VSS 0.00538f
C1780 VDD.t248 VSS 0.00421f
C1781 VDD.n164 VSS 0.01053f
C1782 VDD.t70 VSS 0.00421f
C1783 VDD.n166 VSS 0.00538f
C1784 VDD.t69 VSS 0.00421f
C1785 VDD.n168 VSS 0.01053f
C1786 VDD.t67 VSS 0.00421f
C1787 VDD.n169 VSS 0.01048f
C1788 VDD.n170 VSS 0.00711f
C1789 VDD.t8 VSS 0.00421f
C1790 VDD.t11 VSS 0.00421f
C1791 VDD.n171 VSS 0.01053f
C1792 VDD.n172 VSS 0.00538f
C1793 VDD.t7 VSS 0.00421f
C1794 VDD.n173 VSS 0.01014f
C1795 VDD.t14 VSS 0.00421f
C1796 VDD.t9 VSS 0.00421f
C1797 VDD.n174 VSS 0.01053f
C1798 VDD.n175 VSS 0.00538f
C1799 VDD.t12 VSS 0.00421f
C1800 VDD.n176 VSS 0.01014f
C1801 VDD.t244 VSS 0.00421f
C1802 VDD.t241 VSS 0.00421f
C1803 VDD.n177 VSS 0.01053f
C1804 VDD.n178 VSS 0.00538f
C1805 VDD.t243 VSS 0.00421f
C1806 VDD.n179 VSS 0.01014f
C1807 VDD.t183 VSS 0.00421f
C1808 VDD.t54 VSS 0.00421f
C1809 VDD.n180 VSS 0.01048f
C1810 VDD.n181 VSS 0.00538f
C1811 VDD.t180 VSS 0.00421f
C1812 VDD.n182 VSS 0.01053f
C1813 VDD.t181 VSS 0.00421f
C1814 VDD.n184 VSS 0.00538f
C1815 VDD.t187 VSS 0.00421f
C1816 VDD.n185 VSS 0.01053f
C1817 VDD.n187 VSS 0.0082f
C1818 VDD.t4 VSS 0.00421f
C1819 VDD.n188 VSS 0.00538f
C1820 VDD.t3 VSS 0.00421f
C1821 VDD.n189 VSS 0.01053f
C1822 VDD.t96 VSS 0.00421f
C1823 VDD.t94 VSS 0.00421f
C1824 VDD.n192 VSS 0.00538f
C1825 VDD.t95 VSS 0.00421f
C1826 VDD.n193 VSS 0.01053f
C1827 VDD.t98 VSS 0.00421f
C1828 VDD.n195 VSS 0.00538f
C1829 VDD.t128 VSS 0.00421f
C1830 VDD.n197 VSS 0.00538f
C1831 VDD.n198 VSS 0.00711f
C1832 VDD.t213 VSS 0.00421f
C1833 VDD.t147 VSS 0.00421f
C1834 VDD.n199 VSS 0.01048f
C1835 VDD.n200 VSS 0.01053f
C1836 VDD.t209 VSS 0.00421f
C1837 VDD.n202 VSS 0.00538f
C1838 VDD.t214 VSS 0.00421f
C1839 VDD.n203 VSS 0.00734f
C1840 VDD.t210 VSS 0.00421f
C1841 VDD.n204 VSS 0.00538f
C1842 VDD.t203 VSS 0.00421f
C1843 VDD.n206 VSS 0.00538f
C1844 VDD.t159 VSS 0.00421f
C1845 VDD.n207 VSS 0.00958f
C1846 VDD.t160 VSS 0.00421f
C1847 VDD.n208 VSS 0.00538f
C1848 VDD.t105 VSS 0.00421f
C1849 VDD.n210 VSS 0.00538f
C1850 VDD.t102 VSS 0.00421f
C1851 VDD.n212 VSS 0.00538f
C1852 VDD.t219 VSS 0.00421f
C1853 VDD.n214 VSS 0.00538f
C1854 VDD.t24 VSS 0.00421f
C1855 VDD.n215 VSS 0.01048f
C1856 VDD.n216 VSS 0.00711f
C1857 VDD.t119 VSS 0.00421f
C1858 VDD.n217 VSS 0.00538f
C1859 VDD.t120 VSS 0.00421f
C1860 VDD.n218 VSS 0.00958f
C1861 VDD.t221 VSS 0.00421f
C1862 VDD.t220 VSS 0.00421f
C1863 VDD.n219 VSS 0.01053f
C1864 VDD.n220 VSS 0.00538f
C1865 VDD.t222 VSS 0.00421f
C1866 VDD.n221 VSS 0.01053f
C1867 VDD.t101 VSS 0.00421f
C1868 VDD.t107 VSS 0.00421f
C1869 VDD.n223 VSS 0.01053f
C1870 VDD.n224 VSS 0.00538f
C1871 VDD.t104 VSS 0.00421f
C1872 VDD.n225 VSS 0.00734f
C1873 VDD.t100 VSS 0.00421f
C1874 VDD.t106 VSS 0.00421f
C1875 VDD.n226 VSS 0.01053f
C1876 VDD.n227 VSS 0.00538f
C1877 VDD.t140 VSS 0.00421f
C1878 VDD.t103 VSS 0.00421f
C1879 VDD.n229 VSS 0.01053f
C1880 VDD.n230 VSS 0.01048f
C1881 VDD.n231 VSS 0.00711f
C1882 VDD.t205 VSS 0.00421f
C1883 VDD.n232 VSS 0.00538f
C1884 VDD.t204 VSS 0.00421f
C1885 VDD.n233 VSS 0.01053f
C1886 VDD.t211 VSS 0.00421f
C1887 VDD.t206 VSS 0.00421f
C1888 VDD.n235 VSS 0.01053f
C1889 VDD.n236 VSS 0.00538f
C1890 VDD.t208 VSS 0.00421f
C1891 VDD.n237 VSS 0.01053f
C1892 VDD.n239 VSS 0.0082f
C1893 VDD.n240 VSS 0.10792f
C1894 VDD.n241 VSS 0.00505f
C1895 VDD.t231 VSS 0.00474f
C1896 VDD.t317 VSS 0.0046f
C1897 VDD.n242 VSS 0.00842f
C1898 VDD.t326 VSS 0.0046f
C1899 VDD.n243 VSS 0.00322f
C1900 VDD.t233 VSS 0.00474f
C1901 VDD.t324 VSS 0.0046f
C1902 VDD.n244 VSS 0.00842f
C1903 VDD.t331 VSS 0.0046f
C1904 VDD.n245 VSS 0.00322f
C1905 VDD.n246 VSS 0.01856f
C1906 VDD.n247 VSS 0.01081f
C1907 VDD.t136 VSS 0.0043f
C1908 VDD.t321 VSS 0.00417f
C1909 VDD.n248 VSS 0.00842f
C1910 VDD.t346 VSS 0.00417f
C1911 VDD.n249 VSS 0.00605f
C1912 VDD.n250 VSS 0.01951f
C1913 VDD.t133 VSS 0.00474f
C1914 VDD.t315 VSS 0.0046f
C1915 VDD.n251 VSS 0.00842f
C1916 VDD.t316 VSS 0.0046f
C1917 VDD.n252 VSS 0.00322f
C1918 VDD.n253 VSS 0.01178f
C1919 VDD.n254 VSS 0.16312f
C1920 VDD.n255 VSS 0.01329f
C1921 VDD.n256 VSS 0.0082f
C1922 VDD.n257 VSS 0.19499f
C1923 VDD.n258 VSS 0.14275f
C1924 VDD.n259 VSS 0.01437f
C1925 VDD.n260 VSS 0.01584f
C1926 VDD.n261 VSS 0.00426f
C1927 VDD.t135 VSS 0.00474f
C1928 VDD.t320 VSS 0.0046f
C1929 VDD.n262 VSS 0.00842f
C1930 VDD.t345 VSS 0.0046f
C1931 VDD.n263 VSS 0.00322f
C1932 VDD.n264 VSS 0.02283f
C1933 VDD.t130 VSS 0.00474f
C1934 VDD.t314 VSS 0.0046f
C1935 VDD.n265 VSS 0.00842f
C1936 VDD.t330 VSS 0.0046f
C1937 VDD.n266 VSS 0.00322f
C1938 VDD.n267 VSS 0.01429f
C1939 VDD.n268 VSS 0.0085f
C1940 VDD.t131 VSS 0.00474f
C1941 VDD.t336 VSS 0.0046f
C1942 VDD.n269 VSS 0.00842f
C1943 VDD.t323 VSS 0.0046f
C1944 VDD.n270 VSS 0.00322f
C1945 VDD.n271 VSS 0.01019f
C1946 VDD.n272 VSS 0.03157f
C1947 VDD.n273 VSS 0.05145f
C1948 VDD.n276 VSS 0.02574f
C1949 VDD.t49 VSS 0.00421f
C1950 VDD.t62 VSS 0.00421f
C1951 VDD.t50 VSS 0.00421f
C1952 VDD.n279 VSS 0.01053f
C1953 VDD.n280 VSS 0.00538f
C1954 VDD.t63 VSS 0.00421f
C1955 VDD.t273 VSS 0.00421f
C1956 VDD.t45 VSS 0.00421f
C1957 VDD.t271 VSS 0.00421f
C1958 VDD.n282 VSS 0.01053f
C1959 VDD.n283 VSS 0.00538f
C1960 VDD.t44 VSS 0.00421f
C1961 VDD.t58 VSS 0.00421f
C1962 VDD.n284 VSS 0.19712f
C1963 VDD.n285 VSS 0.01019f
C1964 VDD.t65 VSS 0.00421f
C1965 VDD.t57 VSS 0.00421f
C1966 VDD.n287 VSS 0.01053f
C1967 VDD.n288 VSS 0.00538f
C1968 VDD.t66 VSS 0.00421f
C1969 VDD.n289 VSS 0.01053f
C1970 VDD.t56 VSS 0.24945f
C1971 VDD.n291 VSS 0.04529f
C1972 VDD.n292 VSS 0.00538f
C1973 VDD.n293 VSS 0.01053f
C1974 VDD.t43 VSS 0.24945f
C1975 VDD.n295 VSS 0.04529f
C1976 VDD.n296 VSS 0.00538f
C1977 VDD.n297 VSS 0.01053f
C1978 VDD.t48 VSS 0.24945f
C1979 VDD.n299 VSS 0.04529f
C1980 VDD.n300 VSS 0.00538f
C1981 VDD.n301 VSS 0.01015f
C1982 VDD.n302 VSS 0.01012f
C1983 VDD.n303 VSS 0.0082f
C1984 VDD.n304 VSS 0.19323f
C1985 VDD.t250 VSS 0.00474f
C1986 VDD.t289 VSS 0.0046f
C1987 VDD.n305 VSS 0.00842f
C1988 VDD.t275 VSS 0.0046f
C1989 VDD.n306 VSS 0.00322f
C1990 VDD.n307 VSS 0.01411f
C1991 VDD.t251 VSS 0.00474f
C1992 VDD.t296 VSS 0.0046f
C1993 VDD.n308 VSS 0.00842f
C1994 VDD.t282 VSS 0.0046f
C1995 VDD.n309 VSS 0.00322f
C1996 VDD.n310 VSS 0.01429f
C1997 VDD.t249 VSS 0.0043f
C1998 VDD.t304 VSS 0.00417f
C1999 VDD.n311 VSS 0.00842f
C2000 VDD.t287 VSS 0.00417f
C2001 VDD.n312 VSS 0.00605f
C2002 VDD.n313 VSS 0.01951f
C2003 VDD.t252 VSS 0.00474f
C2004 VDD.t295 VSS 0.0046f
C2005 VDD.n314 VSS 0.00842f
C2006 VDD.t281 VSS 0.0046f
C2007 VDD.n315 VSS 0.00322f
C2008 VDD.n316 VSS 0.01178f
C2009 VDD.n317 VSS 0.16312f
C2010 VDD.n318 VSS 0.01136f
C2011 VDD.n319 VSS 0.0082f
C2012 VDD.n320 VSS 0.19323f
C2013 VDD.n321 VSS 0.14275f
C2014 VDD.n322 VSS 0.01437f
C2015 VDD.n323 VSS 0.01584f
C2016 VDD.n324 VSS 0.00426f
C2017 VDD.t254 VSS 0.00474f
C2018 VDD.t278 VSS 0.0046f
C2019 VDD.n325 VSS 0.00842f
C2020 VDD.t274 VSS 0.0046f
C2021 VDD.n326 VSS 0.00322f
C2022 VDD.n327 VSS 0.02283f
C2023 VDD.n328 VSS 0.0085f
C2024 VDD.n329 VSS 0.00426f
C2025 VDD.t178 VSS 0.00474f
C2026 VDD.t297 VSS 0.0046f
C2027 VDD.n330 VSS 0.00842f
C2028 VDD.t283 VSS 0.0046f
C2029 VDD.n331 VSS 0.00322f
C2030 VDD.n332 VSS 0.02283f
C2031 VDD.n333 VSS 0.0085f
C2032 VDD.t172 VSS 0.00474f
C2033 VDD.t279 VSS 0.0046f
C2034 VDD.n334 VSS 0.00842f
C2035 VDD.t276 VSS 0.0046f
C2036 VDD.n335 VSS 0.00322f
C2037 VDD.n336 VSS 0.01856f
C2038 VDD.n337 VSS 0.0085f
C2039 VDD.t171 VSS 0.00474f
C2040 VDD.t286 VSS 0.0046f
C2041 VDD.n338 VSS 0.00842f
C2042 VDD.t301 VSS 0.0046f
C2043 VDD.n339 VSS 0.00322f
C2044 VDD.n340 VSS 0.01088f
C2045 VDD.n341 VSS 0.00907f
C2046 VDD.n342 VSS 0.23133f
C2047 VDD.n343 VSS 0.0082f
C2048 VDD.n344 VSS 0.10792f
C2049 VDD.n345 VSS 0.01012f
C2050 VDD.n346 VSS 0.0082f
C2051 VDD.n347 VSS 0.19323f
C2052 VDD.n348 VSS 0.14275f
C2053 VDD.n349 VSS 0.01418f
C2054 VDD.n350 VSS 0.00505f
C2055 VDD.t170 VSS 0.00474f
C2056 VDD.t291 VSS 0.0046f
C2057 VDD.n351 VSS 0.00842f
C2058 VDD.t277 VSS 0.0046f
C2059 VDD.n352 VSS 0.00322f
C2060 VDD.n353 VSS 0.01856f
C2061 VDD.n354 VSS 0.0085f
C2062 VDD.t173 VSS 0.00474f
C2063 VDD.t284 VSS 0.0046f
C2064 VDD.n355 VSS 0.00842f
C2065 VDD.t285 VSS 0.0046f
C2066 VDD.n356 VSS 0.00322f
C2067 VDD.n357 VSS 0.01856f
C2068 VDD.t177 VSS 0.0043f
C2069 VDD.t294 VSS 0.00417f
C2070 VDD.n358 VSS 0.00842f
C2071 VDD.t280 VSS 0.00417f
C2072 VDD.n359 VSS 0.00605f
C2073 VDD.n360 VSS 0.02387f
C2074 VDD.t169 VSS 1.46885f
C2075 VDD.n361 VSS 0.1473f
C2076 VDD.n362 VSS 0.01081f
C2077 VDD.n363 VSS 0.00943f
C2078 VDD.n364 VSS 0.14275f
C2079 VDD.n365 VSS 0.0082f
C2080 VDD.n366 VSS 0.10792f
C2081 VDD.n367 VSS 0.00907f
C2082 VDD.n368 VSS 0.14428f
C2083 VDD.n369 VSS 0.19637f
C2084 VDD.n370 VSS 0.05123f
C2085 VDD.n371 VSS 0.03157f
C2086 VDD.n373 VSS 0.10699f
C2087 VDD.n374 VSS 0.08198f
C2088 VDD.n379 VSS 0.00907f
C2089 VDD.n380 VSS 0.23133f
C2090 VDD.n381 VSS 0.05145f
C2091 VDD.n382 VSS 0.08198f
C2092 VDD.n383 VSS 0.10699f
C2093 VDD.n384 VSS 0.02574f
C2094 VDD.n385 VSS 0.05123f
C2095 VDD.n386 VSS 0.19712f
C2096 VDD.n387 VSS 0.00907f
C2097 VDD.n388 VSS 0.14428f
C2098 VDD.n389 VSS 0.0082f
C2099 VDD.n390 VSS 0.10792f
C2100 VDD.n391 VSS 0.01206f
C2101 VDD.n392 VSS 0.0082f
C2102 VDD.n393 VSS 0.19499f
C2103 VDD.n394 VSS 0.14275f
C2104 VDD.n395 VSS 0.00943f
C2105 VDD.n396 VSS 0.01411f
C2106 VDD.n397 VSS 0.00426f
C2107 VDD.t134 VSS 0.00474f
C2108 VDD.t319 VSS 0.0046f
C2109 VDD.n398 VSS 0.00842f
C2110 VDD.t327 VSS 0.0046f
C2111 VDD.n399 VSS 0.00322f
C2112 VDD.n400 VSS 0.02283f
C2113 VDD.n401 VSS 0.0085f
C2114 VDD.t238 VSS 0.00474f
C2115 VDD.t325 VSS 0.0046f
C2116 VDD.n402 VSS 0.00842f
C2117 VDD.t322 VSS 0.0046f
C2118 VDD.n403 VSS 0.00322f
C2119 VDD.n404 VSS 0.01856f
C2120 VDD.n405 VSS 0.0085f
C2121 VDD.t236 VSS 0.00474f
C2122 VDD.t318 VSS 0.0046f
C2123 VDD.n406 VSS 0.00842f
C2124 VDD.t343 VSS 0.0046f
C2125 VDD.n407 VSS 0.00322f
C2126 VDD.n408 VSS 0.01856f
C2127 VDD.t234 VSS 0.0043f
C2128 VDD.t351 VSS 0.00417f
C2129 VDD.n409 VSS 0.00842f
C2130 VDD.t334 VSS 0.00417f
C2131 VDD.n410 VSS 0.00605f
C2132 VDD.n411 VSS 0.02387f
C2133 VDD.t129 VSS 1.46885f
C2134 VDD.n412 VSS 0.1473f
C2135 VDD.n413 VSS 0.0085f
C2136 VDD.n414 VSS 0.01088f
C2137 VDD.n415 VSS 0.01418f
C2138 VDD.n416 VSS 0.14275f
C2139 VDD.n417 VSS 0.0082f
C2140 VDD.n418 VSS 0.19499f
C2141 VDD.n419 VSS 0.01206f
C2142 VDD.t212 VSS 0.00421f
C2143 VDD.n420 VSS 0.00538f
C2144 VDD.t207 VSS 0.00421f
C2145 VDD.n421 VSS 0.01053f
C2146 VDD.t124 VSS 0.00421f
C2147 VDD.n423 VSS 0.00538f
C2148 VDD.t123 VSS 0.00421f
C2149 VDD.n424 VSS 0.00958f
C2150 VDD.t127 VSS 0.00421f
C2151 VDD.t126 VSS 0.00421f
C2152 VDD.n425 VSS 0.01053f
C2153 VDD.n426 VSS 0.00538f
C2154 VDD.n427 VSS 0.01206f
C2155 VDD.t125 VSS 0.00421f
C2156 VDD.n428 VSS 0.01053f
C2157 VDD.t92 VSS 0.00421f
C2158 VDD.n430 VSS 0.00734f
C2159 VDD.t97 VSS 0.00421f
C2160 VDD.t93 VSS 0.00421f
C2161 VDD.n431 VSS 0.01053f
C2162 VDD.n432 VSS 0.00538f
C2163 VDD.t99 VSS 0.00421f
C2164 VDD.n433 VSS 0.01053f
C2165 VDD.t23 VSS 2.70101f
C2166 VDD.n435 VSS 0.54903f
C2167 VDD.n436 VSS 0.00538f
C2168 VDD.n437 VSS 0.01206f
C2169 VDD.n438 VSS 0.19499f
C2170 VDD.n439 VSS 0.0082f
C2171 VDD.t1 VSS 0.00421f
C2172 VDD.n440 VSS 0.00538f
C2173 VDD.t2 VSS 0.00421f
C2174 VDD.n442 VSS 0.01053f
C2175 VDD.t64 VSS 0.00421f
C2176 VDD.n443 VSS 0.01048f
C2177 VDD.n444 VSS 0.00711f
C2178 VDD.t0 VSS 2.70101f
C2179 VDD.n445 VSS 0.54903f
C2180 VDD.n446 VSS 0.00538f
C2181 VDD.n447 VSS 0.0082f
C2182 VDD.n448 VSS 0.19499f
C2183 VDD.n449 VSS 0.14275f
C2184 VDD.n450 VSS 0.01437f
C2185 VDD.n451 VSS 0.01584f
C2186 VDD.n452 VSS 0.00426f
C2187 VDD.t110 VSS 0.00474f
C2188 VDD.t367 VSS 0.0046f
C2189 VDD.n453 VSS 0.00842f
C2190 VDD.t371 VSS 0.0046f
C2191 VDD.n454 VSS 0.00322f
C2192 VDD.n455 VSS 0.02283f
C2193 VDD.n456 VSS 0.0085f
C2194 VDD.n457 VSS 0.00426f
C2195 VDD.t117 VSS 0.00474f
C2196 VDD.t378 VSS 0.0046f
C2197 VDD.n458 VSS 0.00842f
C2198 VDD.t361 VSS 0.0046f
C2199 VDD.n459 VSS 0.00322f
C2200 VDD.n460 VSS 0.02283f
C2201 VDD.n461 VSS 0.0085f
C2202 VDD.t261 VSS 0.00474f
C2203 VDD.t372 VSS 0.0046f
C2204 VDD.n462 VSS 0.00842f
C2205 VDD.t355 VSS 0.0046f
C2206 VDD.n463 VSS 0.00322f
C2207 VDD.n464 VSS 0.01856f
C2208 VDD.n465 VSS 0.0085f
C2209 VDD.t265 VSS 0.00474f
C2210 VDD.t358 VSS 0.0046f
C2211 VDD.n466 VSS 0.00842f
C2212 VDD.t360 VSS 0.0046f
C2213 VDD.n467 VSS 0.00322f
C2214 VDD.n468 VSS 0.01088f
C2215 VDD.n469 VSS 0.01418f
C2216 VDD.n470 VSS 0.00505f
C2217 VDD.t263 VSS 0.00474f
C2218 VDD.t370 VSS 0.0046f
C2219 VDD.n471 VSS 0.00842f
C2220 VDD.t354 VSS 0.0046f
C2221 VDD.n472 VSS 0.00322f
C2222 VDD.n473 VSS 0.01856f
C2223 VDD.n474 VSS 0.0085f
C2224 VDD.t266 VSS 0.00474f
C2225 VDD.t364 VSS 0.0046f
C2226 VDD.n475 VSS 0.00842f
C2227 VDD.t359 VSS 0.0046f
C2228 VDD.n476 VSS 0.00322f
C2229 VDD.n477 VSS 0.01856f
C2230 VDD.t264 VSS 0.0043f
C2231 VDD.t356 VSS 0.00417f
C2232 VDD.n478 VSS 0.00842f
C2233 VDD.t381 VSS 0.00417f
C2234 VDD.n479 VSS 0.00605f
C2235 VDD.n480 VSS 0.02387f
C2236 VDD.t108 VSS 1.46885f
C2237 VDD.n481 VSS 0.1473f
C2238 VDD.n482 VSS 0.01081f
C2239 VDD.n483 VSS 0.00943f
C2240 VDD.n484 VSS 0.14275f
C2241 VDD.n485 VSS 0.10792f
C2242 VDD.n486 VSS 0.0082f
C2243 VDD.t146 VSS 0.00421f
C2244 VDD.n487 VSS 0.01053f
C2245 VDD.t163 VSS 0.00421f
C2246 VDD.n489 VSS 0.00734f
C2247 VDD.t166 VSS 0.00421f
C2248 VDD.t164 VSS 0.00421f
C2249 VDD.n490 VSS 0.01053f
C2250 VDD.n491 VSS 0.00538f
C2251 VDD.t162 VSS 0.00421f
C2252 VDD.n492 VSS 0.01053f
C2253 VDD.t33 VSS 2.70101f
C2254 VDD.n494 VSS 0.54903f
C2255 VDD.n495 VSS 0.00538f
C2256 VDD.n496 VSS 0.0082f
C2257 VDD.n497 VSS 0.10792f
C2258 VDD.n498 VSS 0.00907f
C2259 VDD.n499 VSS 0.23337f
C2260 VDD.n500 VSS 0.10276f
C2261 VDD.n502 VSS 0.10813f
C2262 VDD.t36 VSS 0.68302f
C2263 VDD.n504 VSS 0.54903f
C2264 VDD.t158 VSS 0.00421f
C2265 VDD.t272 VSS 0.00421f
C2266 VDD.n505 VSS 0.01048f
C2267 VDD.n506 VSS 0.00711f
C2268 VDD.n507 VSS 0.01053f
.ends

* Extracted by KLayout with SG13G2 LVS runset on : 28/03/2026 20:26

.SUBCKT 8xPI VSS VINQB VS[1] VINQ VINIB VS[0] VST[7] VINI VDD VST[6] VST[5]
+ VST[4] VOUT VST[3] VST[2] VST[1] VST[0]
X$1 VSS VDD VINQB VST[7] VS[1] VINQ \$5 VINIB VS[0] VINI MUX_4_1
X$2 VSS VDD VINQB VST[4] VS[1] VINQ \$5 VINIB VS[0] VINI MUX_4_1
X$3 VSS VDD VINQB VST[6] VS[1] VINQ \$5 VINIB VS[0] VINI MUX_4_1
X$4 VSS VDD VINQB VST[0] VS[1] VINQ \$5 VINIB VS[0] VINI MUX_4_1
X$5 VSS VDD VINQB VST[1] VS[1] VINQ \$5 VINIB VS[0] VINI MUX_4_1
X$6 VSS VDD VINQB VST[2] VS[1] VINQ \$5 VINIB VS[0] VINI MUX_4_1
X$7 VSS VDD VINQB VST[3] VS[1] VINQ \$5 VINIB VS[0] VINI MUX_4_1
X$8 VSS VDD VINQB VST[5] VS[1] VINQ \$5 VINIB VS[0] VINI MUX_4_1
X$9 VSS VDD \$44 \$5 inv_PI
X$10 VSS VDD \$44 VOUT buff_PI_d16
.ENDS 8xPI

.SUBCKT buff_PI_d16 VSS VDD VIN VOUT
X$1 VSS \$13 \$9 VDD inv_PI_d8
X$2 VSS VDD \$13 VOUT inv_PI_d16
X$3 VSS \$6 VDD \$9 inv_PI_d4
X$4 VIN VSS VDD \$6 inv_PI_d2
.ENDS buff_PI_d16

.SUBCKT MUX_4_1 VSS VDD VIND VST VS[1] VINC VOUT VINB VS[0] VINA
X$1 VSS VINB \$10 VS[0] VDD VINA MUX_2_1
X$2 VSS \$4 VOUT VST VDD \$10 MUX_2_1
X$3 VSS VIND \$4 VS[1] VDD VINC MUX_2_1
.ENDS MUX_4_1

.SUBCKT inv_PI_d16 VSS VDD VIN VOUT
X$1 VSS VOUT VIN VDD inv_PI_d8
X$2 VSS VOUT VIN VDD inv_PI_d8
.ENDS inv_PI_d16

.SUBCKT MUX_2_1 VSS VINB VOUT VS VDD VINA
X$1 VSS \$15 \$8 \$10 \$20 VDD tg_custom
X$2 VSS VDD \$10 tieh_custom
X$3 VSS \$15 \$14 VS \$20 VDD tg_custom
X$4 VSS VOUT \$10 \$8 \$15 VDD tg_custom
X$5 VSS \$15 \$14 VS \$20 VDD tg_custom
X$6 VSS VDD \$20 VINA inv_PI
X$7 VDD VS VSS \$14 inv
X$8 VSS \$5 \$8 \$10 \$9 VDD tg_custom
X$9 VSS VDD \$8 tiel_custom
X$10 VSS VDD \$9 VINB inv_PI
X$11 VSS \$5 VS \$14 \$9 VDD tg_custom
X$12 VSS VOUT \$10 \$8 \$5 VDD tg_custom
X$13 VSS \$5 \$8 \$10 \$9 VDD tg_custom
.ENDS MUX_2_1

.SUBCKT inv_PI_d8 VSS VOUT VIN VDD
X$1 VSS VIN VDD VOUT inv_PI_d4
X$2 VSS VIN VDD VOUT inv_PI_d4
.ENDS inv_PI_d8

.SUBCKT tieh_custom VSS VDD VOUT
M$1 VSS \$3 \$3 VSS sg13_lv_nmos L=0.13u W=0.15u AS=0.1005p AD=0.1005p PS=1.34u
+ PD=1.34u
M$2 VDD \$3 VOUT VDD sg13_lv_pmos L=0.13u W=0.15u AS=0.1005p AD=0.1005p
+ PS=1.34u PD=1.34u
.ENDS tieh_custom

.SUBCKT tiel_custom VSS VDD VOUT
M$1 VDD \$3 \$3 VDD sg13_lv_pmos L=0.13u W=0.15u AS=0.1005p AD=0.1005p PS=1.34u
+ PD=1.34u
M$2 VSS \$3 VOUT VSS sg13_lv_nmos L=0.13u W=0.15u AS=0.1005p AD=0.1005p
+ PS=1.34u PD=1.34u
.ENDS tiel_custom

.SUBCKT tg_custom VBN VOUT VSN VSP VIN VBP
M$1 VIN VSN VOUT VBN sg13_lv_nmos L=0.13u W=0.15u AS=0.1005p AD=0.1005p
+ PS=1.34u PD=1.34u
M$2 VIN VSP VOUT VBP sg13_lv_pmos L=0.13u W=0.3u AS=0.156p AD=0.156p PS=2.08u
+ PD=2.08u
.ENDS tg_custom

.SUBCKT inv VDD VIN VSS VOUT
M$1 VSS VIN VOUT VSS sg13_lv_nmos L=0.13u W=0.15u AS=0.1005p AD=0.1005p
+ PS=1.34u PD=1.34u
M$2 VDD VIN VOUT VDD sg13_lv_pmos L=0.13u W=0.15u AS=0.1005p AD=0.1005p
+ PS=1.34u PD=1.34u
.ENDS inv

.SUBCKT inv_PI_d4 VSS VIN VDD VOUT
X$1 VIN VSS VDD VOUT inv_PI_d2
X$2 VIN VSS VDD VOUT inv_PI_d2
.ENDS inv_PI_d4

.SUBCKT inv_PI_d2 VIN VSS VDD VOUT
X$1 VSS VDD VOUT VIN inv_PI
X$2 VSS VDD VOUT VIN inv_PI
.ENDS inv_PI_d2

.SUBCKT inv_PI VSS VDD VOUT VIN
M$1 VSS VIN VOUT VSS sg13_lv_nmos L=0.13u W=0.3u AS=0.156p AD=0.156p PS=2.08u
+ PD=2.08u
M$3 VDD VIN VOUT VDD sg13_lv_pmos L=0.13u W=0.45u AS=0.2115p AD=0.2115p
+ PS=2.82u PD=2.82u
.ENDS inv_PI

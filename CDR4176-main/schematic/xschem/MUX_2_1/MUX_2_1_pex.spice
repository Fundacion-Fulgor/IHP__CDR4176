* NGSPICE file created from MUX_2_1.ext - technology: ihp-sg13g2

.subckt MUX_2_1_pex VDD VINA VOUT VS VINB VSS
X0 inv_PI_0.VOUT VINA.t0 VDD.t10 VDD.t0 sg13_lv_pmos ad=55.5f pd=0.74u as=0.1005p ps=1.34u w=0.15u l=0.13u
X1 VOUT.t3 tg_custom_6.VSN.t1 tg_custom_2.VOUT VDD.t0 sg13_lv_pmos ad=55.5f pd=0.74u as=0.1005p ps=1.34u w=0.15u l=0.13u
X2 a_4858_280# a_4858_280# VDD.t3 VDD.t1 sg13_lv_pmos ad=0.1005p pd=1.34u as=0.1005p ps=1.34u w=0.15u l=0.13u
X3 VOUT.t1 tg_custom_6.VSP.t1 tg_custom_6.VOUT VSS.t1 sg13_lv_nmos ad=0.1005p pd=1.34u as=0.1005p ps=1.34u w=0.15u l=0.13u
X4 tg_custom_4.VSP VS.t0 VSS.t4 VSS.t3 sg13_lv_nmos ad=0.1005p pd=1.34u as=0.1005p ps=1.34u w=0.15u l=0.13u
X5 tg_custom_2.VOUT tg_custom_4.VSP inv_PI_0.VOUT VSS.t12 sg13_lv_nmos ad=0.1005p pd=1.34u as=0.1005p ps=1.34u w=0.15u l=0.13u
X6 inv_PI_0.VOUT VINA.t0 VDD.t8 VDD.t0 sg13_lv_pmos ad=0.1005p pd=1.34u as=55.5f ps=0.74u w=0.15u l=0.13u
X7 tg_custom_6.VOUT tg_custom_6.VSP.t2 inv_PI_1.VOUT VDD.t1 sg13_lv_pmos ad=55.5f pd=0.74u as=0.1005p ps=1.34u w=0.15u l=0.13u
X8 tg_custom_6.VOUT tg_custom_6.VSN.t2 inv_PI_1.VOUT VSS.t21 sg13_lv_nmos ad=0.1005p pd=1.34u as=0.1005p ps=1.34u w=0.15u l=0.13u
X9 inv_PI_0.VOUT VS.t1 tg_custom_2.VOUT VDD.t0 sg13_lv_pmos ad=0.1005p pd=1.34u as=55.5f ps=0.74u w=0.15u l=0.13u
X10 inv_PI_1.VOUT VINB.t0 VSS.t10 VSS.t9 sg13_lv_nmos ad=55.5f pd=0.74u as=0.1005p ps=1.34u w=0.15u l=0.13u
X11 tg_custom_6.VOUT tg_custom_4.VSP inv_PI_1.VOUT VDD.t1 sg13_lv_pmos ad=55.5f pd=0.74u as=0.1005p ps=1.34u w=0.15u l=0.13u
X12 tg_custom_2.VOUT VS.t2 inv_PI_0.VOUT VDD.t0 sg13_lv_pmos ad=55.5f pd=0.74u as=0.1005p ps=1.34u w=0.15u l=0.13u
X13 inv_PI_1.VOUT tg_custom_6.VSP.t2 tg_custom_6.VOUT VDD.t1 sg13_lv_pmos ad=0.1005p pd=1.34u as=55.5f ps=0.74u w=0.15u l=0.13u
X14 a_4858_981# a_4858_981# VSS.t14 VSS.t13 sg13_lv_nmos ad=0.1005p pd=1.34u as=0.1005p ps=1.34u w=0.15u l=0.13u
X15 inv_PI_0.VOUT VINA.t0 VSS.t18 VSS.t17 sg13_lv_nmos ad=55.5f pd=0.74u as=0.1005p ps=1.34u w=0.15u l=0.13u
X16 VSS.t8 VINB.t0 inv_PI_1.VOUT VSS.t7 sg13_lv_nmos ad=0.1005p pd=1.34u as=55.5f ps=0.74u w=0.15u l=0.13u
X17 tg_custom_2.VOUT tg_custom_6.VSN.t3 inv_PI_0.VOUT VSS.t20 sg13_lv_nmos ad=0.1005p pd=1.34u as=0.1005p ps=1.34u w=0.15u l=0.13u
X18 inv_PI_1.VOUT tg_custom_4.VSP tg_custom_6.VOUT VDD.t1 sg13_lv_pmos ad=0.1005p pd=1.34u as=55.5f ps=0.74u w=0.15u l=0.13u
X19 VOUT.t2 tg_custom_6.VSN.t4 tg_custom_6.VOUT VDD.t1 sg13_lv_pmos ad=55.5f pd=0.74u as=0.1005p ps=1.34u w=0.15u l=0.13u
X20 tg_custom_4.VSP VS.t0 VDD.t2 VDD.t0 sg13_lv_pmos ad=0.1005p pd=1.34u as=0.1005p ps=1.34u w=0.15u l=0.13u
X21 tg_custom_2.VOUT VS.t1 inv_PI_0.VOUT VDD.t0 sg13_lv_pmos ad=55.5f pd=0.74u as=0.1005p ps=1.34u w=0.15u l=0.13u
X22 inv_PI_1.VOUT VINB.t0 VDD.t6 VDD.t1 sg13_lv_pmos ad=55.5f pd=0.74u as=0.1005p ps=1.34u w=0.15u l=0.13u
X23 inv_PI_0.VOUT tg_custom_6.VSP.t3 tg_custom_2.VOUT VDD.t0 sg13_lv_pmos ad=0.1005p pd=1.34u as=55.5f ps=0.74u w=0.15u l=0.13u
X24 tg_custom_6.VOUT tg_custom_6.VSP.t4 inv_PI_1.VOUT VDD.t1 sg13_lv_pmos ad=55.5f pd=0.74u as=0.1005p ps=1.34u w=0.15u l=0.13u
X25 tg_custom_6.VOUT tg_custom_6.VSN.t4 VOUT.t2 VDD.t1 sg13_lv_pmos ad=0.1005p pd=1.34u as=55.5f ps=0.74u w=0.15u l=0.13u
X26 VDD.t4 VINB.t0 inv_PI_1.VOUT VDD.t1 sg13_lv_pmos ad=55.5f pd=0.74u as=55.5f ps=0.74u w=0.15u l=0.13u
X27 VOUT.t0 tg_custom_6.VSP.t5 tg_custom_2.VOUT VSS.t0 sg13_lv_nmos ad=0.1005p pd=1.34u as=0.1005p ps=1.34u w=0.15u l=0.13u
X28 tg_custom_6.VSN.t0 a_4858_280# VSS.t6 VSS.t5 sg13_lv_nmos ad=0.1005p pd=1.34u as=0.1005p ps=1.34u w=0.15u l=0.13u
X29 inv_PI_1.VOUT tg_custom_6.VSP.t4 tg_custom_6.VOUT VDD.t1 sg13_lv_pmos ad=0.1005p pd=1.34u as=55.5f ps=0.74u w=0.15u l=0.13u
X30 VDD.t8 VINA.t0 inv_PI_0.VOUT VDD.t0 sg13_lv_pmos ad=55.5f pd=0.74u as=55.5f ps=0.74u w=0.15u l=0.13u
X31 inv_PI_0.VOUT VS.t2 tg_custom_2.VOUT VDD.t0 sg13_lv_pmos ad=0.1005p pd=1.34u as=55.5f ps=0.74u w=0.15u l=0.13u
X32 tg_custom_6.VSP.t0 a_4858_981# VDD.t7 VDD.t0 sg13_lv_pmos ad=0.1005p pd=1.34u as=0.1005p ps=1.34u w=0.15u l=0.13u
X33 tg_custom_2.VOUT tg_custom_6.VSN.t1 VOUT.t3 VDD.t0 sg13_lv_pmos ad=0.1005p pd=1.34u as=55.5f ps=0.74u w=0.15u l=0.13u
X34 tg_custom_6.VOUT tg_custom_6.VSN.t5 inv_PI_1.VOUT VSS.t19 sg13_lv_nmos ad=0.1005p pd=1.34u as=0.1005p ps=1.34u w=0.15u l=0.13u
X35 VSS.t16 VINA.t0 inv_PI_0.VOUT VSS.t15 sg13_lv_nmos ad=0.1005p pd=1.34u as=55.5f ps=0.74u w=0.15u l=0.13u
X36 inv_PI_1.VOUT VINB.t0 VDD.t4 VDD.t1 sg13_lv_pmos ad=0.1005p pd=1.34u as=55.5f ps=0.74u w=0.15u l=0.13u
X37 tg_custom_2.VOUT tg_custom_6.VSP.t3 inv_PI_0.VOUT VDD.t0 sg13_lv_pmos ad=55.5f pd=0.74u as=0.1005p ps=1.34u w=0.15u l=0.13u
X38 tg_custom_6.VOUT VS.t3 inv_PI_1.VOUT VSS.t2 sg13_lv_nmos ad=0.1005p pd=1.34u as=0.1005p ps=1.34u w=0.15u l=0.13u
X39 tg_custom_2.VOUT tg_custom_4.VSP inv_PI_0.VOUT VSS.t11 sg13_lv_nmos ad=0.1005p pd=1.34u as=0.1005p ps=1.34u w=0.15u l=0.13u
R0 VINA.n0 VINA.t0 15.0005
R1 VINA.n0 VINA 9.52166
R2 VINA VINA.n0 0.0225
R3 VDD.n26 VDD.t2 17.3167
R4 VDD.n25 VDD.t10 17.3167
R5 VDD.n9 VDD.t8 17.3167
R6 VDD.n4 VDD.t7 17.3167
R7 VDD.n19 VDD.t3 17.3167
R8 VDD.n10 VDD.t4 17.3167
R9 VDD.n11 VDD.t6 17.3167
R10 VDD.n22 VDD.n15 17.0005
R11 VDD.n22 VDD.n17 17.0005
R12 VDD.n22 VDD.n13 17.0005
R13 VDD.n28 VDD.n7 17.0005
R14 VDD.n28 VDD.n2 17.0005
R15 VDD.n28 VDD 17.0005
R16 VDD.n28 VDD.n1 17.0005
R17 VDD.n23 VDD.n22 8.47207
R18 VDD.n22 VDD.n16 8.47207
R19 VDD.n22 VDD.n14 8.47207
R20 VDD.n22 VDD.n18 8.47207
R21 VDD.n22 VDD.n20 8.47207
R22 VDD.n22 VDD.n12 8.47207
R23 VDD.n28 VDD.n6 8.47207
R24 VDD.n29 VDD.n28 8.47207
R25 VDD.n28 VDD.n3 8.47207
R26 VDD.n28 VDD.n5 8.47207
R27 VDD.n28 VDD.n0 8.47207
R28 VDD.n28 VDD.n8 8.47207
R29 VDD.n28 VDD.n24 8.47207
R30 VDD.n28 VDD.n27 8.47207
R31 VDD.n22 VDD.n21 5.6548
R32 VDD.n22 VDD.t1 0.944944
R33 VDD.n28 VDD.t0 0.8505
R34 VDD.n21 VDD 0.171673
R35 VDD VDD.n12 0.152562
R36 VDD.n20 VDD 0.152562
R37 VDD VDD.n18 0.152562
R38 VDD VDD.n14 0.152562
R39 VDD.n16 VDD 0.152562
R40 VDD.n29 VDD 0.152562
R41 VDD VDD.n3 0.152562
R42 VDD.n5 VDD 0.152562
R43 VDD VDD.n0 0.152562
R44 VDD.n6 VDD 0.152562
R45 VDD.n8 VDD 0.152562
R46 VDD.n27 VDD 0.152562
R47 VDD VDD.n23 0.116914
R48 VDD.n24 VDD 0.116914
R49 VDD.n13 VDD 0.116611
R50 VDD VDD.n17 0.116611
R51 VDD.n15 VDD 0.116611
R52 VDD VDD.n2 0.116611
R53 VDD VDD.n1 0.116611
R54 VDD.n7 VDD 0.116611
R55 VDD VDD.n13 0.0942037
R56 VDD.n17 VDD 0.0942037
R57 VDD VDD.n15 0.0942037
R58 VDD.n11 VDD 0.0942037
R59 VDD.n2 VDD 0.0942037
R60 VDD VDD.n1 0.0942037
R61 VDD VDD.n7 0.0942037
R62 VDD VDD.n25 0.0942037
R63 VDD.n23 VDD.n11 0.058858
R64 VDD.n16 VDD.n10 0.058858
R65 VDD VDD.n14 0.058858
R66 VDD.n18 VDD 0.058858
R67 VDD.n20 VDD.n19 0.058858
R68 VDD VDD.n12 0.058858
R69 VDD.n5 VDD.n4 0.058858
R70 VDD.n9 VDD.n8 0.058858
R71 VDD.n25 VDD.n24 0.058858
R72 VDD.n27 VDD.n26 0.058858
R73 VDD VDD.n6 0.058858
R74 VDD VDD.n29 0.058858
R75 VDD VDD.n3 0.058858
R76 VDD VDD.n0 0.058858
R77 VDD VDD.n10 0.0585556
R78 VDD VDD.n9 0.0585556
R79 VDD.n21 VDD 0.0396158
R80 VDD.n4 VDD 0.00966667
R81 VDD.n19 VDD 0.00762963
R82 VDD.n26 VDD 0.00559259
R83 tg_custom_6.VSN.n1 tg_custom_6.VSN 36.9663
R84 tg_custom_6.VSN.n0 tg_custom_6.VSN 27.9685
R85 tg_custom_6.VSN.n2 tg_custom_6.VSN 27.0005
R86 tg_custom_6.VSN.n0 tg_custom_6.VSN 27.0005
R87 tg_custom_6.VSN.n3 tg_custom_6.VSN 18.6611
R88 tg_custom_6.VSN.n4 tg_custom_6.VSN.n3 18.3649
R89 tg_custom_6.VSN.n4 tg_custom_6.VSN.t0 17.0005
R90 tg_custom_6.VSN tg_custom_6.VSN.t2 15.0005
R91 tg_custom_6.VSN tg_custom_6.VSN.t4 15.0005
R92 tg_custom_6.VSN tg_custom_6.VSN.t3 15.0005
R93 tg_custom_6.VSN tg_custom_6.VSN.t1 15.0005
R94 tg_custom_6.VSN tg_custom_6.VSN.t5 15.0005
R95 tg_custom_6.VSN.n1 tg_custom_6.VSN.n0 10.0641
R96 tg_custom_6.VSN.n3 tg_custom_6.VSN.n2 9.8101
R97 tg_custom_6.VSN.n2 tg_custom_6.VSN.n1 9.0005
R98 tg_custom_6.VSN tg_custom_6.VSN.n4 0.0108125
R99 VOUT.n4 VOUT.n3 18.2997
R100 VOUT.n5 VOUT.n4 18.2987
R101 VOUT VOUT.t2 17.7739
R102 VOUT VOUT.t3 17.7739
R103 VOUT.n3 VOUT.t1 17.0005
R104 VOUT.n5 VOUT.t0 17.0005
R105 VOUT.n2 VOUT 0.3525
R106 VOUT.n6 VOUT 0.3525
R107 VOUT.n1 VOUT 0.162063
R108 VOUT.n0 VOUT 0.162063
R109 VOUT.n1 VOUT 0.15175
R110 VOUT.n0 VOUT 0.15175
R111 VOUT.n4 VOUT 0.112944
R112 VOUT.n3 VOUT.n1 0.0403276
R113 VOUT.n3 VOUT.n2 0.0403276
R114 VOUT.n5 VOUT.n0 0.0403276
R115 VOUT.n6 VOUT.n5 0.0403276
R116 VOUT.n2 VOUT 0.00998276
R117 VOUT VOUT.n6 0.00998276
R118 tg_custom_6.VSP.n0 tg_custom_6.VSP 64.0301
R119 tg_custom_6.VSP.n1 tg_custom_6.VSP 46.0301
R120 tg_custom_6.VSP.n3 tg_custom_6.VSP.n2 37.0641
R121 tg_custom_6.VSP tg_custom_6.VSP.t0 17.0177
R122 tg_custom_6.VSP tg_custom_6.VSP.t2 15.0005
R123 tg_custom_6.VSP tg_custom_6.VSP.t4 15.0005
R124 tg_custom_6.VSP tg_custom_6.VSP.t1 15.0005
R125 tg_custom_6.VSP tg_custom_6.VSP.t3 15.0005
R126 tg_custom_6.VSP tg_custom_6.VSP.t5 15.0005
R127 tg_custom_6.VSP.n2 tg_custom_6.VSP 9.66547
R128 tg_custom_6.VSP.n4 tg_custom_6.VSP.n3 9.53876
R129 tg_custom_6.VSP.n1 tg_custom_6.VSP 9.0005
R130 tg_custom_6.VSP.n0 tg_custom_6.VSP 9.0005
R131 tg_custom_6.VSP.n2 tg_custom_6.VSP.n1 0.7749
R132 tg_custom_6.VSP.n3 tg_custom_6.VSP.n0 0.7749
R133 tg_custom_6.VSP tg_custom_6.VSP.n4 0.1105
R134 tg_custom_6.VSP.n4 tg_custom_6.VSP 0.0726875
R135 tg_custom_6.VSP.n4 tg_custom_6.VSP 0.0555
R136 VSS.n44 VSS.n43 38114.4
R137 VSS.n5 VSS.t3 4853.62
R138 VSS.n47 VSS.n46 1465.2
R139 VSS.n55 VSS.n54 1465.2
R140 VSS.n53 VSS.n3 1465.2
R141 VSS.n45 VSS.n15 1448.82
R142 VSS.n12 VSS.n11 1448.82
R143 VSS.n30 VSS.n0 1374.14
R144 VSS.n42 VSS.n41 1365.97
R145 VSS.n37 VSS.n36 1365.97
R146 VSS.n35 VSS.n34 1365.97
R147 VSS.n40 VSS.n39 1349.63
R148 VSS.n33 VSS.n32 1349.63
R149 VSS.t1 VSS.n44 465.2
R150 VSS.n46 VSS.t21 465.2
R151 VSS.n54 VSS.t19 465.2
R152 VSS.t2 VSS.n3 465.2
R153 VSS.n5 VSS.t9 465.2
R154 VSS.n47 VSS.t1 448.82
R155 VSS.t21 VSS.n45 448.82
R156 VSS.t5 VSS.n15 448.82
R157 VSS.n55 VSS.t5 448.82
R158 VSS.t19 VSS.n53 448.82
R159 VSS.n12 VSS.t2 448.82
R160 VSS.n11 VSS.t7 448.82
R161 VSS.n4 VSS.t7 448.82
R162 VSS.t9 VSS.n4 448.82
R163 VSS.n43 VSS.t0 434.43
R164 VSS.n41 VSS.t20 434.43
R165 VSS.n36 VSS.t12 434.43
R166 VSS.n34 VSS.t11 434.43
R167 VSS.t17 VSS.n30 434.43
R168 VSS.t0 VSS.n42 418.094
R169 VSS.t20 VSS.n40 418.094
R170 VSS.n39 VSS.t13 418.094
R171 VSS.n37 VSS.t13 418.094
R172 VSS.t12 VSS.n35 418.094
R173 VSS.t11 VSS.n33 418.094
R174 VSS.n32 VSS.t15 418.094
R175 VSS.t15 VSS.n31 418.094
R176 VSS.n31 VSS.t17 418.094
R177 VSS.t3 VSS.n0 209.048
R178 VSS.n24 VSS.n14 27.4411
R179 VSS.n64 VSS.n63 27.4411
R180 VSS.n66 VSS.t16 17.3786
R181 VSS.n68 VSS.t18 17.3786
R182 VSS.n8 VSS.t8 17.3786
R183 VSS.n7 VSS.t10 17.3786
R184 VSS.n71 VSS.t4 17.3133
R185 VSS.n25 VSS.t14 17.3133
R186 VSS.n57 VSS.t6 17.3133
R187 VSS.n61 VSS.n12 17.0005
R188 VSS.n45 VSS.n16 17.0005
R189 VSS.n50 VSS.n16 17.0005
R190 VSS.n48 VSS.n47 17.0005
R191 VSS.n53 VSS.n13 17.0005
R192 VSS.n58 VSS.n13 17.0005
R193 VSS.n56 VSS.n52 17.0005
R194 VSS.n56 VSS.n15 17.0005
R195 VSS.n57 VSS.n56 17.0005
R196 VSS.n56 VSS.n55 17.0005
R197 VSS.n61 VSS.n60 17.0005
R198 VSS.n10 VSS.n4 17.0005
R199 VSS.n11 VSS.n10 17.0005
R200 VSS.n33 VSS.n2 17.0005
R201 VSS.n22 VSS.n18 17.0005
R202 VSS.n40 VSS.n18 17.0005
R203 VSS.n21 VSS.n18 17.0005
R204 VSS.n20 VSS.n18 17.0005
R205 VSS.n42 VSS.n17 17.0005
R206 VSS.n35 VSS.n29 17.0005
R207 VSS.n29 VSS.n28 17.0005
R208 VSS.n38 VSS.n23 17.0005
R209 VSS.n39 VSS.n38 17.0005
R210 VSS.n38 VSS.n25 17.0005
R211 VSS.n38 VSS.n37 17.0005
R212 VSS.n26 VSS.n2 17.0005
R213 VSS.n31 VSS.n1 17.0005
R214 VSS.n32 VSS.n1 17.0005
R215 VSS.n70 VSS.n0 16.9582
R216 VSS.n51 VSS.n16 8.45768
R217 VSS.n59 VSS.n13 8.45768
R218 VSS.n62 VSS.n61 8.45768
R219 VSS.n10 VSS.n6 8.45768
R220 VSS.n10 VSS.n9 8.45768
R221 VSS.n29 VSS.n27 8.45768
R222 VSS.n65 VSS.n2 8.45768
R223 VSS.n69 VSS.n1 8.45768
R224 VSS.n67 VSS.n1 8.45768
R225 VSS.n49 VSS.n48 5.63845
R226 VSS.n19 VSS.n17 5.63845
R227 VSS.n41 VSS.n18 0.333113
R228 VSS.n43 VSS.n17 0.333113
R229 VSS.n36 VSS.n29 0.333113
R230 VSS.n34 VSS.n2 0.333113
R231 VSS.n30 VSS.n1 0.333113
R232 VSS.n46 VSS.n16 0.311206
R233 VSS.n48 VSS.n44 0.311206
R234 VSS.n54 VSS.n13 0.311206
R235 VSS.n61 VSS.n3 0.311206
R236 VSS.n10 VSS.n5 0.311206
R237 VSS VSS.n49 0.267398
R238 VSS VSS.n19 0.267398
R239 VSS VSS.n51 0.228195
R240 VSS VSS.n59 0.228195
R241 VSS.n62 VSS 0.228195
R242 VSS.n6 VSS 0.228195
R243 VSS.n27 VSS 0.228195
R244 VSS VSS.n65 0.228195
R245 VSS VSS.n69 0.228195
R246 VSS.n70 VSS 0.228195
R247 VSS.n9 VSS 0.190001
R248 VSS VSS.n67 0.190001
R249 VSS VSS.n50 0.144111
R250 VSS VSS.n58 0.144111
R251 VSS.n60 VSS 0.144111
R252 VSS VSS.n20 0.144111
R253 VSS.n28 VSS 0.144111
R254 VSS.n26 VSS 0.144111
R255 VSS.n50 VSS 0.141056
R256 VSS.n52 VSS 0.141056
R257 VSS.n58 VSS 0.141056
R258 VSS.n60 VSS 0.141056
R259 VSS.n8 VSS 0.141056
R260 VSS.n20 VSS 0.141056
R261 VSS VSS.n22 0.141056
R262 VSS.n23 VSS 0.141056
R263 VSS.n28 VSS 0.141056
R264 VSS VSS.n26 0.141056
R265 VSS.n66 VSS 0.141056
R266 VSS.n51 VSS 0.118195
R267 VSS.n59 VSS 0.118195
R268 VSS VSS.n27 0.118195
R269 VSS VSS.n21 0.0998056
R270 VSS.n63 VSS.n62 0.0876395
R271 VSS.n9 VSS.n8 0.0876395
R272 VSS.n7 VSS.n6 0.0876395
R273 VSS.n65 VSS.n64 0.0876395
R274 VSS.n67 VSS.n66 0.0876395
R275 VSS.n69 VSS.n68 0.0876395
R276 VSS.n71 VSS.n70 0.0876395
R277 VSS.n52 VSS.n14 0.0875833
R278 VSS.n57 VSS.n14 0.0875833
R279 VSS.n24 VSS.n23 0.0875833
R280 VSS.n25 VSS.n24 0.0875833
R281 VSS.n49 VSS 0.079454
R282 VSS.n19 VSS 0.079454
R283 VSS.n22 VSS 0.0753611
R284 VSS VSS.n7 0.0723056
R285 VSS.n68 VSS 0.0723056
R286 VSS.n63 VSS 0.0310556
R287 VSS.n21 VSS 0.0310556
R288 VSS.n64 VSS 0.0310556
R289 VSS VSS.n71 0.0188333
R290 VSS VSS.n57 0.0127222
R291 VSS VSS.n25 0.00813889
R292 VS.n2 VS 49.0942
R293 VS VS.n3 27.9069
R294 VS.n3 VS 27.0005
R295 VS.n1 VS.n0 18.0005
R296 VS.n0 VS.t0 15.0005
R297 VS VS.t3 15.0005
R298 VS VS.t2 15.0005
R299 VS VS.t1 15.0005
R300 VS.n2 VS.n1 9.0005
R301 VS.n3 VS.n2 2.40396
R302 VS.n1 VS 0.173241
R303 VS.n0 VS 0.0151667
R304 VINB.n0 VINB.t0 15.0005
R305 VINB.n0 VINB 9.52166
R306 VINB VINB.n0 0.0225
C0 inv_PI_1.VOUT inv_PI_0.VOUT 0.01617f
C1 tg_custom_2.VOUT a_4972_875# -0
C2 VDD tg_custom_4.VSP 0.55836f
C3 VS VINA 0.23243f
C4 VDD tg_custom_6.VOUT 0.22934f
C5 VINA tg_custom_6.VSP 0
C6 tg_custom_6.VSN tg_custom_4.VSP 0.01556f
C7 tg_custom_6.VSN tg_custom_6.VOUT 0.45581f
C8 VOUT tg_custom_4.VSP 0.00102f
C9 tg_custom_6.VOUT VOUT 0.33029f
C10 a_4858_981# a_4858_280# 0.00234f
C11 inv_PI_0.VOUT VINA 0.19651f
C12 VINB tg_custom_4.VSP 0.02104f
C13 tg_custom_6.VOUT VINB 0.00439f
C14 tg_custom_6.VOUT a_5384_174# -0
C15 VS tg_custom_4.VSP 1.87291f
C16 tg_custom_6.VOUT VS 0.13017f
C17 inv_PI_1.VOUT a_4858_280# 0.06167f
C18 VDD tg_custom_2.VOUT 0.39413f
C19 tg_custom_4.VSP tg_custom_6.VSP 0.05928f
C20 tg_custom_6.VOUT tg_custom_6.VSP 0.26465f
C21 inv_PI_0.VOUT tg_custom_4.VSP 0.07155f
C22 a_4858_981# inv_PI_1.VOUT 0
C23 tg_custom_6.VSN tg_custom_2.VOUT 0.20859f
C24 tg_custom_2.VOUT VOUT 0.28725f
C25 a_4858_981# VINA 0
C26 tg_custom_4.VSP a_4262_875# -0
C27 tg_custom_6.VOUT a_4262_174# -0
C28 tg_custom_2.VOUT VS 0.07248f
C29 a_4972_875# tg_custom_6.VSP -0
C30 tg_custom_2.VOUT tg_custom_6.VSP 0.22974f
C31 a_4858_280# tg_custom_4.VSP 0
C32 tg_custom_6.VOUT a_4858_280# 0.01265f
C33 inv_PI_1.VOUT VINA 0
C34 tg_custom_2.VOUT inv_PI_0.VOUT 0.75631f
C35 VDD tg_custom_6.VSN 0.73163f
C36 VDD VOUT 0.12912f
C37 a_4858_981# tg_custom_4.VSP 0.0206f
C38 VDD VINB 0.24958f
C39 tg_custom_2.VOUT a_5384_875# -0
C40 tg_custom_6.VSN VOUT 0.2192f
C41 tg_custom_2.VOUT a_4262_875# -0
C42 tg_custom_6.VSN VINB 0
C43 VDD VS 0.78737f
C44 inv_PI_1.VOUT tg_custom_4.VSP 0.135f
C45 tg_custom_6.VOUT inv_PI_1.VOUT 0.72287f
C46 VDD tg_custom_6.VSP 0.87952f
C47 tg_custom_6.VSN VS 0.02795f
C48 VOUT VS 0
C49 VDD inv_PI_0.VOUT 0.93358f
C50 tg_custom_2.VOUT a_4858_280# 0
C51 a_4972_174# tg_custom_6.VOUT -0
C52 tg_custom_6.VSN tg_custom_6.VSP 2.89276f
C53 VOUT tg_custom_6.VSP 0.2174f
C54 VINA tg_custom_4.VSP 0.0755f
C55 VINB VS 0.03637f
C56 tg_custom_6.VSN inv_PI_0.VOUT 0.00842f
C57 a_4858_981# tg_custom_2.VOUT 0.01839f
C58 inv_PI_0.VOUT VOUT 0
C59 VINB tg_custom_6.VSP 0
C60 tg_custom_6.VSN a_5384_875# 0
C61 VS tg_custom_6.VSP 0.03234f
C62 inv_PI_0.VOUT VS 0.22088f
C63 tg_custom_2.VOUT inv_PI_1.VOUT 0.09498f
C64 VDD a_4858_280# 0.12323f
C65 inv_PI_0.VOUT tg_custom_6.VSP 0.3575f
C66 tg_custom_6.VOUT tg_custom_4.VSP 0.03404f
C67 VDD a_3850_875# 0
C68 tg_custom_6.VSN a_4858_280# 0.06063f
C69 VDD a_4858_981# 0.07757f
C70 tg_custom_2.VOUT VINA 0.00187f
C71 a_4858_280# VOUT 0
C72 tg_custom_6.VOUT a_4674_174# -0
C73 a_5384_875# tg_custom_6.VSP 0
C74 a_4858_981# tg_custom_6.VSN 0.00585f
C75 VINB a_4858_280# 0
C76 a_4858_981# VOUT 0
C77 a_4674_875# tg_custom_2.VOUT -0
C78 VDD inv_PI_1.VOUT 0.89671f
C79 a_4858_280# tg_custom_6.VSP 0.05112f
C80 a_4858_981# VS 0.02073f
C81 tg_custom_2.VOUT tg_custom_4.VSP 0.30207f
C82 tg_custom_6.VSN inv_PI_1.VOUT 0.08864f
C83 tg_custom_6.VOUT tg_custom_2.VOUT 0.01974f
C84 inv_PI_1.VOUT VOUT 0.00572f
C85 VDD VINA 0.35645f
C86 a_4858_981# tg_custom_6.VSP 0.05743f
C87 inv_PI_1.VOUT VINB 0.1844f
C88 a_4858_981# inv_PI_0.VOUT 0.04339f
C89 inv_PI_1.VOUT VS 0.05123f
C90 VINB VINA 0.02923f
C91 inv_PI_1.VOUT tg_custom_6.VSP 0.43913f
C92 VINB VSS 0.63943f
C93 VOUT VSS 0.42002f
C94 VINA VSS 0.51709f
C95 VS VSS 1.58586f
C96 VDD VSS 3.2979f
C97 a_5384_174# VSS 0.00838f $ **FLOATING
C98 a_4972_174# VSS 0.00838f $ **FLOATING
C99 a_4674_174# VSS 0.00838f $ **FLOATING
C100 a_4262_174# VSS 0.00838f $ **FLOATING
C101 a_3850_174# VSS 0.00838f $ **FLOATING
C102 a_4858_280# VSS 0.18812f
C103 tg_custom_6.VOUT VSS 1.08232f
C104 inv_PI_1.VOUT VSS 0.56123f
C105 a_5384_875# VSS 0.00838f $ **FLOATING
C106 a_4972_875# VSS 0.00838f $ **FLOATING
C107 a_4674_875# VSS 0.00838f $ **FLOATING
C108 a_4262_875# VSS 0.00838f $ **FLOATING
C109 a_3850_875# VSS 0.00838f $ **FLOATING
C110 a_3324_875# VSS 0.00838f $ **FLOATING
C111 tg_custom_6.VSN VSS 2.22261f
C112 a_4858_981# VSS 0.2261f
C113 tg_custom_6.VSP VSS 2.3216f
C114 tg_custom_2.VOUT VSS 0.89666f
C115 inv_PI_0.VOUT VSS 0.5584f
C116 tg_custom_4.VSP VSS 1.36255f
C117 tg_custom_6.VSP.t5 VSS 0.09525f
C118 tg_custom_6.VSP.t3 VSS 0.14332f
C119 tg_custom_6.VSP.n0 VSS 0.36498f
C120 tg_custom_6.VSP.t1 VSS 0.09525f
C121 tg_custom_6.VSP.t4 VSS 0.14332f
C122 tg_custom_6.VSP.n1 VSS 0.31369f
C123 tg_custom_6.VSP.t2 VSS 0.14332f
C124 tg_custom_6.VSP.n2 VSS 0.50184f
C125 tg_custom_6.VSP.n3 VSS 0.37065f
C126 tg_custom_6.VSP.t0 VSS 0.03832f
C127 tg_custom_6.VSP.n4 VSS 0.08022f
C128 tg_custom_6.VSN.t4 VSS 0.15308f
C129 tg_custom_6.VSN.t1 VSS 0.15308f
C130 tg_custom_6.VSN.t3 VSS 0.10174f
C131 tg_custom_6.VSN.n0 VSS 0.41657f
C132 tg_custom_6.VSN.n1 VSS 0.70493f
C133 tg_custom_6.VSN.t2 VSS 0.10174f
C134 tg_custom_6.VSN.n2 VSS 0.25684f
C135 tg_custom_6.VSN.t5 VSS 0.10174f
C136 tg_custom_6.VSN.n3 VSS 0.27094f
C137 tg_custom_6.VSN.t0 VSS 0.04092f
C138 tg_custom_6.VSN.n4 VSS 0.08418f
.ends

* Extracted by KLayout with SG13G2 LVS runset on : 28/03/2026 20:09

.SUBCKT 8xPI_top VBN|VSS PH270|VIN|VINB|VIND|VINQB|VOUT VIN|VOUT VIN|VOUT$1
+ SQ[1]|VIN|VOUT|VS|VSN|VSP|VS[1] VOUT|VSN|VSP VIN|VINB|VOUT VOUT|VSN|VSP$1
+ VOUT|VSN|VSP$2 VIN|VOUT$2 VIN|VOUT$3 VIN|VOUT$4
+ STQ[7]|VIN|VOUT|VS|VSN|VSP|VST|VST[7] VOUT|VSN|VSP$3
+ PH90|VIN|VINA|VINC|VINQ|VOUT VOUT|VSN|VSP$4 VOUT|VSN|VSP$5 VIN|VOUT$5
+ VIN|VOUT$6 VIN|VOUT$7 VIN|VINA|VOUT VIN|VOUT$8
+ SQ[0]|VIN|VOUT|VS|VSN|VSP|VS[0] VOUT|VSN|VSP$6 VOUT|VSN|VSP$7 VOUT|VSN|VSP$8
+ CLKN|VIN|VOUT|VOUTDP VIN|VOUT$9 VIN|VOUT$10 VIN|VOUT$11
+ PH0|PH3|V3|VIN|VOUT|VOUTDP VIN|VOUT$12 PH0|PH1|V1|VIN|VOUT|VOUTDN VIN|VOUT$13
+ PH0|PH1|PH5|V5|VIN|VOUT|VOUTDP VIN|VOUT$14 VIN|VOUT$15 CLKN|VIN|VOUT|VOUTDP$1
+ CLKN|VIN|VOUT|VOUTDP$2 VIN|VOUT$16 VIN|VOUT$17 VIN|VOUT$18 VIN|VOUT$19
+ VIN|VOUT$20 VIN|VOUT$21 VBP|VDD PH0|VIN|VINA|VINI|VOUT VIN|VOUT$22
+ VIN|VOUT$23 VIN|VOUT$24 VIN|VOUT$25 VIN|VOUT$26 VIN|VOUT$27 VIN|VOUT$28
+ VIN|VOUT$29 VIN|VOUT$30 VIN|VOUT$31 VIN|VINB|VOUT$1 VOUT|VSN|VSP$9
+ VOUT|VSN|VSP$10 VOUT|VSN|VSP$11 VIN|VOUT$32 VIN VIN$1 VIN$2 VIN$3 VIN$4 VIN$5
+ VIN|VOUT$33 VIN|VOUT$34 VIN|VOUT$35 VIN|VOUT$36
+ STQ[6]|VIN|VOUT|VS|VSN|VSP|VST|VST[6] VOUT|VSN|VSP$12 VOUT|VSN|VSP$13
+ VOUT|VSN|VSP$14 VIN|VOUT$37 VIN|VOUT$38 VOUT|VSN|VSP$15 VIN|VINA|VOUT$1
+ VIN|VOUT$39 VIN|VOUT$40 VOUT|VSN|VSP$16 VOUT|VSN|VSP$17 VIN|VOUT$41
+ CLKP|VIN|VOUT|VOUTDN VIN|VOUT$42 CLKP|VIN|VOUT|VOUTDN$1 VIN|VOUT$43
+ CLKP|VIN|VOUT|VOUTDN$2 VIN|VOUT$44 VIN|VOUT$45 VIN|VOUT$46 VIN|VOUT$47
+ VIN|VOUT$48 VIN|VOUT$49 VIN|VOUT$50 VIN|VOUT$51 PH0|PH1|V0|VIN|VOUT|VOUTDN
+ PH0|PH1|PH4|V4|VIN|VOUT|VOUTDP PH1|PH2|V2|VIN|VOUT|VOUTDN VIN|VOUT$52
+ VIN|VOUT$53 VIN|VOUT$54 VIN|VOUT$55 VIN|VOUT$56 VIN|VOUT$57 VIN|VOUT$58
+ VIN|VOUT$59 VIN|VOUT$60 VIN|VOUT$61 VIN|VINB|VOUT$2 VIN|VOUT$62
+ VOUT|VSN|VSP$18 CTRL|VCONT VOUT|VSN|VSP$19 VOUT|VSN|VSP$20 VIN|VOUT$63
+ VIN|VOUT$64 VIN|VOUT$65 VIN|VOUT$66 STQ[5]|VIN|VOUT|VS|VSN|VSP|VST|VST[5]
+ VOUT|VSN|VSP$21 VOUT|VSN|VSP$22 VOUT|VSN|VSP$23 VIN|VOUT$67 VIN|VOUT$68
+ VIN|VINA|VOUT$2 VIN|VOUT$69 VIN|VOUT$70 VOUT|VSN|VSP$24 VOUT|VSN|VSP$25
+ VOUT|VSN|VSP$26 PH180|VIN|VINB|VINIB|VOUT VIN|VOUT$71 VIN|VOUT$72 VIN|VOUT$73
+ VIN|VOUT$74 VOUT|VSN|VSP$27 VIN|VINB|VOUT$3 VIN|VOUT$75 VOUT|VSN|VSP$28
+ VOUT|VSN|VSP$29 VIN|VOUT$76 VIN|VOUT$77 VIN|VOUT$78
+ STQ[4]|VIN|VOUT|VS|VSN|VSP|VST|VST[4] VOUT|VSN|VSP$30 VOUT|VSN|VSP$31
+ VIN|VOUT$79 PH1|VIN|VOUT VIN|VOUT$80 VIN|VOUT$81 VIN|VOUT$82 VOUT|VSN|VSP$32
+ VIN|VOUT$83 VIN|VOUT$84 VIN|VOUT$85 VIN|VINA|VOUT$3 VIN|VOUT$86 VIN|VOUT$87
+ VIN|VOUT$88 VOUT|VSN|VSP$33 VOUT|VSN|VSP$34 VOUT|VSN|VSP$35 VIN|VOUT$89
+ VIN|VOUT$90 VIN|VOUT$91 VIN|VOUT$92 VOUT VIN|VOUT$93 VIN|VOUT$94 VIN|VOUT$95
+ VIN|VOUT$96 VIN|VOUT$97 VIN|VINB|VOUT$4 VOUT|VSN|VSP$36 VOUT|VSN|VSP$37
+ PH0|VIN|VOUT VOUT|VSN|VSP$38 VIN|VOUT$98 VIN|VOUT$99 VIN|VOUT$100
+ VIN|VOUT$101 VIN|VOUT$102 VIN|VOUT$103 VIN|VOUT$104 VIN|VOUT$105
+ STQ[3]|VIN|VOUT|VS|VSN|VSP|VST|VST[3] VOUT|VSN|VSP$39 VOUT|VSN|VSP$40
+ VOUT|VSN|VSP$41 VIN|VOUT$106 VIN|VINA|VOUT$4 VIN|VOUT$107 VIN|VOUT$108
+ VOUT|VSN|VSP$42 VIN|VOUT$109 VIN|VOUT$110 VOUT|VSN|VSP$43 VOUT|VSN|VSP$44
+ VIN|VOUT$111 VIN|VOUT$112 VIN|VOUT$113 VIN|VOUT$114 VIN|VOUT$115
+ VIN|VINB|VOUT$5 VIN|VOUT$116 VIN|VOUT$117 VOUT|VSN|VSP$45 VOUT|VSN|VSP$46
+ VOUT|VSN|VSP$47 VOUT|VSN|VSS A|S[4]|VIN|VOUT|VS[4] B|S[3]|VDD|VIN|VSP|VS[3]
+ VIN|VOUT$118 VIN|VOUT$119 VIN|VOUT$120 VIN|VOUT$121 VIN|VOUT$122 VIN|VOUT$123
+ VIN|VOUT$124 STQ[2]|VIN|VOUT|VS|VSN|VSP|VST|VST[2] VOUT|VSN|VSP$48
+ VOUT|VSN|VSP$49 VOUT|VSN|VSP$50 VIN|VOUT$125 VIN|VINA|VOUT$5 VIN|VOUT$126
+ VIN|VOUT$127 VIN|VOUT$128 VOUT|VSN|VSP$51 VIN|VOUT$129 VOUT|VSN|VSP$52
+ VOUT|VSN|VSP$53 VIN|VOUT$130 VOUT|VSN|VSS$1 VIN|VOUT$131
+ B|OUT|ST[7]|VDD|VIN|VSP A|VIN|VOUT VIN|VOUT$132 VIN|VOUT$133 VIN|VOUT$134
+ VIN|VOUT$135 VIN|VOUT$136 VOUT|VSN|VSS$2 A|VIN|VOUT$1 B|OUT|ST[6]|VDD|VIN|VSP
+ VIN|VOUT$137 PH1|PHOUT|VIN|VOUT VIN|VOUT$138 VIN|VINB|VOUT$6 VIN|VOUT$139
+ VOUT|VSN|VSP$54 VOUT|VSN|VSP$55 PH0|PHOUT|VIN|VOUT VOUT|VSN|VSP$56
+ VIN|VOUT$140 VIN|VOUT$141 VIN|VOUT$142 VOUT|VSN|VSS$3 B|OUT|ST[5]|VDD|VIN|VSP
+ A|VIN|VOUT$2 VIN|VOUT$143 VIN|VOUT$144 VIN|VOUT$145 VIN|VOUT$146 VIN|VOUT$147
+ VIN|VOUT$148 VIN|VOUT$149 VIN|VOUT$150 STQ[1]|VIN|VOUT|VS|VSN|VSP|VST|VST[1]
+ VOUT|VSN|VSP$57 VOUT|VSN|VSP$58 VOUT|VSN|VSP$59 B|ST[4]|VDD|VIN|VOUT|VSP
+ VOUT|VSN|VSS$4 A|VIN|VOUT$3 VIN|VOUT$151 VIN|VOUT$152 VIN|VINA|VOUT$6
+ VIN|VOUT$153 VIN|VOUT$154 VOUT|VSN|VSP$60 VOUT|VSN|VSP$61 VIN|VOUT$155
+ VIN|VOUT$156 VOUT|VSN|VSP$62 VOUT|VSN|VSS$5 A|VIN|VOUT$4
+ B|OUT|ST[3]|VDD|VIN|VSP VIN|VOUT$157 VIN|VOUT$158 VIN|VOUT$159
+ B|OUT|ST[2]|VDD|VIN|VSP B|OUT|ST[1]|VDD|VIN|VSP VOUT|VSN|VSS$6 A|VIN|VOUT$5
+ A|OUT|VOUT VIN|VOUT$160 A|B|VOUT A|B|VOUT$1 B|C|VIN|VOUT VIN|VOUT$161
+ A|OUT|VOUT$1 VIN|VOUT$162 VOUT|VSN|VSP$63 VIN|VINB|VOUT$7 VOUT|VSN|VSP$64
+ VOUT|VSN|VSP$65 VOUT|VSN|VSS$7 A|VIN|VOUT$6 VIN|VOUT$163 OUT|VIN OUT|VIN$1
+ VIN|VOUT$164 VIN|VOUT$165 VIN|VOUT$166 SQ[2]|VIN|VOUT|VS|VSN|VSP|VST|VST[0]
+ VOUT|VSN|VSP$66 VOUT|VSN|VSP$67 VOUT|VSN|VSP$68 VIN|VOUT$167 VIN|VOUT$168
+ VIN|VINA|VOUT$7 VIN|VOUT$169 VIN|VOUT$170 VOUT|VSN|VSP$69 VOUT|VSN|VSP$70
+ VOUT|VSN|VSP$71 S[2]|VIN|VS[2] S[1]|VIN|VS[1] S[0]|VIN|VS[0] VIN|VOUT$171
+ VIN|VOUT$172 VIN|VOUT$173
M$1 VBN|VSS PH270|VIN|VINB|VIND|VINQB|VOUT VIN|VOUT VBN|VSS sg13_lv_nmos
+ L=0.13u W=0.3u AS=0.156p AD=0.156p PS=2.08u PD=2.08u
M$3 VIN|VOUT SQ[1]|VIN|VOUT|VS|VSN|VSP|VS[1] VIN|VOUT$1 VBN|VSS sg13_lv_nmos
+ L=0.13u W=0.15u AS=0.1005p AD=0.1005p PS=1.34u PD=1.34u
M$4 VIN|VOUT VOUT|VSN|VSP VIN|VOUT$1 VBN|VSS sg13_lv_nmos L=0.13u W=0.3u
+ AS=0.201p AD=0.201p PS=2.68u PD=2.68u
M$5 VBN|VSS \$16 VOUT|VSN|VSP VBN|VSS sg13_lv_nmos L=0.13u W=0.15u AS=0.1005p
+ AD=0.1005p PS=1.34u PD=1.34u
M$7 VIN|VOUT$1 VOUT|VSN|VSP$2 VIN|VINB|VOUT VBN|VSS sg13_lv_nmos L=0.13u
+ W=0.15u AS=0.1005p AD=0.1005p PS=1.34u PD=1.34u
M$8 VBN|VSS SQ[1]|VIN|VOUT|VS|VSN|VSP|VS[1] VOUT|VSN|VSP$1 VBN|VSS sg13_lv_nmos
+ L=0.13u W=0.15u AS=0.1005p AD=0.1005p PS=1.34u PD=1.34u
M$9 VBN|VSS PH90|VIN|VINA|VINC|VINQ|VOUT VIN|VOUT$5 VBN|VSS sg13_lv_nmos
+ L=0.13u W=0.3u AS=0.156p AD=0.156p PS=2.08u PD=2.08u
M$11 VIN|VOUT$5 VOUT|VSN|VSP$1 VIN|VOUT$2 VBN|VSS sg13_lv_nmos L=0.13u W=0.3u
+ AS=0.201p AD=0.201p PS=2.68u PD=2.68u
M$13 VBN|VSS \$24 \$24 VBN|VSS sg13_lv_nmos L=0.13u W=0.15u AS=0.1005p
+ AD=0.1005p PS=1.34u PD=1.34u
M$14 VIN|VOUT$5 VOUT|VSN|VSP VIN|VOUT$2 VBN|VSS sg13_lv_nmos L=0.13u W=0.15u
+ AS=0.1005p AD=0.1005p PS=1.34u PD=1.34u
M$15 VIN|VOUT$2 VOUT|VSN|VSP$2 VIN|VINB|VOUT VBN|VSS sg13_lv_nmos L=0.13u
+ W=0.15u AS=0.1005p AD=0.1005p PS=1.34u PD=1.34u
M$16 VBN|VSS VIN|VINB|VOUT VIN|VOUT$6 VBN|VSS sg13_lv_nmos L=0.13u W=0.3u
+ AS=0.156p AD=0.156p PS=2.08u PD=2.08u
M$18 VIN|VOUT$6 STQ[7]|VIN|VOUT|VS|VSN|VSP|VST|VST[7] VIN|VOUT$3 VBN|VSS
+ sg13_lv_nmos L=0.13u W=0.15u AS=0.1005p AD=0.1005p PS=1.34u PD=1.34u
M$19 VIN|VOUT$6 VOUT|VSN|VSP$3 VIN|VOUT$3 VBN|VSS sg13_lv_nmos L=0.13u W=0.3u
+ AS=0.201p AD=0.201p PS=2.68u PD=2.68u
M$20 VBN|VSS \$50 VOUT|VSN|VSP$3 VBN|VSS sg13_lv_nmos L=0.13u W=0.15u
+ AS=0.1005p AD=0.1005p PS=1.34u PD=1.34u
M$22 VIN|VOUT$3 VOUT|VSN|VSP$5 VIN|VOUT$4 VBN|VSS sg13_lv_nmos L=0.13u W=0.15u
+ AS=0.1005p AD=0.1005p PS=1.34u PD=1.34u
M$23 VBN|VSS PH180|VIN|VINB|VINIB|VOUT VIN|VOUT$9 VBN|VSS sg13_lv_nmos L=0.13u
+ W=0.3u AS=0.156p AD=0.156p PS=2.08u PD=2.08u
M$25 VIN|VOUT$9 SQ[0]|VIN|VOUT|VS|VSN|VSP|VS[0] VIN|VOUT$7 VBN|VSS sg13_lv_nmos
+ L=0.13u W=0.15u AS=0.1005p AD=0.1005p PS=1.34u PD=1.34u
M$26 VIN|VOUT$9 VOUT|VSN|VSP$6 VIN|VOUT$7 VBN|VSS sg13_lv_nmos L=0.13u W=0.3u
+ AS=0.201p AD=0.201p PS=2.68u PD=2.68u
M$27 VBN|VSS \$97 VOUT|VSN|VSP$6 VBN|VSS sg13_lv_nmos L=0.13u W=0.15u
+ AS=0.1005p AD=0.1005p PS=1.34u PD=1.34u
M$29 VIN|VOUT$7 VOUT|VSN|VSP$8 VIN|VINA|VOUT VBN|VSS sg13_lv_nmos L=0.13u
+ W=0.15u AS=0.1005p AD=0.1005p PS=1.34u PD=1.34u
M$30 VBN|VSS STQ[7]|VIN|VOUT|VS|VSN|VSP|VST|VST[7] VOUT|VSN|VSP$4 VBN|VSS
+ sg13_lv_nmos L=0.13u W=0.15u AS=0.1005p AD=0.1005p PS=1.34u PD=1.34u
M$31 VBN|VSS VIN|VINA|VOUT VIN|VOUT$10 VBN|VSS sg13_lv_nmos L=0.13u W=0.3u
+ AS=0.156p AD=0.156p PS=2.08u PD=2.08u
M$33 VIN|VOUT$10 VOUT|VSN|VSP$4 VIN|VOUT$8 VBN|VSS sg13_lv_nmos L=0.13u W=0.3u
+ AS=0.201p AD=0.201p PS=2.68u PD=2.68u
M$35 VBN|VSS \$74 \$74 VBN|VSS sg13_lv_nmos L=0.13u W=0.15u AS=0.1005p
+ AD=0.1005p PS=1.34u PD=1.34u
M$36 VIN|VOUT$10 VOUT|VSN|VSP$3 VIN|VOUT$8 VBN|VSS sg13_lv_nmos L=0.13u W=0.15u
+ AS=0.1005p AD=0.1005p PS=1.34u PD=1.34u
M$37 VIN|VOUT$8 VOUT|VSN|VSP$5 VIN|VOUT$4 VBN|VSS sg13_lv_nmos L=0.13u W=0.15u
+ AS=0.1005p AD=0.1005p PS=1.34u PD=1.34u
M$38 VBN|VSS CLKN|VIN|VOUT|VOUTDP VIN|VOUT$11 VBN|VSS sg13_lv_nmos L=0.13u
+ W=0.15u AS=0.1005p AD=0.1005p PS=1.34u PD=1.34u
M$39 VBN|VSS VIN|VOUT$11 VIN|VOUT$14 VBN|VSS sg13_lv_nmos L=0.13u W=0.3u
+ AS=0.156p AD=0.156p PS=2.08u PD=2.08u
M$41 VBN|VSS VIN|VOUT$14 VIN|VOUT$15 VBN|VSS sg13_lv_nmos L=0.13u W=0.6u
+ AS=0.312p AD=0.312p PS=4.16u PD=4.16u
M$45 VBN|VSS VIN|VOUT$15 PH0|PH3|V3|VIN|VOUT|VOUTDP VBN|VSS sg13_lv_nmos
+ L=0.13u W=1.2u AS=0.624p AD=0.624p PS=8.32u PD=8.32u
M$53 VBN|VSS CLKN|VIN|VOUT|VOUTDP$2 VIN|VOUT$12 VBN|VSS sg13_lv_nmos L=0.13u
+ W=0.15u AS=0.1005p AD=0.1005p PS=1.34u PD=1.34u
M$54 VBN|VSS VIN|VOUT$12 VIN|VOUT$16 VBN|VSS sg13_lv_nmos L=0.13u W=0.3u
+ AS=0.156p AD=0.156p PS=2.08u PD=2.08u
M$56 VBN|VSS VIN|VOUT$16 VIN|VOUT$17 VBN|VSS sg13_lv_nmos L=0.13u W=0.6u
+ AS=0.312p AD=0.312p PS=4.16u PD=4.16u
M$60 VBN|VSS VIN|VOUT$17 PH0|PH1|V1|VIN|VOUT|VOUTDN VBN|VSS sg13_lv_nmos
+ L=0.13u W=1.2u AS=0.624p AD=0.624p PS=8.32u PD=8.32u
M$68 VBN|VSS CLKN|VIN|VOUT|VOUTDP$1 VIN|VOUT$13 VBN|VSS sg13_lv_nmos L=0.13u
+ W=0.15u AS=0.1005p AD=0.1005p PS=1.34u PD=1.34u
M$69 VBN|VSS VIN|VOUT$13 VIN|VOUT$18 VBN|VSS sg13_lv_nmos L=0.13u W=0.3u
+ AS=0.156p AD=0.156p PS=2.08u PD=2.08u
M$71 VBN|VSS VIN|VOUT$18 VIN|VOUT$19 VBN|VSS sg13_lv_nmos L=0.13u W=0.6u
+ AS=0.312p AD=0.312p PS=4.16u PD=4.16u
M$75 VBN|VSS VIN|VOUT$19 PH0|PH1|PH5|V5|VIN|VOUT|VOUTDP VBN|VSS sg13_lv_nmos
+ L=0.13u W=1.2u AS=0.624p AD=0.624p PS=8.32u PD=8.32u
M$83 VBN|VSS SQ[0]|VIN|VOUT|VS|VSN|VSP|VS[0] VOUT|VSN|VSP$7 VBN|VSS
+ sg13_lv_nmos L=0.13u W=0.15u AS=0.1005p AD=0.1005p PS=1.34u PD=1.34u
M$84 VBN|VSS PH0|VIN|VINA|VINI|VOUT VIN|VOUT$20 VBN|VSS sg13_lv_nmos L=0.13u
+ W=0.3u AS=0.156p AD=0.156p PS=2.08u PD=2.08u
M$86 VIN|VOUT$20 VOUT|VSN|VSP$7 VIN|VOUT$21 VBN|VSS sg13_lv_nmos L=0.13u W=0.3u
+ AS=0.201p AD=0.201p PS=2.68u PD=2.68u
M$88 VBN|VSS \$135 \$135 VBN|VSS sg13_lv_nmos L=0.13u W=0.15u AS=0.1005p
+ AD=0.1005p PS=1.34u PD=1.34u
M$89 VIN|VOUT$20 VOUT|VSN|VSP$6 VIN|VOUT$21 VBN|VSS sg13_lv_nmos L=0.13u
+ W=0.15u AS=0.1005p AD=0.1005p PS=1.34u PD=1.34u
M$90 VIN|VOUT$21 VOUT|VSN|VSP$8 VIN|VINA|VOUT VBN|VSS sg13_lv_nmos L=0.13u
+ W=0.15u AS=0.1005p AD=0.1005p PS=1.34u PD=1.34u
M$91 VBN|VSS VIN|VOUT$22 CLKN|VIN|VOUT|VOUTDP VBN|VSS sg13_lv_nmos L=0.13u
+ W=1.2u AS=0.624p AD=0.624p PS=8.32u PD=8.32u
M$99 VBN|VSS VIN|VOUT$23 VIN|VOUT$22 VBN|VSS sg13_lv_nmos L=0.13u W=0.6u
+ AS=0.312p AD=0.312p PS=4.16u PD=4.16u
M$103 VBN|VSS VIN|VOUT$24 VIN|VOUT$23 VBN|VSS sg13_lv_nmos L=0.13u W=0.3u
+ AS=0.156p AD=0.156p PS=2.08u PD=2.08u
M$105 VIN|VOUT$24 VIN$1 VBN|VSS VBN|VSS sg13_lv_nmos L=0.13u W=0.15u AS=0.1005p
+ AD=0.1005p PS=1.34u PD=1.34u
M$106 VBN|VSS VIN|VOUT$25 CLKN|VIN|VOUT|VOUTDP$2 VBN|VSS sg13_lv_nmos L=0.13u
+ W=1.2u AS=0.624p AD=0.624p PS=8.32u PD=8.32u
M$114 VBN|VSS VIN|VOUT$26 VIN|VOUT$25 VBN|VSS sg13_lv_nmos L=0.13u W=0.6u
+ AS=0.312p AD=0.312p PS=4.16u PD=4.16u
M$118 VBN|VSS VIN|VOUT$27 VIN|VOUT$26 VBN|VSS sg13_lv_nmos L=0.13u W=0.3u
+ AS=0.156p AD=0.156p PS=2.08u PD=2.08u
M$120 VIN|VOUT$27 VIN$3 VBN|VSS VBN|VSS sg13_lv_nmos L=0.13u W=0.15u AS=0.1005p
+ AD=0.1005p PS=1.34u PD=1.34u
M$121 VBN|VSS VIN|VOUT$28 CLKN|VIN|VOUT|VOUTDP$1 VBN|VSS sg13_lv_nmos L=0.13u
+ W=1.2u AS=0.624p AD=0.624p PS=8.32u PD=8.32u
M$129 VBN|VSS VIN|VOUT$29 VIN|VOUT$28 VBN|VSS sg13_lv_nmos L=0.13u W=0.6u
+ AS=0.312p AD=0.312p PS=4.16u PD=4.16u
M$133 VBN|VSS VIN|VOUT$30 VIN|VOUT$29 VBN|VSS sg13_lv_nmos L=0.13u W=0.3u
+ AS=0.156p AD=0.156p PS=2.08u PD=2.08u
M$135 VIN|VOUT$30 VIN$5 VBN|VSS VBN|VSS sg13_lv_nmos L=0.13u W=0.15u AS=0.1005p
+ AD=0.1005p PS=1.34u PD=1.34u
M$136 VBN|VSS PH270|VIN|VINB|VIND|VINQB|VOUT VIN|VOUT$32 VBN|VSS sg13_lv_nmos
+ L=0.13u W=0.3u AS=0.156p AD=0.156p PS=2.08u PD=2.08u
M$138 VIN|VOUT$32 SQ[1]|VIN|VOUT|VS|VSN|VSP|VS[1] VIN|VOUT$31 VBN|VSS
+ sg13_lv_nmos L=0.13u W=0.15u AS=0.1005p AD=0.1005p PS=1.34u PD=1.34u
M$139 VIN|VOUT$32 VOUT|VSN|VSP$10 VIN|VOUT$31 VBN|VSS sg13_lv_nmos L=0.13u
+ W=0.3u AS=0.201p AD=0.201p PS=2.68u PD=2.68u
M$140 VBN|VSS \$991 VOUT|VSN|VSP$10 VBN|VSS sg13_lv_nmos L=0.13u W=0.15u
+ AS=0.1005p AD=0.1005p PS=1.34u PD=1.34u
M$142 VIN|VOUT$31 VOUT|VSN|VSP$11 VIN|VINB|VOUT$1 VBN|VSS sg13_lv_nmos L=0.13u
+ W=0.15u AS=0.1005p AD=0.1005p PS=1.34u PD=1.34u
M$143 VBN|VSS CLKP|VIN|VOUT|VOUTDN$2 VIN VBN|VSS sg13_lv_nmos L=0.13u W=4.5u
+ AS=1.8p AD=1.665p PS=24u PD=22.2u
M$153 VBN|VSS CLKN|VIN|VOUT|VOUTDP$1 VIN$1 VBN|VSS sg13_lv_nmos L=0.13u W=4.5u
+ AS=1.665p AD=1.8p PS=22.2u PD=24u
M$163 VBN|VSS CLKP|VIN|VOUT|VOUTDN VIN$2 VBN|VSS sg13_lv_nmos L=0.13u W=4.5u
+ AS=1.8p AD=1.665p PS=24u PD=22.2u
M$173 VBN|VSS CLKN|VIN|VOUT|VOUTDP VIN$3 VBN|VSS sg13_lv_nmos L=0.13u W=4.5u
+ AS=1.665p AD=1.8p PS=22.2u PD=24u
M$183 VBN|VSS CLKP|VIN|VOUT|VOUTDN$1 VIN$4 VBN|VSS sg13_lv_nmos L=0.13u W=4.5u
+ AS=1.8p AD=1.665p PS=24u PD=22.2u
M$193 VBN|VSS CLKN|VIN|VOUT|VOUTDP$2 VIN$5 VBN|VSS sg13_lv_nmos L=0.13u W=4.5u
+ AS=1.665p AD=1.8p PS=22.2u PD=24u
M$323 VBN|VSS SQ[1]|VIN|VOUT|VS|VSN|VSP|VS[1] VOUT|VSN|VSP$9 VBN|VSS
+ sg13_lv_nmos L=0.13u W=0.15u AS=0.1005p AD=0.1005p PS=1.34u PD=1.34u
M$324 VBN|VSS PH90|VIN|VINA|VINC|VINQ|VOUT VIN|VOUT$33 VBN|VSS sg13_lv_nmos
+ L=0.13u W=0.3u AS=0.156p AD=0.156p PS=2.08u PD=2.08u
M$326 VIN|VOUT$33 VOUT|VSN|VSP$9 VIN|VOUT$34 VBN|VSS sg13_lv_nmos L=0.13u
+ W=0.3u AS=0.201p AD=0.201p PS=2.68u PD=2.68u
M$328 VBN|VSS \$1284 \$1284 VBN|VSS sg13_lv_nmos L=0.13u W=0.15u AS=0.1005p
+ AD=0.1005p PS=1.34u PD=1.34u
M$329 VIN|VOUT$33 VOUT|VSN|VSP$10 VIN|VOUT$34 VBN|VSS sg13_lv_nmos L=0.13u
+ W=0.15u AS=0.1005p AD=0.1005p PS=1.34u PD=1.34u
M$330 VIN|VOUT$34 VOUT|VSN|VSP$11 VIN|VINB|VOUT$1 VBN|VSS sg13_lv_nmos L=0.13u
+ W=0.15u AS=0.1005p AD=0.1005p PS=1.34u PD=1.34u
M$331 VBN|VSS VIN|VINB|VOUT$1 VIN|VOUT$35 VBN|VSS sg13_lv_nmos L=0.13u W=0.3u
+ AS=0.156p AD=0.156p PS=2.08u PD=2.08u
M$333 VIN|VOUT$35 STQ[6]|VIN|VOUT|VS|VSN|VSP|VST|VST[6] VIN|VOUT$36 VBN|VSS
+ sg13_lv_nmos L=0.13u W=0.15u AS=0.1005p AD=0.1005p PS=1.34u PD=1.34u
M$334 VIN|VOUT$35 VOUT|VSN|VSP$12 VIN|VOUT$36 VBN|VSS sg13_lv_nmos L=0.13u
+ W=0.3u AS=0.201p AD=0.201p PS=2.68u PD=2.68u
M$335 VBN|VSS \$1321 VOUT|VSN|VSP$12 VBN|VSS sg13_lv_nmos L=0.13u W=0.15u
+ AS=0.1005p AD=0.1005p PS=1.34u PD=1.34u
M$337 VIN|VOUT$36 VOUT|VSN|VSP$14 VIN|VOUT$4 VBN|VSS sg13_lv_nmos L=0.13u
+ W=0.15u AS=0.1005p AD=0.1005p PS=1.34u PD=1.34u
M$338 VIN CTRL|VCONT \$1313 VBN|VSS sg13_lv_nmos L=0.13u W=0.3u AS=0.156p
+ AD=0.156p PS=2.08u PD=2.08u
M$340 VIN$1 CTRL|VCONT \$1314 VBN|VSS sg13_lv_nmos L=0.13u W=0.3u AS=0.156p
+ AD=0.156p PS=2.08u PD=2.08u
M$342 VIN$2 CTRL|VCONT \$1315 VBN|VSS sg13_lv_nmos L=0.13u W=0.3u AS=0.156p
+ AD=0.156p PS=2.08u PD=2.08u
M$344 VIN$3 CTRL|VCONT \$1316 VBN|VSS sg13_lv_nmos L=0.13u W=0.3u AS=0.156p
+ AD=0.156p PS=2.08u PD=2.08u
M$346 VIN$4 CTRL|VCONT \$1317 VBN|VSS sg13_lv_nmos L=0.13u W=0.3u AS=0.156p
+ AD=0.156p PS=2.08u PD=2.08u
M$348 VIN$5 CTRL|VCONT \$1318 VBN|VSS sg13_lv_nmos L=0.13u W=0.3u AS=0.156p
+ AD=0.156p PS=2.08u PD=2.08u
M$350 VBN|VSS PH180|VIN|VINB|VINIB|VOUT VIN|VOUT$37 VBN|VSS sg13_lv_nmos
+ L=0.13u W=0.3u AS=0.156p AD=0.156p PS=2.08u PD=2.08u
M$352 VIN|VOUT$37 SQ[0]|VIN|VOUT|VS|VSN|VSP|VS[0] VIN|VOUT$38 VBN|VSS
+ sg13_lv_nmos L=0.13u W=0.15u AS=0.1005p AD=0.1005p PS=1.34u PD=1.34u
M$353 VIN|VOUT$37 VOUT|VSN|VSP$15 VIN|VOUT$38 VBN|VSS sg13_lv_nmos L=0.13u
+ W=0.3u AS=0.201p AD=0.201p PS=2.68u PD=2.68u
M$354 VBN|VSS \$1397 VOUT|VSN|VSP$15 VBN|VSS sg13_lv_nmos L=0.13u W=0.15u
+ AS=0.1005p AD=0.1005p PS=1.34u PD=1.34u
M$356 VIN|VOUT$38 VOUT|VSN|VSP$17 VIN|VINA|VOUT$1 VBN|VSS sg13_lv_nmos L=0.13u
+ W=0.15u AS=0.1005p AD=0.1005p PS=1.34u PD=1.34u
M$357 VBN|VSS STQ[6]|VIN|VOUT|VS|VSN|VSP|VST|VST[6] VOUT|VSN|VSP$13 VBN|VSS
+ sg13_lv_nmos L=0.13u W=0.15u AS=0.1005p AD=0.1005p PS=1.34u PD=1.34u
M$358 VBN|VSS VIN|VINA|VOUT$1 VIN|VOUT$39 VBN|VSS sg13_lv_nmos L=0.13u W=0.3u
+ AS=0.156p AD=0.156p PS=2.08u PD=2.08u
M$360 VIN|VOUT$39 VOUT|VSN|VSP$13 VIN|VOUT$40 VBN|VSS sg13_lv_nmos L=0.13u
+ W=0.3u AS=0.201p AD=0.201p PS=2.68u PD=2.68u
M$362 VBN|VSS \$1370 \$1370 VBN|VSS sg13_lv_nmos L=0.13u W=0.15u AS=0.1005p
+ AD=0.1005p PS=1.34u PD=1.34u
M$363 VIN|VOUT$39 VOUT|VSN|VSP$12 VIN|VOUT$40 VBN|VSS sg13_lv_nmos L=0.13u
+ W=0.15u AS=0.1005p AD=0.1005p PS=1.34u PD=1.34u
M$364 VIN|VOUT$40 VOUT|VSN|VSP$14 VIN|VOUT$4 VBN|VSS sg13_lv_nmos L=0.13u
+ W=0.15u AS=0.1005p AD=0.1005p PS=1.34u PD=1.34u
M$365 VBN|VSS VIN VIN|VOUT$41 VBN|VSS sg13_lv_nmos L=0.13u W=0.15u AS=0.1005p
+ AD=0.1005p PS=1.34u PD=1.34u
M$366 VBN|VSS VIN|VOUT$41 VIN|VOUT$44 VBN|VSS sg13_lv_nmos L=0.13u W=0.3u
+ AS=0.156p AD=0.156p PS=2.08u PD=2.08u
M$368 VBN|VSS VIN|VOUT$44 VIN|VOUT$45 VBN|VSS sg13_lv_nmos L=0.13u W=0.6u
+ AS=0.312p AD=0.312p PS=4.16u PD=4.16u
M$372 VBN|VSS VIN|VOUT$45 CLKP|VIN|VOUT|VOUTDN VBN|VSS sg13_lv_nmos L=0.13u
+ W=1.2u AS=0.624p AD=0.624p PS=8.32u PD=8.32u
M$380 VBN|VSS VIN$2 VIN|VOUT$42 VBN|VSS sg13_lv_nmos L=0.13u W=0.15u AS=0.1005p
+ AD=0.1005p PS=1.34u PD=1.34u
M$381 VBN|VSS VIN|VOUT$42 VIN|VOUT$46 VBN|VSS sg13_lv_nmos L=0.13u W=0.3u
+ AS=0.156p AD=0.156p PS=2.08u PD=2.08u
M$383 VBN|VSS VIN|VOUT$46 VIN|VOUT$47 VBN|VSS sg13_lv_nmos L=0.13u W=0.6u
+ AS=0.312p AD=0.312p PS=4.16u PD=4.16u
M$387 VBN|VSS VIN|VOUT$47 CLKP|VIN|VOUT|VOUTDN$1 VBN|VSS sg13_lv_nmos L=0.13u
+ W=1.2u AS=0.624p AD=0.624p PS=8.32u PD=8.32u
M$395 VBN|VSS VIN$4 VIN|VOUT$43 VBN|VSS sg13_lv_nmos L=0.13u W=0.15u AS=0.1005p
+ AD=0.1005p PS=1.34u PD=1.34u
M$396 VBN|VSS VIN|VOUT$43 VIN|VOUT$48 VBN|VSS sg13_lv_nmos L=0.13u W=0.3u
+ AS=0.156p AD=0.156p PS=2.08u PD=2.08u
M$398 VBN|VSS VIN|VOUT$48 VIN|VOUT$49 VBN|VSS sg13_lv_nmos L=0.13u W=0.6u
+ AS=0.312p AD=0.312p PS=4.16u PD=4.16u
M$402 VBN|VSS VIN|VOUT$49 CLKP|VIN|VOUT|VOUTDN$2 VBN|VSS sg13_lv_nmos L=0.13u
+ W=1.2u AS=0.624p AD=0.624p PS=8.32u PD=8.32u
M$410 VBN|VSS SQ[0]|VIN|VOUT|VS|VSN|VSP|VS[0] VOUT|VSN|VSP$16 VBN|VSS
+ sg13_lv_nmos L=0.13u W=0.15u AS=0.1005p AD=0.1005p PS=1.34u PD=1.34u
M$411 VBN|VSS PH0|VIN|VINA|VINI|VOUT VIN|VOUT$51 VBN|VSS sg13_lv_nmos L=0.13u
+ W=0.3u AS=0.156p AD=0.156p PS=2.08u PD=2.08u
M$413 VIN|VOUT$51 VOUT|VSN|VSP$16 VIN|VOUT$50 VBN|VSS sg13_lv_nmos L=0.13u
+ W=0.3u AS=0.201p AD=0.201p PS=2.68u PD=2.68u
M$415 VBN|VSS \$1700 \$1700 VBN|VSS sg13_lv_nmos L=0.13u W=0.15u AS=0.1005p
+ AD=0.1005p PS=1.34u PD=1.34u
M$416 VIN|VOUT$51 VOUT|VSN|VSP$15 VIN|VOUT$50 VBN|VSS sg13_lv_nmos L=0.13u
+ W=0.15u AS=0.1005p AD=0.1005p PS=1.34u PD=1.34u
M$417 VIN|VOUT$50 VOUT|VSN|VSP$17 VIN|VINA|VOUT$1 VBN|VSS sg13_lv_nmos L=0.13u
+ W=0.15u AS=0.1005p AD=0.1005p PS=1.34u PD=1.34u
M$418 VBN|VSS VIN|VOUT$52 PH0|PH1|V0|VIN|VOUT|VOUTDN VBN|VSS sg13_lv_nmos
+ L=0.13u W=1.2u AS=0.624p AD=0.624p PS=8.32u PD=8.32u
M$426 VBN|VSS VIN|VOUT$53 VIN|VOUT$52 VBN|VSS sg13_lv_nmos L=0.13u W=0.6u
+ AS=0.312p AD=0.312p PS=4.16u PD=4.16u
M$430 VBN|VSS VIN|VOUT$54 VIN|VOUT$53 VBN|VSS sg13_lv_nmos L=0.13u W=0.3u
+ AS=0.156p AD=0.156p PS=2.08u PD=2.08u
M$432 VIN|VOUT$54 CLKP|VIN|VOUT|VOUTDN VBN|VSS VBN|VSS sg13_lv_nmos L=0.13u
+ W=0.15u AS=0.1005p AD=0.1005p PS=1.34u PD=1.34u
M$433 VBN|VSS VIN|VOUT$55 PH0|PH1|PH4|V4|VIN|VOUT|VOUTDP VBN|VSS sg13_lv_nmos
+ L=0.13u W=1.2u AS=0.624p AD=0.624p PS=8.32u PD=8.32u
M$441 VBN|VSS VIN|VOUT$56 VIN|VOUT$55 VBN|VSS sg13_lv_nmos L=0.13u W=0.6u
+ AS=0.312p AD=0.312p PS=4.16u PD=4.16u
M$445 VBN|VSS VIN|VOUT$57 VIN|VOUT$56 VBN|VSS sg13_lv_nmos L=0.13u W=0.3u
+ AS=0.156p AD=0.156p PS=2.08u PD=2.08u
M$447 VIN|VOUT$57 CLKP|VIN|VOUT|VOUTDN$1 VBN|VSS VBN|VSS sg13_lv_nmos L=0.13u
+ W=0.15u AS=0.1005p AD=0.1005p PS=1.34u PD=1.34u
M$448 VBN|VSS VIN|VOUT$58 PH1|PH2|V2|VIN|VOUT|VOUTDN VBN|VSS sg13_lv_nmos
+ L=0.13u W=1.2u AS=0.624p AD=0.624p PS=8.32u PD=8.32u
M$456 VBN|VSS VIN|VOUT$59 VIN|VOUT$58 VBN|VSS sg13_lv_nmos L=0.13u W=0.6u
+ AS=0.312p AD=0.312p PS=4.16u PD=4.16u
M$460 VBN|VSS VIN|VOUT$60 VIN|VOUT$59 VBN|VSS sg13_lv_nmos L=0.13u W=0.3u
+ AS=0.156p AD=0.156p PS=2.08u PD=2.08u
M$462 VIN|VOUT$60 CLKP|VIN|VOUT|VOUTDN$2 VBN|VSS VBN|VSS sg13_lv_nmos L=0.13u
+ W=0.15u AS=0.1005p AD=0.1005p PS=1.34u PD=1.34u
M$463 VBN|VSS PH270|VIN|VINB|VIND|VINQB|VOUT VIN|VOUT$62 VBN|VSS sg13_lv_nmos
+ L=0.13u W=0.3u AS=0.156p AD=0.156p PS=2.08u PD=2.08u
M$465 VIN|VOUT$62 SQ[1]|VIN|VOUT|VS|VSN|VSP|VS[1] VIN|VOUT$61 VBN|VSS
+ sg13_lv_nmos L=0.13u W=0.15u AS=0.1005p AD=0.1005p PS=1.34u PD=1.34u
M$466 VIN|VOUT$62 VOUT|VSN|VSP$18 VIN|VOUT$61 VBN|VSS sg13_lv_nmos L=0.13u
+ W=0.3u AS=0.201p AD=0.201p PS=2.68u PD=2.68u
M$467 VBN|VSS \$2560 VOUT|VSN|VSP$18 VBN|VSS sg13_lv_nmos L=0.13u W=0.15u
+ AS=0.1005p AD=0.1005p PS=1.34u PD=1.34u
M$469 VIN|VOUT$61 VOUT|VSN|VSP$20 VIN|VINB|VOUT$2 VBN|VSS sg13_lv_nmos L=0.13u
+ W=0.15u AS=0.1005p AD=0.1005p PS=1.34u PD=1.34u
M$470 VBN|VSS SQ[1]|VIN|VOUT|VS|VSN|VSP|VS[1] VOUT|VSN|VSP$19 VBN|VSS
+ sg13_lv_nmos L=0.13u W=0.15u AS=0.1005p AD=0.1005p PS=1.34u PD=1.34u
M$471 VBN|VSS PH90|VIN|VINA|VINC|VINQ|VOUT VIN|VOUT$63 VBN|VSS sg13_lv_nmos
+ L=0.13u W=0.3u AS=0.156p AD=0.156p PS=2.08u PD=2.08u
M$473 VIN|VOUT$63 VOUT|VSN|VSP$19 VIN|VOUT$64 VBN|VSS sg13_lv_nmos L=0.13u
+ W=0.3u AS=0.201p AD=0.201p PS=2.68u PD=2.68u
M$475 VBN|VSS \$2581 \$2581 VBN|VSS sg13_lv_nmos L=0.13u W=0.15u AS=0.1005p
+ AD=0.1005p PS=1.34u PD=1.34u
M$476 VIN|VOUT$63 VOUT|VSN|VSP$18 VIN|VOUT$64 VBN|VSS sg13_lv_nmos L=0.13u
+ W=0.15u AS=0.1005p AD=0.1005p PS=1.34u PD=1.34u
M$477 VIN|VOUT$64 VOUT|VSN|VSP$20 VIN|VINB|VOUT$2 VBN|VSS sg13_lv_nmos L=0.13u
+ W=0.15u AS=0.1005p AD=0.1005p PS=1.34u PD=1.34u
M$478 VBN|VSS VIN|VINB|VOUT$2 VIN|VOUT$65 VBN|VSS sg13_lv_nmos L=0.13u W=0.3u
+ AS=0.156p AD=0.156p PS=2.08u PD=2.08u
M$480 VIN|VOUT$65 STQ[5]|VIN|VOUT|VS|VSN|VSP|VST|VST[5] VIN|VOUT$66 VBN|VSS
+ sg13_lv_nmos L=0.13u W=0.15u AS=0.1005p AD=0.1005p PS=1.34u PD=1.34u
M$481 VIN|VOUT$65 VOUT|VSN|VSP$21 VIN|VOUT$66 VBN|VSS sg13_lv_nmos L=0.13u
+ W=0.3u AS=0.201p AD=0.201p PS=2.68u PD=2.68u
M$482 VBN|VSS \$2618 VOUT|VSN|VSP$21 VBN|VSS sg13_lv_nmos L=0.13u W=0.15u
+ AS=0.1005p AD=0.1005p PS=1.34u PD=1.34u
M$484 VIN|VOUT$66 VOUT|VSN|VSP$23 VIN|VOUT$4 VBN|VSS sg13_lv_nmos L=0.13u
+ W=0.15u AS=0.1005p AD=0.1005p PS=1.34u PD=1.34u
M$485 VBN|VSS PH180|VIN|VINB|VINIB|VOUT VIN|VOUT$67 VBN|VSS sg13_lv_nmos
+ L=0.13u W=0.3u AS=0.156p AD=0.156p PS=2.08u PD=2.08u
M$487 VIN|VOUT$67 SQ[0]|VIN|VOUT|VS|VSN|VSP|VS[0] VIN|VOUT$68 VBN|VSS
+ sg13_lv_nmos L=0.13u W=0.15u AS=0.1005p AD=0.1005p PS=1.34u PD=1.34u
M$488 VIN|VOUT$67 VOUT|VSN|VSP$24 VIN|VOUT$68 VBN|VSS sg13_lv_nmos L=0.13u
+ W=0.3u AS=0.201p AD=0.201p PS=2.68u PD=2.68u
M$489 VBN|VSS \$2688 VOUT|VSN|VSP$24 VBN|VSS sg13_lv_nmos L=0.13u W=0.15u
+ AS=0.1005p AD=0.1005p PS=1.34u PD=1.34u
M$491 VIN|VOUT$68 VOUT|VSN|VSP$26 VIN|VINA|VOUT$2 VBN|VSS sg13_lv_nmos L=0.13u
+ W=0.15u AS=0.1005p AD=0.1005p PS=1.34u PD=1.34u
M$492 VBN|VSS STQ[5]|VIN|VOUT|VS|VSN|VSP|VST|VST[5] VOUT|VSN|VSP$22 VBN|VSS
+ sg13_lv_nmos L=0.13u W=0.15u AS=0.1005p AD=0.1005p PS=1.34u PD=1.34u
M$493 VBN|VSS VIN|VINA|VOUT$2 VIN|VOUT$69 VBN|VSS sg13_lv_nmos L=0.13u W=0.3u
+ AS=0.156p AD=0.156p PS=2.08u PD=2.08u
M$495 VIN|VOUT$69 VOUT|VSN|VSP$22 VIN|VOUT$70 VBN|VSS sg13_lv_nmos L=0.13u
+ W=0.3u AS=0.201p AD=0.201p PS=2.68u PD=2.68u
M$497 VBN|VSS \$2666 \$2666 VBN|VSS sg13_lv_nmos L=0.13u W=0.15u AS=0.1005p
+ AD=0.1005p PS=1.34u PD=1.34u
M$498 VIN|VOUT$69 VOUT|VSN|VSP$21 VIN|VOUT$70 VBN|VSS sg13_lv_nmos L=0.13u
+ W=0.15u AS=0.1005p AD=0.1005p PS=1.34u PD=1.34u
M$499 VIN|VOUT$70 VOUT|VSN|VSP$23 VIN|VOUT$4 VBN|VSS sg13_lv_nmos L=0.13u
+ W=0.15u AS=0.1005p AD=0.1005p PS=1.34u PD=1.34u
M$500 VBN|VSS PH0|PH1|V0|VIN|VOUT|VOUTDN PH0|PH3|V3|VIN|VOUT|VOUTDP VBN|VSS
+ sg13_lv_nmos L=0.13u W=0.3u AS=0.156p AD=0.156p PS=2.08u PD=2.08u
M$502 VBN|VSS PH0|PH3|V3|VIN|VOUT|VOUTDP PH0|PH1|V0|VIN|VOUT|VOUTDN VBN|VSS
+ sg13_lv_nmos L=0.13u W=0.3u AS=0.156p AD=0.156p PS=2.08u PD=2.08u
M$504 VBN|VSS PH0|PH1|PH4|V4|VIN|VOUT|VOUTDP PH0|PH1|V1|VIN|VOUT|VOUTDN VBN|VSS
+ sg13_lv_nmos L=0.13u W=0.3u AS=0.156p AD=0.156p PS=2.08u PD=2.08u
M$506 VBN|VSS PH0|PH1|V1|VIN|VOUT|VOUTDN PH0|PH1|PH4|V4|VIN|VOUT|VOUTDP VBN|VSS
+ sg13_lv_nmos L=0.13u W=0.3u AS=0.156p AD=0.156p PS=2.08u PD=2.08u
M$508 VBN|VSS PH1|PH2|V2|VIN|VOUT|VOUTDN PH0|PH1|PH5|V5|VIN|VOUT|VOUTDP VBN|VSS
+ sg13_lv_nmos L=0.13u W=0.3u AS=0.156p AD=0.156p PS=2.08u PD=2.08u
M$510 VBN|VSS PH0|PH1|PH5|V5|VIN|VOUT|VOUTDP PH1|PH2|V2|VIN|VOUT|VOUTDN VBN|VSS
+ sg13_lv_nmos L=0.13u W=0.3u AS=0.156p AD=0.156p PS=2.08u PD=2.08u
M$512 VBN|VSS SQ[0]|VIN|VOUT|VS|VSN|VSP|VS[0] VOUT|VSN|VSP$25 VBN|VSS
+ sg13_lv_nmos L=0.13u W=0.15u AS=0.1005p AD=0.1005p PS=1.34u PD=1.34u
M$513 VIN|VOUT$71 VOUT|VSN|VSP$25 VIN|VOUT$72 VBN|VSS sg13_lv_nmos L=0.13u
+ W=0.3u AS=0.201p AD=0.201p PS=2.68u PD=2.68u
M$515 VBN|VSS \$2854 \$2854 VBN|VSS sg13_lv_nmos L=0.13u W=0.15u AS=0.1005p
+ AD=0.1005p PS=1.34u PD=1.34u
M$516 VIN|VOUT$71 VOUT|VSN|VSP$24 VIN|VOUT$72 VBN|VSS sg13_lv_nmos L=0.13u
+ W=0.15u AS=0.1005p AD=0.1005p PS=1.34u PD=1.34u
M$517 VIN|VOUT$72 VOUT|VSN|VSP$26 VIN|VINA|VOUT$2 VBN|VSS sg13_lv_nmos L=0.13u
+ W=0.15u AS=0.1005p AD=0.1005p PS=1.34u PD=1.34u
M$518 VBN|VSS VIN|VOUT$73 PH180|VIN|VINB|VINIB|VOUT VBN|VSS sg13_lv_nmos
+ L=0.13u W=9.6u AS=4.992p AD=4.992p PS=66.56u PD=66.56u
M$534 VBN|VSS PH0|VIN|VINA|VINI|VOUT VIN|VOUT$71 VBN|VSS sg13_lv_nmos L=0.13u
+ W=0.3u AS=0.156p AD=0.156p PS=2.08u PD=2.08u
M$536 VIN|VOUT$75 SQ[1]|VIN|VOUT|VS|VSN|VSP|VS[1] VIN|VOUT$74 VBN|VSS
+ sg13_lv_nmos L=0.13u W=0.15u AS=0.1005p AD=0.1005p PS=1.34u PD=1.34u
M$537 VIN|VOUT$75 VOUT|VSN|VSP$27 VIN|VOUT$74 VBN|VSS sg13_lv_nmos L=0.13u
+ W=0.3u AS=0.201p AD=0.201p PS=2.68u PD=2.68u
M$538 VBN|VSS \$2914 VOUT|VSN|VSP$27 VBN|VSS sg13_lv_nmos L=0.13u W=0.15u
+ AS=0.1005p AD=0.1005p PS=1.34u PD=1.34u
M$540 VIN|VOUT$74 VOUT|VSN|VSP$28 VIN|VINB|VOUT$3 VBN|VSS sg13_lv_nmos L=0.13u
+ W=0.15u AS=0.1005p AD=0.1005p PS=1.34u PD=1.34u
M$557 VBN|VSS SQ[1]|VIN|VOUT|VS|VSN|VSP|VS[1] VOUT|VSN|VSP$29 VBN|VSS
+ sg13_lv_nmos L=0.13u W=0.15u AS=0.1005p AD=0.1005p PS=1.34u PD=1.34u
M$558 VBN|VSS PH270|VIN|VINB|VIND|VINQB|VOUT VIN|VOUT$75 VBN|VSS sg13_lv_nmos
+ L=0.13u W=0.3u AS=0.156p AD=0.156p PS=2.08u PD=2.08u
M$560 VIN|VOUT$83 VOUT|VSN|VSP$29 VIN|VOUT$76 VBN|VSS sg13_lv_nmos L=0.13u
+ W=0.3u AS=0.201p AD=0.201p PS=2.68u PD=2.68u
M$562 VBN|VSS \$2932 \$2932 VBN|VSS sg13_lv_nmos L=0.13u W=0.15u AS=0.1005p
+ AD=0.1005p PS=1.34u PD=1.34u
M$563 VIN|VOUT$83 VOUT|VSN|VSP$27 VIN|VOUT$76 VBN|VSS sg13_lv_nmos L=0.13u
+ W=0.15u AS=0.1005p AD=0.1005p PS=1.34u PD=1.34u
M$564 VIN|VOUT$76 VOUT|VSN|VSP$28 VIN|VINB|VOUT$3 VBN|VSS sg13_lv_nmos L=0.13u
+ W=0.15u AS=0.1005p AD=0.1005p PS=1.34u PD=1.34u
M$565 VIN|VOUT$84 STQ[4]|VIN|VOUT|VS|VSN|VSP|VST|VST[4] VIN|VOUT$77 VBN|VSS
+ sg13_lv_nmos L=0.13u W=0.15u AS=0.1005p AD=0.1005p PS=1.34u PD=1.34u
M$566 VIN|VOUT$84 VOUT|VSN|VSP$30 VIN|VOUT$77 VBN|VSS sg13_lv_nmos L=0.13u
+ W=0.3u AS=0.201p AD=0.201p PS=2.68u PD=2.68u
M$567 VBN|VSS \$2996 VOUT|VSN|VSP$30 VBN|VSS sg13_lv_nmos L=0.13u W=0.15u
+ AS=0.1005p AD=0.1005p PS=1.34u PD=1.34u
M$569 VIN|VOUT$77 VOUT|VSN|VSP$31 VIN|VOUT$4 VBN|VSS sg13_lv_nmos L=0.13u
+ W=0.15u AS=0.1005p AD=0.1005p PS=1.34u PD=1.34u
M$570 VBN|VSS PH0|PH3|V3|VIN|VOUT|VOUTDP VIN|VOUT$79 VBN|VSS sg13_lv_nmos
+ L=0.13u W=0.6u AS=0.312p AD=0.312p PS=4.16u PD=4.16u
M$574 VBN|VSS VIN|VOUT$79 PH1|VIN|VOUT VBN|VSS sg13_lv_nmos L=0.13u W=0.6u
+ AS=0.312p AD=0.312p PS=4.16u PD=4.16u
M$578 VBN|VSS PH1|VIN|VOUT VIN|VOUT$80 VBN|VSS sg13_lv_nmos L=0.13u W=0.6u
+ AS=0.312p AD=0.312p PS=4.16u PD=4.16u
M$582 VBN|VSS VIN|VOUT$80 VIN|VOUT$78 VBN|VSS sg13_lv_nmos L=0.13u W=1.2u
+ AS=0.624p AD=0.624p PS=8.32u PD=8.32u
M$590 VBN|VSS VIN|VOUT$81 VIN|VOUT$82 VBN|VSS sg13_lv_nmos L=0.13u W=4.8u
+ AS=2.496p AD=2.496p PS=33.28u PD=33.28u
M$606 VBN|VSS VIN|VOUT$82 VIN|VOUT$73 VBN|VSS sg13_lv_nmos L=0.13u W=4.8u
+ AS=2.496p AD=2.496p PS=33.28u PD=33.28u
M$638 VBN|VSS PH90|VIN|VINA|VINC|VINQ|VOUT VIN|VOUT$83 VBN|VSS sg13_lv_nmos
+ L=0.13u W=0.3u AS=0.156p AD=0.156p PS=2.08u PD=2.08u
M$640 VIN|VOUT$87 SQ[0]|VIN|VOUT|VS|VSN|VSP|VS[0] VIN|VOUT$85 VBN|VSS
+ sg13_lv_nmos L=0.13u W=0.15u AS=0.1005p AD=0.1005p PS=1.34u PD=1.34u
M$641 VIN|VOUT$87 VOUT|VSN|VSP$33 VIN|VOUT$85 VBN|VSS sg13_lv_nmos L=0.13u
+ W=0.3u AS=0.201p AD=0.201p PS=2.68u PD=2.68u
M$642 VBN|VSS \$3074 VOUT|VSN|VSP$33 VBN|VSS sg13_lv_nmos L=0.13u W=0.15u
+ AS=0.1005p AD=0.1005p PS=1.34u PD=1.34u
M$644 VIN|VOUT$85 VOUT|VSN|VSP$35 VIN|VINA|VOUT$3 VBN|VSS sg13_lv_nmos L=0.13u
+ W=0.15u AS=0.1005p AD=0.1005p PS=1.34u PD=1.34u
M$645 VBN|VSS STQ[4]|VIN|VOUT|VS|VSN|VSP|VST|VST[4] VOUT|VSN|VSP$32 VBN|VSS
+ sg13_lv_nmos L=0.13u W=0.15u AS=0.1005p AD=0.1005p PS=1.34u PD=1.34u
M$646 VBN|VSS VIN|VINB|VOUT$3 VIN|VOUT$84 VBN|VSS sg13_lv_nmos L=0.13u W=0.3u
+ AS=0.156p AD=0.156p PS=2.08u PD=2.08u
M$648 VIN|VOUT$88 VOUT|VSN|VSP$32 VIN|VOUT$86 VBN|VSS sg13_lv_nmos L=0.13u
+ W=0.3u AS=0.201p AD=0.201p PS=2.68u PD=2.68u
M$650 VBN|VSS \$3054 \$3054 VBN|VSS sg13_lv_nmos L=0.13u W=0.15u AS=0.1005p
+ AD=0.1005p PS=1.34u PD=1.34u
M$651 VIN|VOUT$88 VOUT|VSN|VSP$30 VIN|VOUT$86 VBN|VSS sg13_lv_nmos L=0.13u
+ W=0.15u AS=0.1005p AD=0.1005p PS=1.34u PD=1.34u
M$652 VIN|VOUT$86 VOUT|VSN|VSP$31 VIN|VOUT$4 VBN|VSS sg13_lv_nmos L=0.13u
+ W=0.15u AS=0.1005p AD=0.1005p PS=1.34u PD=1.34u
M$653 VBN|VSS VIN|VOUT$78 VIN|VOUT$81 VBN|VSS sg13_lv_nmos L=0.13u W=2.4u
+ AS=1.248p AD=1.248p PS=16.64u PD=16.64u
M$717 VBN|VSS SQ[0]|VIN|VOUT|VS|VSN|VSP|VS[0] VOUT|VSN|VSP$34 VBN|VSS
+ sg13_lv_nmos L=0.13u W=0.15u AS=0.1005p AD=0.1005p PS=1.34u PD=1.34u
M$718 VBN|VSS PH180|VIN|VINB|VINIB|VOUT VIN|VOUT$87 VBN|VSS sg13_lv_nmos
+ L=0.13u W=0.3u AS=0.156p AD=0.156p PS=2.08u PD=2.08u
M$720 VIN|VOUT$90 VOUT|VSN|VSP$34 VIN|VOUT$89 VBN|VSS sg13_lv_nmos L=0.13u
+ W=0.3u AS=0.201p AD=0.201p PS=2.68u PD=2.68u
M$722 VBN|VSS \$3163 \$3163 VBN|VSS sg13_lv_nmos L=0.13u W=0.15u AS=0.1005p
+ AD=0.1005p PS=1.34u PD=1.34u
M$723 VIN|VOUT$90 VOUT|VSN|VSP$33 VIN|VOUT$89 VBN|VSS sg13_lv_nmos L=0.13u
+ W=0.15u AS=0.1005p AD=0.1005p PS=1.34u PD=1.34u
M$724 VIN|VOUT$89 VOUT|VSN|VSP$35 VIN|VINA|VOUT$3 VBN|VSS sg13_lv_nmos L=0.13u
+ W=0.15u AS=0.1005p AD=0.1005p PS=1.34u PD=1.34u
M$725 VBN|VSS VIN|VINA|VOUT$3 VIN|VOUT$88 VBN|VSS sg13_lv_nmos L=0.13u W=0.3u
+ AS=0.156p AD=0.156p PS=2.08u PD=2.08u
M$727 VBN|VSS VIN|VOUT$93 PH0|VIN|VINA|VINI|VOUT VBN|VSS sg13_lv_nmos L=0.13u
+ W=9.6u AS=4.992p AD=4.992p PS=66.56u PD=66.56u
M$743 VBN|VSS PH0|VIN|VINA|VINI|VOUT VIN|VOUT$90 VBN|VSS sg13_lv_nmos L=0.13u
+ W=0.3u AS=0.156p AD=0.156p PS=2.08u PD=2.08u
M$745 VIN|VOUT$96 SQ[1]|VIN|VOUT|VS|VSN|VSP|VS[1] VIN|VOUT$97 VBN|VSS
+ sg13_lv_nmos L=0.13u W=0.15u AS=0.1005p AD=0.1005p PS=1.34u PD=1.34u
M$746 VIN|VOUT$96 VOUT|VSN|VSP$36 VIN|VOUT$97 VBN|VSS sg13_lv_nmos L=0.13u
+ W=0.3u AS=0.201p AD=0.201p PS=2.68u PD=2.68u
M$747 VBN|VSS \$3249 VOUT|VSN|VSP$36 VBN|VSS sg13_lv_nmos L=0.13u W=0.15u
+ AS=0.1005p AD=0.1005p PS=1.34u PD=1.34u
M$749 VIN|VOUT$97 VOUT|VSN|VSP$37 VIN|VINB|VOUT$4 VBN|VSS sg13_lv_nmos L=0.13u
+ W=0.15u AS=0.1005p AD=0.1005p PS=1.34u PD=1.34u
M$750 VBN|VSS VIN|VOUT$4 VIN|VOUT$91 VBN|VSS sg13_lv_nmos L=0.13u W=0.3u
+ AS=0.156p AD=0.156p PS=2.08u PD=2.08u
M$752 VBN|VSS VIN|VOUT$91 VIN|VOUT$94 VBN|VSS sg13_lv_nmos L=0.13u W=0.6u
+ AS=0.312p AD=0.312p PS=4.16u PD=4.16u
M$756 VBN|VSS VIN|VOUT$94 VIN|VOUT$92 VBN|VSS sg13_lv_nmos L=0.13u W=1.2u
+ AS=0.624p AD=0.624p PS=8.32u PD=8.32u
M$764 VBN|VSS VIN|VOUT$95 VOUT VBN|VSS sg13_lv_nmos L=0.13u W=4.8u AS=2.496p
+ AD=2.496p PS=33.28u PD=33.28u
M$780 VBN|VSS PH0|VIN|VOUT PH1|VIN|VOUT VBN|VSS sg13_lv_nmos L=0.13u W=0.6u
+ AS=0.312p AD=0.312p PS=4.16u PD=4.16u
M$784 VBN|VSS PH1|VIN|VOUT PH0|VIN|VOUT VBN|VSS sg13_lv_nmos L=0.13u W=0.3u
+ AS=0.156p AD=0.156p PS=2.08u PD=2.08u
M$802 VBN|VSS PH270|VIN|VINB|VIND|VINQB|VOUT VIN|VOUT$96 VBN|VSS sg13_lv_nmos
+ L=0.13u W=0.3u AS=0.156p AD=0.156p PS=2.08u PD=2.08u
M$804 VBN|VSS VIN|VOUT$92 VIN|VOUT$95 VBN|VSS sg13_lv_nmos L=0.13u W=2.4u
+ AS=1.248p AD=1.248p PS=16.64u PD=16.64u
M$836 VBN|VSS PH0|PH1|V0|VIN|VOUT|VOUTDN VIN|VOUT$103 VBN|VSS sg13_lv_nmos
+ L=0.13u W=0.6u AS=0.312p AD=0.312p PS=4.16u PD=4.16u
M$840 VBN|VSS VIN|VOUT$103 PH0|VIN|VOUT VBN|VSS sg13_lv_nmos L=0.13u W=0.6u
+ AS=0.312p AD=0.312p PS=4.16u PD=4.16u
M$844 VBN|VSS PH0|VIN|VOUT VIN|VOUT$104 VBN|VSS sg13_lv_nmos L=0.13u W=0.6u
+ AS=0.312p AD=0.312p PS=4.16u PD=4.16u
M$848 VBN|VSS VIN|VOUT$104 VIN|VOUT$110 VBN|VSS sg13_lv_nmos L=0.13u W=1.2u
+ AS=0.624p AD=0.624p PS=8.32u PD=8.32u
M$856 VBN|VSS VIN|VOUT$105 VIN|VOUT$100 VBN|VSS sg13_lv_nmos L=0.13u W=4.8u
+ AS=2.496p AD=2.496p PS=33.28u PD=33.28u
M$872 VBN|VSS VIN|VOUT$100 VIN|VOUT$93 VBN|VSS sg13_lv_nmos L=0.13u W=4.8u
+ AS=2.496p AD=2.496p PS=33.28u PD=33.28u
M$904 VBN|VSS SQ[1]|VIN|VOUT|VS|VSN|VSP|VS[1] VOUT|VSN|VSP$38 VBN|VSS
+ sg13_lv_nmos L=0.13u W=0.15u AS=0.1005p AD=0.1005p PS=1.34u PD=1.34u
M$905 VBN|VSS PH90|VIN|VINA|VINC|VINQ|VOUT VIN|VOUT$101 VBN|VSS sg13_lv_nmos
+ L=0.13u W=0.3u AS=0.156p AD=0.156p PS=2.08u PD=2.08u
M$907 VIN|VOUT$101 VOUT|VSN|VSP$38 VIN|VOUT$99 VBN|VSS sg13_lv_nmos L=0.13u
+ W=0.3u AS=0.201p AD=0.201p PS=2.68u PD=2.68u
M$909 VBN|VSS \$3384 \$3384 VBN|VSS sg13_lv_nmos L=0.13u W=0.15u AS=0.1005p
+ AD=0.1005p PS=1.34u PD=1.34u
M$910 VIN|VOUT$101 VOUT|VSN|VSP$36 VIN|VOUT$99 VBN|VSS sg13_lv_nmos L=0.13u
+ W=0.15u AS=0.1005p AD=0.1005p PS=1.34u PD=1.34u
M$911 VIN|VOUT$99 VOUT|VSN|VSP$37 VIN|VINB|VOUT$4 VBN|VSS sg13_lv_nmos L=0.13u
+ W=0.15u AS=0.1005p AD=0.1005p PS=1.34u PD=1.34u
M$912 VBN|VSS VIN|VINB|VOUT$4 VIN|VOUT$102 VBN|VSS sg13_lv_nmos L=0.13u W=0.3u
+ AS=0.156p AD=0.156p PS=2.08u PD=2.08u
M$914 VIN|VOUT$102 STQ[3]|VIN|VOUT|VS|VSN|VSP|VST|VST[3] VIN|VOUT$98 VBN|VSS
+ sg13_lv_nmos L=0.13u W=0.15u AS=0.1005p AD=0.1005p PS=1.34u PD=1.34u
M$915 VIN|VOUT$102 VOUT|VSN|VSP$39 VIN|VOUT$98 VBN|VSS sg13_lv_nmos L=0.13u
+ W=0.3u AS=0.201p AD=0.201p PS=2.68u PD=2.68u
M$916 VBN|VSS \$3407 VOUT|VSN|VSP$39 VBN|VSS sg13_lv_nmos L=0.13u W=0.15u
+ AS=0.1005p AD=0.1005p PS=1.34u PD=1.34u
M$918 VIN|VOUT$98 VOUT|VSN|VSP$40 VIN|VOUT$4 VBN|VSS sg13_lv_nmos L=0.13u
+ W=0.15u AS=0.1005p AD=0.1005p PS=1.34u PD=1.34u
M$919 VBN|VSS VIN|VOUT$110 VIN|VOUT$105 VBN|VSS sg13_lv_nmos L=0.13u W=2.4u
+ AS=1.248p AD=1.248p PS=16.64u PD=16.64u
M$983 VBN|VSS PH180|VIN|VINB|VINIB|VOUT VIN|VOUT$108 VBN|VSS sg13_lv_nmos
+ L=0.13u W=0.3u AS=0.156p AD=0.156p PS=2.08u PD=2.08u
M$985 VIN|VOUT$108 SQ[0]|VIN|VOUT|VS|VSN|VSP|VS[0] VIN|VOUT$106 VBN|VSS
+ sg13_lv_nmos L=0.13u W=0.15u AS=0.1005p AD=0.1005p PS=1.34u PD=1.34u
M$986 VIN|VOUT$108 VOUT|VSN|VSP$42 VIN|VOUT$106 VBN|VSS sg13_lv_nmos L=0.13u
+ W=0.3u AS=0.201p AD=0.201p PS=2.68u PD=2.68u
M$987 VBN|VSS \$3558 VOUT|VSN|VSP$42 VBN|VSS sg13_lv_nmos L=0.13u W=0.15u
+ AS=0.1005p AD=0.1005p PS=1.34u PD=1.34u
M$989 VIN|VOUT$106 VOUT|VSN|VSP$44 VIN|VINA|VOUT$4 VBN|VSS sg13_lv_nmos L=0.13u
+ W=0.15u AS=0.1005p AD=0.1005p PS=1.34u PD=1.34u
M$990 VBN|VSS STQ[3]|VIN|VOUT|VS|VSN|VSP|VST|VST[3] VOUT|VSN|VSP$41 VBN|VSS
+ sg13_lv_nmos L=0.13u W=0.15u AS=0.1005p AD=0.1005p PS=1.34u PD=1.34u
M$991 VBN|VSS VIN|VINA|VOUT$4 VIN|VOUT$109 VBN|VSS sg13_lv_nmos L=0.13u W=0.3u
+ AS=0.156p AD=0.156p PS=2.08u PD=2.08u
M$993 VIN|VOUT$109 VOUT|VSN|VSP$41 VIN|VOUT$107 VBN|VSS sg13_lv_nmos L=0.13u
+ W=0.3u AS=0.201p AD=0.201p PS=2.68u PD=2.68u
M$995 VBN|VSS \$3501 \$3501 VBN|VSS sg13_lv_nmos L=0.13u W=0.15u AS=0.1005p
+ AD=0.1005p PS=1.34u PD=1.34u
M$996 VIN|VOUT$109 VOUT|VSN|VSP$39 VIN|VOUT$107 VBN|VSS sg13_lv_nmos L=0.13u
+ W=0.15u AS=0.1005p AD=0.1005p PS=1.34u PD=1.34u
M$997 VIN|VOUT$107 VOUT|VSN|VSP$40 VIN|VOUT$4 VBN|VSS sg13_lv_nmos L=0.13u
+ W=0.15u AS=0.1005p AD=0.1005p PS=1.34u PD=1.34u
M$998 VBN|VSS SQ[0]|VIN|VOUT|VS|VSN|VSP|VS[0] VOUT|VSN|VSP$43 VBN|VSS
+ sg13_lv_nmos L=0.13u W=0.15u AS=0.1005p AD=0.1005p PS=1.34u PD=1.34u
M$999 VIN|VOUT$112 VOUT|VSN|VSP$43 VIN|VOUT$113 VBN|VSS sg13_lv_nmos L=0.13u
+ W=0.3u AS=0.201p AD=0.201p PS=2.68u PD=2.68u
M$1001 VBN|VSS \$3612 \$3612 VBN|VSS sg13_lv_nmos L=0.13u W=0.15u AS=0.1005p
+ AD=0.1005p PS=1.34u PD=1.34u
M$1002 VIN|VOUT$112 VOUT|VSN|VSP$42 VIN|VOUT$113 VBN|VSS sg13_lv_nmos L=0.13u
+ W=0.15u AS=0.1005p AD=0.1005p PS=1.34u PD=1.34u
M$1003 VIN|VOUT$113 VOUT|VSN|VSP$44 VIN|VINA|VOUT$4 VBN|VSS sg13_lv_nmos
+ L=0.13u W=0.15u AS=0.1005p AD=0.1005p PS=1.34u PD=1.34u
M$1004 VBN|VSS PH0|PH1|PH5|V5|VIN|VOUT|VOUTDP VIN|VOUT$111 VBN|VSS sg13_lv_nmos
+ L=0.13u W=0.6u AS=0.312p AD=0.312p PS=4.16u PD=4.16u
M$1008 VBN|VSS VIN|VOUT$114 PH270|VIN|VINB|VIND|VINQB|VOUT VBN|VSS sg13_lv_nmos
+ L=0.13u W=9.6u AS=4.992p AD=4.992p PS=66.56u PD=66.56u
M$1024 VBN|VSS PH0|VIN|VINA|VINI|VOUT VIN|VOUT$112 VBN|VSS sg13_lv_nmos L=0.13u
+ W=0.3u AS=0.156p AD=0.156p PS=2.08u PD=2.08u
M$1026 VIN|VOUT$117 SQ[1]|VIN|VOUT|VS|VSN|VSP|VS[1] VIN|VOUT$115 VBN|VSS
+ sg13_lv_nmos L=0.13u W=0.15u AS=0.1005p AD=0.1005p PS=1.34u PD=1.34u
M$1027 VIN|VOUT$117 VOUT|VSN|VSP$45 VIN|VOUT$115 VBN|VSS sg13_lv_nmos L=0.13u
+ W=0.3u AS=0.201p AD=0.201p PS=2.68u PD=2.68u
M$1028 VBN|VSS \$3705 VOUT|VSN|VSP$45 VBN|VSS sg13_lv_nmos L=0.13u W=0.15u
+ AS=0.1005p AD=0.1005p PS=1.34u PD=1.34u
M$1030 VIN|VOUT$115 VOUT|VSN|VSP$47 VIN|VINB|VOUT$5 VBN|VSS sg13_lv_nmos
+ L=0.13u W=0.15u AS=0.1005p AD=0.1005p PS=1.34u PD=1.34u
M$1031 SQ[1]|VIN|VOUT|VS|VSN|VSP|VS[1] VIN|VOUT$116 VBN|VSS VBN|VSS
+ sg13_lv_nmos L=0.13u W=0.15u AS=0.1005p AD=0.1005p PS=1.34u PD=1.34u
M$1032 VIN|VOUT$116 A|S[4]|VIN|VOUT|VS[4] VBN|VSS VBN|VSS sg13_lv_nmos L=0.13u
+ W=0.15u AS=0.1005p AD=0.1005p PS=1.34u PD=1.34u
M$1033 VBN|VSS VIN|VOUT$111 PH1|PHOUT|VIN|VOUT VBN|VSS sg13_lv_nmos L=0.13u
+ W=0.6u AS=0.312p AD=0.312p PS=4.16u PD=4.16u
M$1053 VBN|VSS PH270|VIN|VINB|VIND|VINQB|VOUT VIN|VOUT$117 VBN|VSS sg13_lv_nmos
+ L=0.13u W=0.3u AS=0.156p AD=0.156p PS=2.08u PD=2.08u
M$1055 VOUT|VSN|VSS B|S[3]|VDD|VIN|VSP|VS[3] VBN|VSS VBN|VSS sg13_lv_nmos
+ L=0.13u W=0.15u AS=0.1005p AD=0.1005p PS=1.34u PD=1.34u
M$1056 A|S[4]|VIN|VOUT|VS[4] VOUT|VSN|VSS SQ[0]|VIN|VOUT|VS|VSN|VSP|VS[0]
+ VBN|VSS sg13_lv_nmos L=0.13u W=0.15u AS=0.1005p AD=0.1005p PS=1.34u PD=1.34u
M$1057 SQ[0]|VIN|VOUT|VS|VSN|VSP|VS[0] A|S[4]|VIN|VOUT|VS[4] VOUT|VSN|VSS
+ VBN|VSS sg13_lv_nmos L=0.13u W=0.15u AS=0.1005p AD=0.1005p PS=1.34u PD=1.34u
M$1058 VBN|VSS SQ[1]|VIN|VOUT|VS|VSN|VSP|VS[1] VOUT|VSN|VSP$46 VBN|VSS
+ sg13_lv_nmos L=0.13u W=0.15u AS=0.1005p AD=0.1005p PS=1.34u PD=1.34u
M$1059 VIN|VOUT$118 VOUT|VSN|VSP$46 VIN|VOUT$119 VBN|VSS sg13_lv_nmos L=0.13u
+ W=0.3u AS=0.201p AD=0.201p PS=2.68u PD=2.68u
M$1061 VBN|VSS \$3735 \$3735 VBN|VSS sg13_lv_nmos L=0.13u W=0.15u AS=0.1005p
+ AD=0.1005p PS=1.34u PD=1.34u
M$1062 VIN|VOUT$118 VOUT|VSN|VSP$45 VIN|VOUT$119 VBN|VSS sg13_lv_nmos L=0.13u
+ W=0.15u AS=0.1005p AD=0.1005p PS=1.34u PD=1.34u
M$1063 VIN|VOUT$119 VOUT|VSN|VSP$47 VIN|VINB|VOUT$5 VBN|VSS sg13_lv_nmos
+ L=0.13u W=0.15u AS=0.1005p AD=0.1005p PS=1.34u PD=1.34u
M$1064 VIN|VOUT$120 STQ[2]|VIN|VOUT|VS|VSN|VSP|VST|VST[2] VIN|VOUT$121 VBN|VSS
+ sg13_lv_nmos L=0.13u W=0.15u AS=0.1005p AD=0.1005p PS=1.34u PD=1.34u
M$1065 VIN|VOUT$120 VOUT|VSN|VSP$48 VIN|VOUT$121 VBN|VSS sg13_lv_nmos L=0.13u
+ W=0.3u AS=0.201p AD=0.201p PS=2.68u PD=2.68u
M$1066 VBN|VSS \$3759 VOUT|VSN|VSP$48 VBN|VSS sg13_lv_nmos L=0.13u W=0.15u
+ AS=0.1005p AD=0.1005p PS=1.34u PD=1.34u
M$1068 VIN|VOUT$121 VOUT|VSN|VSP$50 VIN|VOUT$4 VBN|VSS sg13_lv_nmos L=0.13u
+ W=0.15u AS=0.1005p AD=0.1005p PS=1.34u PD=1.34u
M$1069 VBN|VSS PH0|PH1|PH4|V4|VIN|VOUT|VOUTDP VIN|VOUT$111 VBN|VSS sg13_lv_nmos
+ L=0.13u W=0.6u AS=0.312p AD=0.312p PS=4.16u PD=4.16u
M$1073 VBN|VSS PH1|PHOUT|VIN|VOUT VIN|VOUT$122 VBN|VSS sg13_lv_nmos L=0.13u
+ W=0.6u AS=0.312p AD=0.312p PS=4.16u PD=4.16u
M$1077 VBN|VSS VIN|VOUT$122 VIN|VOUT$129 VBN|VSS sg13_lv_nmos L=0.13u W=1.2u
+ AS=0.624p AD=0.624p PS=8.32u PD=8.32u
M$1085 VBN|VSS VIN|VOUT$123 VIN|VOUT$124 VBN|VSS sg13_lv_nmos L=0.13u W=4.8u
+ AS=2.496p AD=2.496p PS=33.28u PD=33.28u
M$1101 VBN|VSS VIN|VOUT$124 VIN|VOUT$114 VBN|VSS sg13_lv_nmos L=0.13u W=4.8u
+ AS=2.496p AD=2.496p PS=33.28u PD=33.28u
M$1133 VBN|VSS PH90|VIN|VINA|VINC|VINQ|VOUT VIN|VOUT$118 VBN|VSS sg13_lv_nmos
+ L=0.13u W=0.3u AS=0.156p AD=0.156p PS=2.08u PD=2.08u
M$1135 VIN|VOUT$128 SQ[0]|VIN|VOUT|VS|VSN|VSP|VS[0] VIN|VOUT$125 VBN|VSS
+ sg13_lv_nmos L=0.13u W=0.15u AS=0.1005p AD=0.1005p PS=1.34u PD=1.34u
M$1136 VIN|VOUT$128 VOUT|VSN|VSP$51 VIN|VOUT$125 VBN|VSS sg13_lv_nmos L=0.13u
+ W=0.3u AS=0.201p AD=0.201p PS=2.68u PD=2.68u
M$1137 VBN|VSS \$3938 VOUT|VSN|VSP$51 VBN|VSS sg13_lv_nmos L=0.13u W=0.15u
+ AS=0.1005p AD=0.1005p PS=1.34u PD=1.34u
M$1139 VIN|VOUT$125 VOUT|VSN|VSP$53 VIN|VINA|VOUT$5 VBN|VSS sg13_lv_nmos
+ L=0.13u W=0.15u AS=0.1005p AD=0.1005p PS=1.34u PD=1.34u
M$1140 VBN|VSS STQ[2]|VIN|VOUT|VS|VSN|VSP|VST|VST[2] VOUT|VSN|VSP$49 VBN|VSS
+ sg13_lv_nmos L=0.13u W=0.15u AS=0.1005p AD=0.1005p PS=1.34u PD=1.34u
M$1141 VBN|VSS VIN|VINB|VOUT$5 VIN|VOUT$120 VBN|VSS sg13_lv_nmos L=0.13u W=0.3u
+ AS=0.156p AD=0.156p PS=2.08u PD=2.08u
M$1143 VIN|VOUT$130 VOUT|VSN|VSP$49 VIN|VOUT$126 VBN|VSS sg13_lv_nmos L=0.13u
+ W=0.3u AS=0.201p AD=0.201p PS=2.68u PD=2.68u
M$1145 VBN|VSS \$3869 \$3869 VBN|VSS sg13_lv_nmos L=0.13u W=0.15u AS=0.1005p
+ AD=0.1005p PS=1.34u PD=1.34u
M$1146 VIN|VOUT$130 VOUT|VSN|VSP$48 VIN|VOUT$126 VBN|VSS sg13_lv_nmos L=0.13u
+ W=0.15u AS=0.1005p AD=0.1005p PS=1.34u PD=1.34u
M$1147 VIN|VOUT$126 VOUT|VSN|VSP$50 VIN|VOUT$4 VBN|VSS sg13_lv_nmos L=0.13u
+ W=0.15u AS=0.1005p AD=0.1005p PS=1.34u PD=1.34u
M$1148 SQ[2]|VIN|VOUT|VS|VSN|VSP|VST|VST[0] VIN|VOUT$127 VBN|VSS VBN|VSS
+ sg13_lv_nmos L=0.13u W=0.15u AS=0.1005p AD=0.1005p PS=1.34u PD=1.34u
M$1149 VIN|VOUT$127 B|S[3]|VDD|VIN|VSP|VS[3] VBN|VSS VBN|VSS sg13_lv_nmos
+ L=0.13u W=0.15u AS=0.1005p AD=0.1005p PS=1.34u PD=1.34u
M$1150 VBN|VSS VIN|VOUT$129 VIN|VOUT$123 VBN|VSS sg13_lv_nmos L=0.13u W=2.4u
+ AS=1.248p AD=1.248p PS=16.64u PD=16.64u
M$1214 VBN|VSS SQ[0]|VIN|VOUT|VS|VSN|VSP|VS[0] VOUT|VSN|VSP$52 VBN|VSS
+ sg13_lv_nmos L=0.13u W=0.15u AS=0.1005p AD=0.1005p PS=1.34u PD=1.34u
M$1215 VBN|VSS PH0|VIN|VINA|VINI|VOUT VIN|VOUT$136 VBN|VSS sg13_lv_nmos L=0.13u
+ W=0.3u AS=0.156p AD=0.156p PS=2.08u PD=2.08u
M$1217 VBN|VSS PH180|VIN|VINB|VINIB|VOUT VIN|VOUT$128 VBN|VSS sg13_lv_nmos
+ L=0.13u W=0.3u AS=0.156p AD=0.156p PS=2.08u PD=2.08u
M$1219 VIN|VOUT$136 VOUT|VSN|VSP$52 VIN|VOUT$131 VBN|VSS sg13_lv_nmos L=0.13u
+ W=0.3u AS=0.201p AD=0.201p PS=2.68u PD=2.68u
M$1221 VBN|VSS \$3992 \$3992 VBN|VSS sg13_lv_nmos L=0.13u W=0.15u AS=0.1005p
+ AD=0.1005p PS=1.34u PD=1.34u
M$1222 VIN|VOUT$136 VOUT|VSN|VSP$51 VIN|VOUT$131 VBN|VSS sg13_lv_nmos L=0.13u
+ W=0.15u AS=0.1005p AD=0.1005p PS=1.34u PD=1.34u
M$1223 VIN|VOUT$131 VOUT|VSN|VSP$53 VIN|VINA|VOUT$5 VBN|VSS sg13_lv_nmos
+ L=0.13u W=0.15u AS=0.1005p AD=0.1005p PS=1.34u PD=1.34u
M$1224 VBN|VSS VIN|VINA|VOUT$5 VIN|VOUT$130 VBN|VSS sg13_lv_nmos L=0.13u W=0.3u
+ AS=0.156p AD=0.156p PS=2.08u PD=2.08u
M$1226 VOUT|VSN|VSS$1 B|OUT|ST[7]|VDD|VIN|VSP VBN|VSS VBN|VSS sg13_lv_nmos
+ L=0.13u W=0.15u AS=0.1005p AD=0.1005p PS=1.34u PD=1.34u
M$1227 A|VIN|VOUT VOUT|VSN|VSS$1 STQ[7]|VIN|VOUT|VS|VSN|VSP|VST|VST[7] VBN|VSS
+ sg13_lv_nmos L=0.13u W=0.15u AS=0.1005p AD=0.1005p PS=1.34u PD=1.34u
M$1228 STQ[7]|VIN|VOUT|VS|VSN|VSP|VST|VST[7] A|VIN|VOUT VOUT|VSN|VSS$1 VBN|VSS
+ sg13_lv_nmos L=0.13u W=0.15u AS=0.1005p AD=0.1005p PS=1.34u PD=1.34u
M$1229 A|VIN|VOUT VIN|VOUT$132 VBN|VSS VBN|VSS sg13_lv_nmos L=0.13u W=0.15u
+ AS=0.1005p AD=0.1005p PS=1.34u PD=1.34u
M$1230 VIN|VOUT$132 VIN|VOUT$133 VBN|VSS VBN|VSS sg13_lv_nmos L=0.13u W=0.15u
+ AS=0.1005p AD=0.1005p PS=1.34u PD=1.34u
M$1231 VBN|VSS PH1|PH2|V2|VIN|VOUT|VOUTDN VIN|VOUT$134 VBN|VSS sg13_lv_nmos
+ L=0.13u W=0.6u AS=0.312p AD=0.312p PS=4.16u PD=4.16u
M$1235 VBN|VSS VIN|VOUT$135 PH90|VIN|VINA|VINC|VINQ|VOUT VBN|VSS sg13_lv_nmos
+ L=0.13u W=9.6u AS=4.992p AD=4.992p PS=66.56u PD=66.56u
M$1251 VOUT|VSN|VSS$2 B|OUT|ST[6]|VDD|VIN|VSP VBN|VSS VBN|VSS sg13_lv_nmos
+ L=0.13u W=0.15u AS=0.1005p AD=0.1005p PS=1.34u PD=1.34u
M$1252 A|VIN|VOUT$1 VOUT|VSN|VSS$2 STQ[6]|VIN|VOUT|VS|VSN|VSP|VST|VST[6]
+ VBN|VSS sg13_lv_nmos L=0.13u W=0.15u AS=0.1005p AD=0.1005p PS=1.34u PD=1.34u
M$1253 STQ[6]|VIN|VOUT|VS|VSN|VSP|VST|VST[6] A|VIN|VOUT$1 VOUT|VSN|VSS$2
+ VBN|VSS sg13_lv_nmos L=0.13u W=0.15u AS=0.1005p AD=0.1005p PS=1.34u PD=1.34u
M$1254 A|VIN|VOUT$1 VIN|VOUT$137 VBN|VSS VBN|VSS sg13_lv_nmos L=0.13u W=0.15u
+ AS=0.1005p AD=0.1005p PS=1.34u PD=1.34u
M$1255 VIN|VOUT$137 VIN|VOUT$133 VBN|VSS VBN|VSS sg13_lv_nmos L=0.13u W=0.15u
+ AS=0.1005p AD=0.1005p PS=1.34u PD=1.34u
M$1256 VBN|VSS PH0|PHOUT|VIN|VOUT PH1|PHOUT|VIN|VOUT VBN|VSS sg13_lv_nmos
+ L=0.13u W=0.6u AS=0.312p AD=0.312p PS=4.16u PD=4.16u
M$1260 VBN|VSS PH1|PHOUT|VIN|VOUT PH0|PHOUT|VIN|VOUT VBN|VSS sg13_lv_nmos
+ L=0.13u W=0.3u AS=0.156p AD=0.156p PS=2.08u PD=2.08u
M$1262 VIN|VOUT$139 SQ[1]|VIN|VOUT|VS|VSN|VSP|VS[1] VIN|VOUT$138 VBN|VSS
+ sg13_lv_nmos L=0.13u W=0.15u AS=0.1005p AD=0.1005p PS=1.34u PD=1.34u
M$1263 VIN|VOUT$139 VOUT|VSN|VSP$54 VIN|VOUT$138 VBN|VSS sg13_lv_nmos L=0.13u
+ W=0.3u AS=0.201p AD=0.201p PS=2.68u PD=2.68u
M$1264 VBN|VSS \$4278 VOUT|VSN|VSP$54 VBN|VSS sg13_lv_nmos L=0.13u W=0.15u
+ AS=0.1005p AD=0.1005p PS=1.34u PD=1.34u
M$1266 VIN|VOUT$138 VOUT|VSN|VSP$55 VIN|VINB|VOUT$6 VBN|VSS sg13_lv_nmos
+ L=0.13u W=0.15u AS=0.1005p AD=0.1005p PS=1.34u PD=1.34u
M$1267 VBN|VSS VIN|VOUT$134 PH0|PHOUT|VIN|VOUT VBN|VSS sg13_lv_nmos L=0.13u
+ W=0.6u AS=0.312p AD=0.312p PS=4.16u PD=4.16u
M$1287 VBN|VSS PH270|VIN|VINB|VIND|VINQB|VOUT VIN|VOUT$139 VBN|VSS sg13_lv_nmos
+ L=0.13u W=0.3u AS=0.156p AD=0.156p PS=2.08u PD=2.08u
M$1289 VBN|VSS VIN|VOUT$140 VIN|VOUT$133 VBN|VSS sg13_lv_nmos L=0.13u W=1.2u
+ AS=0.624p AD=0.624p PS=8.32u PD=8.32u
M$1297 VBN|VSS VIN|VOUT$141 VIN|VOUT$140 VBN|VSS sg13_lv_nmos L=0.13u W=0.6u
+ AS=0.312p AD=0.312p PS=4.16u PD=4.16u
M$1301 VBN|VSS VIN|VOUT$142 VIN|VOUT$141 VBN|VSS sg13_lv_nmos L=0.13u W=0.3u
+ AS=0.156p AD=0.156p PS=2.08u PD=2.08u
M$1303 VIN|VOUT$142 B|S[3]|VDD|VIN|VSP|VS[3] VBN|VSS VBN|VSS sg13_lv_nmos
+ L=0.13u W=0.15u AS=0.1005p AD=0.1005p PS=1.34u PD=1.34u
M$1304 VOUT|VSN|VSS$3 B|OUT|ST[5]|VDD|VIN|VSP VBN|VSS VBN|VSS sg13_lv_nmos
+ L=0.13u W=0.15u AS=0.1005p AD=0.1005p PS=1.34u PD=1.34u
M$1305 A|VIN|VOUT$2 VOUT|VSN|VSS$3 STQ[5]|VIN|VOUT|VS|VSN|VSP|VST|VST[5]
+ VBN|VSS sg13_lv_nmos L=0.13u W=0.15u AS=0.1005p AD=0.1005p PS=1.34u PD=1.34u
M$1306 STQ[5]|VIN|VOUT|VS|VSN|VSP|VST|VST[5] A|VIN|VOUT$2 VOUT|VSN|VSS$3
+ VBN|VSS sg13_lv_nmos L=0.13u W=0.15u AS=0.1005p AD=0.1005p PS=1.34u PD=1.34u
M$1307 A|VIN|VOUT$2 VIN|VOUT$143 VBN|VSS VBN|VSS sg13_lv_nmos L=0.13u W=0.15u
+ AS=0.1005p AD=0.1005p PS=1.34u PD=1.34u
M$1308 VIN|VOUT$143 VIN|VOUT$133 VBN|VSS VBN|VSS sg13_lv_nmos L=0.13u W=0.15u
+ AS=0.1005p AD=0.1005p PS=1.34u PD=1.34u
M$1309 VBN|VSS SQ[1]|VIN|VOUT|VS|VSN|VSP|VS[1] VOUT|VSN|VSP$56 VBN|VSS
+ sg13_lv_nmos L=0.13u W=0.15u AS=0.1005p AD=0.1005p PS=1.34u PD=1.34u
M$1310 VIN|VOUT$144 VOUT|VSN|VSP$56 VIN|VOUT$145 VBN|VSS sg13_lv_nmos L=0.13u
+ W=0.3u AS=0.201p AD=0.201p PS=2.68u PD=2.68u
M$1312 VBN|VSS \$4450 \$4450 VBN|VSS sg13_lv_nmos L=0.13u W=0.15u AS=0.1005p
+ AD=0.1005p PS=1.34u PD=1.34u
M$1313 VIN|VOUT$144 VOUT|VSN|VSP$54 VIN|VOUT$145 VBN|VSS sg13_lv_nmos L=0.13u
+ W=0.15u AS=0.1005p AD=0.1005p PS=1.34u PD=1.34u
M$1314 VIN|VOUT$145 VOUT|VSN|VSP$55 VIN|VINB|VOUT$6 VBN|VSS sg13_lv_nmos
+ L=0.13u W=0.15u AS=0.1005p AD=0.1005p PS=1.34u PD=1.34u
M$1315 VIN|VOUT$146 STQ[1]|VIN|VOUT|VS|VSN|VSP|VST|VST[1] VIN|VOUT$147 VBN|VSS
+ sg13_lv_nmos L=0.13u W=0.15u AS=0.1005p AD=0.1005p PS=1.34u PD=1.34u
M$1316 VIN|VOUT$146 VOUT|VSN|VSP$57 VIN|VOUT$147 VBN|VSS sg13_lv_nmos L=0.13u
+ W=0.3u AS=0.201p AD=0.201p PS=2.68u PD=2.68u
M$1317 VBN|VSS \$4474 VOUT|VSN|VSP$57 VBN|VSS sg13_lv_nmos L=0.13u W=0.15u
+ AS=0.1005p AD=0.1005p PS=1.34u PD=1.34u
M$1319 VIN|VOUT$147 VOUT|VSN|VSP$59 VIN|VOUT$4 VBN|VSS sg13_lv_nmos L=0.13u
+ W=0.15u AS=0.1005p AD=0.1005p PS=1.34u PD=1.34u
M$1320 VBN|VSS PH0|PH1|V1|VIN|VOUT|VOUTDN VIN|VOUT$134 VBN|VSS sg13_lv_nmos
+ L=0.13u W=0.6u AS=0.312p AD=0.312p PS=4.16u PD=4.16u
M$1324 VBN|VSS PH0|PHOUT|VIN|VOUT VIN|VOUT$148 VBN|VSS sg13_lv_nmos L=0.13u
+ W=0.6u AS=0.312p AD=0.312p PS=4.16u PD=4.16u
M$1328 VBN|VSS VIN|VOUT$148 VIN|VOUT$156 VBN|VSS sg13_lv_nmos L=0.13u W=1.2u
+ AS=0.624p AD=0.624p PS=8.32u PD=8.32u
M$1336 VBN|VSS VIN|VOUT$149 VIN|VOUT$150 VBN|VSS sg13_lv_nmos L=0.13u W=4.8u
+ AS=2.496p AD=2.496p PS=33.28u PD=33.28u
M$1352 VBN|VSS VIN|VOUT$150 VIN|VOUT$135 VBN|VSS sg13_lv_nmos L=0.13u W=4.8u
+ AS=2.496p AD=2.496p PS=33.28u PD=33.28u
M$1384 VBN|VSS PH90|VIN|VINA|VINC|VINQ|VOUT VIN|VOUT$144 VBN|VSS sg13_lv_nmos
+ L=0.13u W=0.3u AS=0.156p AD=0.156p PS=2.08u PD=2.08u
M$1386 VIN|VOUT$154 SQ[0]|VIN|VOUT|VS|VSN|VSP|VS[0] VIN|VOUT$152 VBN|VSS
+ sg13_lv_nmos L=0.13u W=0.15u AS=0.1005p AD=0.1005p PS=1.34u PD=1.34u
M$1387 VIN|VOUT$154 VOUT|VSN|VSP$60 VIN|VOUT$152 VBN|VSS sg13_lv_nmos L=0.13u
+ W=0.3u AS=0.201p AD=0.201p PS=2.68u PD=2.68u
M$1388 VBN|VSS \$4685 VOUT|VSN|VSP$60 VBN|VSS sg13_lv_nmos L=0.13u W=0.15u
+ AS=0.1005p AD=0.1005p PS=1.34u PD=1.34u
M$1390 VIN|VOUT$152 VOUT|VSN|VSP$61 VIN|VINA|VOUT$6 VBN|VSS sg13_lv_nmos
+ L=0.13u W=0.15u AS=0.1005p AD=0.1005p PS=1.34u PD=1.34u
M$1391 VBN|VSS STQ[1]|VIN|VOUT|VS|VSN|VSP|VST|VST[1] VOUT|VSN|VSP$58 VBN|VSS
+ sg13_lv_nmos L=0.13u W=0.15u AS=0.1005p AD=0.1005p PS=1.34u PD=1.34u
M$1392 VBN|VSS VIN|VINB|VOUT$6 VIN|VOUT$146 VBN|VSS sg13_lv_nmos L=0.13u W=0.3u
+ AS=0.156p AD=0.156p PS=2.08u PD=2.08u
M$1394 VIN|VOUT$155 VOUT|VSN|VSP$58 VIN|VOUT$153 VBN|VSS sg13_lv_nmos L=0.13u
+ W=0.3u AS=0.201p AD=0.201p PS=2.68u PD=2.68u
M$1396 VBN|VSS \$4608 \$4608 VBN|VSS sg13_lv_nmos L=0.13u W=0.15u AS=0.1005p
+ AD=0.1005p PS=1.34u PD=1.34u
M$1397 VIN|VOUT$155 VOUT|VSN|VSP$57 VIN|VOUT$153 VBN|VSS sg13_lv_nmos L=0.13u
+ W=0.15u AS=0.1005p AD=0.1005p PS=1.34u PD=1.34u
M$1398 VIN|VOUT$153 VOUT|VSN|VSP$59 VIN|VOUT$4 VBN|VSS sg13_lv_nmos L=0.13u
+ W=0.15u AS=0.1005p AD=0.1005p PS=1.34u PD=1.34u
M$1399 VOUT|VSN|VSS$4 B|ST[4]|VDD|VIN|VOUT|VSP VBN|VSS VBN|VSS sg13_lv_nmos
+ L=0.13u W=0.15u AS=0.1005p AD=0.1005p PS=1.34u PD=1.34u
M$1400 A|VIN|VOUT$3 VOUT|VSN|VSS$4 STQ[4]|VIN|VOUT|VS|VSN|VSP|VST|VST[4]
+ VBN|VSS sg13_lv_nmos L=0.13u W=0.15u AS=0.1005p AD=0.1005p PS=1.34u PD=1.34u
M$1401 STQ[4]|VIN|VOUT|VS|VSN|VSP|VST|VST[4] A|VIN|VOUT$3 VOUT|VSN|VSS$4
+ VBN|VSS sg13_lv_nmos L=0.13u W=0.15u AS=0.1005p AD=0.1005p PS=1.34u PD=1.34u
M$1402 A|VIN|VOUT$3 VIN|VOUT$151 VBN|VSS VBN|VSS sg13_lv_nmos L=0.13u W=0.15u
+ AS=0.1005p AD=0.1005p PS=1.34u PD=1.34u
M$1403 VIN|VOUT$151 VIN|VOUT$133 VBN|VSS VBN|VSS sg13_lv_nmos L=0.13u W=0.15u
+ AS=0.1005p AD=0.1005p PS=1.34u PD=1.34u
M$1404 VBN|VSS VIN|VOUT$156 VIN|VOUT$149 VBN|VSS sg13_lv_nmos L=0.13u W=2.4u
+ AS=1.248p AD=1.248p PS=16.64u PD=16.64u
M$1468 VBN|VSS SQ[0]|VIN|VOUT|VS|VSN|VSP|VS[0] VOUT|VSN|VSP$62 VBN|VSS
+ sg13_lv_nmos L=0.13u W=0.15u AS=0.1005p AD=0.1005p PS=1.34u PD=1.34u
M$1469 VBN|VSS PH180|VIN|VINB|VINIB|VOUT VIN|VOUT$154 VBN|VSS sg13_lv_nmos
+ L=0.13u W=0.3u AS=0.156p AD=0.156p PS=2.08u PD=2.08u
M$1471 VBN|VSS PH0|VIN|VINA|VINI|VOUT VIN|VOUT$159 VBN|VSS sg13_lv_nmos L=0.13u
+ W=0.3u AS=0.156p AD=0.156p PS=2.08u PD=2.08u
M$1473 VIN|VOUT$159 VOUT|VSN|VSP$62 VIN|VOUT$158 VBN|VSS sg13_lv_nmos L=0.13u
+ W=0.3u AS=0.201p AD=0.201p PS=2.68u PD=2.68u
M$1475 VBN|VSS \$4761 \$4761 VBN|VSS sg13_lv_nmos L=0.13u W=0.15u AS=0.1005p
+ AD=0.1005p PS=1.34u PD=1.34u
M$1476 VIN|VOUT$159 VOUT|VSN|VSP$60 VIN|VOUT$158 VBN|VSS sg13_lv_nmos L=0.13u
+ W=0.15u AS=0.1005p AD=0.1005p PS=1.34u PD=1.34u
M$1477 VIN|VOUT$158 VOUT|VSN|VSP$61 VIN|VINA|VOUT$6 VBN|VSS sg13_lv_nmos
+ L=0.13u W=0.15u AS=0.1005p AD=0.1005p PS=1.34u PD=1.34u
M$1478 VBN|VSS VIN|VINA|VOUT$6 VIN|VOUT$155 VBN|VSS sg13_lv_nmos L=0.13u W=0.3u
+ AS=0.156p AD=0.156p PS=2.08u PD=2.08u
M$1480 VOUT|VSN|VSS$5 B|OUT|ST[3]|VDD|VIN|VSP VBN|VSS VBN|VSS sg13_lv_nmos
+ L=0.13u W=0.15u AS=0.1005p AD=0.1005p PS=1.34u PD=1.34u
M$1481 A|VIN|VOUT$4 VOUT|VSN|VSS$5 STQ[3]|VIN|VOUT|VS|VSN|VSP|VST|VST[3]
+ VBN|VSS sg13_lv_nmos L=0.13u W=0.15u AS=0.1005p AD=0.1005p PS=1.34u PD=1.34u
M$1482 STQ[3]|VIN|VOUT|VS|VSN|VSP|VST|VST[3] A|VIN|VOUT$4 VOUT|VSN|VSS$5
+ VBN|VSS sg13_lv_nmos L=0.13u W=0.15u AS=0.1005p AD=0.1005p PS=1.34u PD=1.34u
M$1483 A|VIN|VOUT$4 VIN|VOUT$157 VBN|VSS VBN|VSS sg13_lv_nmos L=0.13u W=0.15u
+ AS=0.1005p AD=0.1005p PS=1.34u PD=1.34u
M$1484 VIN|VOUT$157 VIN|VOUT$133 VBN|VSS VBN|VSS sg13_lv_nmos L=0.13u W=0.15u
+ AS=0.1005p AD=0.1005p PS=1.34u PD=1.34u
M$1485 VIN|VOUT$162 SQ[1]|VIN|VOUT|VS|VSN|VSP|VS[1] VIN|VOUT$161 VBN|VSS
+ sg13_lv_nmos L=0.13u W=0.15u AS=0.1005p AD=0.1005p PS=1.34u PD=1.34u
M$1486 VIN|VOUT$162 VOUT|VSN|VSP$63 VIN|VOUT$161 VBN|VSS sg13_lv_nmos L=0.13u
+ W=0.3u AS=0.201p AD=0.201p PS=2.68u PD=2.68u
M$1487 VBN|VSS \$4938 VOUT|VSN|VSP$63 VBN|VSS sg13_lv_nmos L=0.13u W=0.15u
+ AS=0.1005p AD=0.1005p PS=1.34u PD=1.34u
M$1489 VIN|VOUT$161 VOUT|VSN|VSP$65 VIN|VINB|VOUT$7 VBN|VSS sg13_lv_nmos
+ L=0.13u W=0.15u AS=0.1005p AD=0.1005p PS=1.34u PD=1.34u
M$1490 VOUT|VSN|VSS$6 B|OUT|ST[2]|VDD|VIN|VSP VBN|VSS VBN|VSS sg13_lv_nmos
+ L=0.13u W=0.15u AS=0.1005p AD=0.1005p PS=1.34u PD=1.34u
M$1491 A|VIN|VOUT$5 VOUT|VSN|VSS$6 STQ[2]|VIN|VOUT|VS|VSN|VSP|VST|VST[2]
+ VBN|VSS sg13_lv_nmos L=0.13u W=0.15u AS=0.1005p AD=0.1005p PS=1.34u PD=1.34u
M$1492 STQ[2]|VIN|VOUT|VS|VSN|VSP|VST|VST[2] A|VIN|VOUT$5 VOUT|VSN|VSS$6
+ VBN|VSS sg13_lv_nmos L=0.13u W=0.15u AS=0.1005p AD=0.1005p PS=1.34u PD=1.34u
M$1493 A|VIN|VOUT$5 VIN|VOUT$160 VBN|VSS VBN|VSS sg13_lv_nmos L=0.13u W=0.15u
+ AS=0.1005p AD=0.1005p PS=1.34u PD=1.34u
M$1494 VIN|VOUT$160 VIN|VOUT$133 VBN|VSS VBN|VSS sg13_lv_nmos L=0.13u W=0.15u
+ AS=0.1005p AD=0.1005p PS=1.34u PD=1.34u
M$1495 VBN|VSS A|B|VOUT B|OUT|ST[1]|VDD|VIN|VSP VBN|VSS sg13_lv_nmos L=0.13u
+ W=0.15u AS=0.1005p AD=0.0555p PS=1.34u PD=0.74u
M$1496 B|OUT|ST[1]|VDD|VIN|VSP A|B|VOUT$1 VBN|VSS VBN|VSS sg13_lv_nmos L=0.13u
+ W=0.15u AS=0.0555p AD=0.0555p PS=0.74u PD=0.74u
M$1497 VBN|VSS B|C|VIN|VOUT B|OUT|ST[1]|VDD|VIN|VSP VBN|VSS sg13_lv_nmos
+ L=0.13u W=0.15u AS=0.0555p AD=0.1005p PS=0.74u PD=1.34u
M$1498 VBN|VSS B|C|VIN|VOUT B|OUT|ST[2]|VDD|VIN|VSP VBN|VSS sg13_lv_nmos
+ L=0.13u W=0.15u AS=0.1005p AD=0.0555p PS=1.34u PD=0.74u
M$1499 B|OUT|ST[2]|VDD|VIN|VSP A|B|VOUT$1 VBN|VSS VBN|VSS sg13_lv_nmos L=0.13u
+ W=0.15u AS=0.0555p AD=0.1005p PS=0.74u PD=1.34u
M$1500 VBN|VSS B|C|VIN|VOUT B|OUT|ST[3]|VDD|VIN|VSP VBN|VSS sg13_lv_nmos
+ L=0.13u W=0.15u AS=0.1005p AD=0.0555p PS=1.34u PD=0.74u
M$1501 B|OUT|ST[3]|VDD|VIN|VSP A|OUT|VOUT VBN|VSS VBN|VSS sg13_lv_nmos L=0.13u
+ W=0.15u AS=0.0555p AD=0.1005p PS=0.74u PD=1.34u
M$1502 B|ST[4]|VDD|VIN|VOUT|VSP B|C|VIN|VOUT VBN|VSS VBN|VSS sg13_lv_nmos
+ L=0.13u W=0.15u AS=0.1005p AD=0.1005p PS=1.34u PD=1.34u
M$1503 VBN|VSS B|C|VIN|VOUT \$4811 VBN|VSS sg13_lv_nmos L=0.13u W=0.15u
+ AS=0.1005p AD=0.0555p PS=1.34u PD=0.74u
M$1504 \$4811 A|OUT|VOUT$1 B|OUT|ST[5]|VDD|VIN|VSP VBN|VSS sg13_lv_nmos L=0.13u
+ W=0.15u AS=0.0555p AD=0.1005p PS=0.74u PD=1.34u
M$1505 B|OUT|ST[6]|VDD|VIN|VSP A|B|VOUT$1 \$4812 VBN|VSS sg13_lv_nmos L=0.13u
+ W=0.15u AS=0.1005p AD=0.0555p PS=1.34u PD=0.74u
M$1506 \$4812 B|C|VIN|VOUT VBN|VSS VBN|VSS sg13_lv_nmos L=0.13u W=0.15u
+ AS=0.0555p AD=0.1005p PS=0.74u PD=1.34u
M$1507 VBN|VSS B|C|VIN|VOUT \$4813 VBN|VSS sg13_lv_nmos L=0.13u W=0.15u
+ AS=0.1005p AD=0.0555p PS=1.34u PD=0.74u
M$1508 \$4813 A|B|VOUT$1 \$4814 VBN|VSS sg13_lv_nmos L=0.13u W=0.15u AS=0.0555p
+ AD=0.0555p PS=0.74u PD=0.74u
M$1509 \$4814 A|B|VOUT B|OUT|ST[7]|VDD|VIN|VSP VBN|VSS sg13_lv_nmos L=0.13u
+ W=0.15u AS=0.0555p AD=0.1005p PS=0.74u PD=1.34u
M$1510 VBN|VSS PH270|VIN|VINB|VIND|VINQB|VOUT VIN|VOUT$162 VBN|VSS sg13_lv_nmos
+ L=0.13u W=0.3u AS=0.156p AD=0.156p PS=2.08u PD=2.08u
M$1512 VOUT|VSN|VSS$7 B|OUT|ST[1]|VDD|VIN|VSP VBN|VSS VBN|VSS sg13_lv_nmos
+ L=0.13u W=0.15u AS=0.1005p AD=0.1005p PS=1.34u PD=1.34u
M$1513 A|VIN|VOUT$6 VOUT|VSN|VSS$7 STQ[1]|VIN|VOUT|VS|VSN|VSP|VST|VST[1]
+ VBN|VSS sg13_lv_nmos L=0.13u W=0.15u AS=0.1005p AD=0.1005p PS=1.34u PD=1.34u
M$1514 STQ[1]|VIN|VOUT|VS|VSN|VSP|VST|VST[1] A|VIN|VOUT$6 VOUT|VSN|VSS$7
+ VBN|VSS sg13_lv_nmos L=0.13u W=0.15u AS=0.1005p AD=0.1005p PS=1.34u PD=1.34u
M$1515 A|VIN|VOUT$6 VIN|VOUT$163 VBN|VSS VBN|VSS sg13_lv_nmos L=0.13u W=0.15u
+ AS=0.1005p AD=0.1005p PS=1.34u PD=1.34u
M$1516 VIN|VOUT$163 VIN|VOUT$133 VBN|VSS VBN|VSS sg13_lv_nmos L=0.13u W=0.15u
+ AS=0.1005p AD=0.1005p PS=1.34u PD=1.34u
M$1517 A|OUT|VOUT OUT|VIN VBN|VSS VBN|VSS sg13_lv_nmos L=0.13u W=0.15u
+ AS=0.1005p AD=0.1005p PS=1.34u PD=1.34u
M$1518 VBN|VSS A|B|VOUT \$5066 VBN|VSS sg13_lv_nmos L=0.13u W=0.15u AS=0.1005p
+ AD=0.0555p PS=1.34u PD=0.74u
M$1519 \$5066 A|B|VOUT$1 OUT|VIN VBN|VSS sg13_lv_nmos L=0.13u W=0.15u
+ AS=0.0555p AD=0.1005p PS=0.74u PD=1.34u
M$1520 A|OUT|VOUT$1 OUT|VIN$1 VBN|VSS VBN|VSS sg13_lv_nmos L=0.13u W=0.15u
+ AS=0.1005p AD=0.1005p PS=1.34u PD=1.34u
M$1521 VBN|VSS A|B|VOUT$1 OUT|VIN$1 VBN|VSS sg13_lv_nmos L=0.13u W=0.15u
+ AS=0.1005p AD=0.0555p PS=1.34u PD=0.74u
M$1522 OUT|VIN$1 A|B|VOUT VBN|VSS VBN|VSS sg13_lv_nmos L=0.13u W=0.15u
+ AS=0.0555p AD=0.1005p PS=0.74u PD=1.34u
M$1523 VBN|VSS SQ[1]|VIN|VOUT|VS|VSN|VSP|VS[1] VOUT|VSN|VSP$64 VBN|VSS
+ sg13_lv_nmos L=0.13u W=0.15u AS=0.1005p AD=0.1005p PS=1.34u PD=1.34u
M$1524 VBN|VSS PH90|VIN|VINA|VINC|VINQ|VOUT VIN|VOUT$167 VBN|VSS sg13_lv_nmos
+ L=0.13u W=0.3u AS=0.156p AD=0.156p PS=2.08u PD=2.08u
M$1526 VIN|VOUT$167 VOUT|VSN|VSP$64 VIN|VOUT$165 VBN|VSS sg13_lv_nmos L=0.13u
+ W=0.3u AS=0.201p AD=0.201p PS=2.68u PD=2.68u
M$1528 VBN|VSS \$5128 \$5128 VBN|VSS sg13_lv_nmos L=0.13u W=0.15u AS=0.1005p
+ AD=0.1005p PS=1.34u PD=1.34u
M$1529 VIN|VOUT$167 VOUT|VSN|VSP$63 VIN|VOUT$165 VBN|VSS sg13_lv_nmos L=0.13u
+ W=0.15u AS=0.1005p AD=0.1005p PS=1.34u PD=1.34u
M$1530 VIN|VOUT$165 VOUT|VSN|VSP$65 VIN|VINB|VOUT$7 VBN|VSS sg13_lv_nmos
+ L=0.13u W=0.15u AS=0.1005p AD=0.1005p PS=1.34u PD=1.34u
M$1531 VBN|VSS VIN|VINB|VOUT$7 VIN|VOUT$166 VBN|VSS sg13_lv_nmos L=0.13u W=0.3u
+ AS=0.156p AD=0.156p PS=2.08u PD=2.08u
M$1533 VIN|VOUT$166 SQ[2]|VIN|VOUT|VS|VSN|VSP|VST|VST[0] VIN|VOUT$164 VBN|VSS
+ sg13_lv_nmos L=0.13u W=0.15u AS=0.1005p AD=0.1005p PS=1.34u PD=1.34u
M$1534 VIN|VOUT$166 VOUT|VSN|VSP$66 VIN|VOUT$164 VBN|VSS sg13_lv_nmos L=0.13u
+ W=0.3u AS=0.201p AD=0.201p PS=2.68u PD=2.68u
M$1535 VBN|VSS \$5209 VOUT|VSN|VSP$66 VBN|VSS sg13_lv_nmos L=0.13u W=0.15u
+ AS=0.1005p AD=0.1005p PS=1.34u PD=1.34u
M$1537 VIN|VOUT$164 VOUT|VSN|VSP$68 VIN|VOUT$4 VBN|VSS sg13_lv_nmos L=0.13u
+ W=0.15u AS=0.1005p AD=0.1005p PS=1.34u PD=1.34u
M$1538 VBN|VSS S[2]|VIN|VS[2] B|C|VIN|VOUT VBN|VSS sg13_lv_nmos L=0.13u W=0.15u
+ AS=0.1005p AD=0.1005p PS=1.34u PD=1.34u
M$1539 VBN|VSS S[1]|VIN|VS[1] A|B|VOUT$1 VBN|VSS sg13_lv_nmos L=0.13u W=0.15u
+ AS=0.1005p AD=0.1005p PS=1.34u PD=1.34u
M$1540 VBN|VSS S[0]|VIN|VS[0] A|B|VOUT VBN|VSS sg13_lv_nmos L=0.13u W=0.15u
+ AS=0.1005p AD=0.1005p PS=1.34u PD=1.34u
M$1541 VBN|VSS PH180|VIN|VINB|VINIB|VOUT VIN|VOUT$171 VBN|VSS sg13_lv_nmos
+ L=0.13u W=0.3u AS=0.156p AD=0.156p PS=2.08u PD=2.08u
M$1543 VIN|VOUT$171 SQ[0]|VIN|VOUT|VS|VSN|VSP|VS[0] VIN|VOUT$168 VBN|VSS
+ sg13_lv_nmos L=0.13u W=0.15u AS=0.1005p AD=0.1005p PS=1.34u PD=1.34u
M$1544 VIN|VOUT$171 VOUT|VSN|VSP$69 VIN|VOUT$168 VBN|VSS sg13_lv_nmos L=0.13u
+ W=0.3u AS=0.201p AD=0.201p PS=2.68u PD=2.68u
M$1545 VBN|VSS \$5273 VOUT|VSN|VSP$69 VBN|VSS sg13_lv_nmos L=0.13u W=0.15u
+ AS=0.1005p AD=0.1005p PS=1.34u PD=1.34u
M$1547 VIN|VOUT$168 VOUT|VSN|VSP$71 VIN|VINA|VOUT$7 VBN|VSS sg13_lv_nmos
+ L=0.13u W=0.15u AS=0.1005p AD=0.1005p PS=1.34u PD=1.34u
M$1548 VBN|VSS SQ[2]|VIN|VOUT|VS|VSN|VSP|VST|VST[0] VOUT|VSN|VSP$67 VBN|VSS
+ sg13_lv_nmos L=0.13u W=0.15u AS=0.1005p AD=0.1005p PS=1.34u PD=1.34u
M$1549 VBN|VSS VIN|VINA|VOUT$7 VIN|VOUT$169 VBN|VSS sg13_lv_nmos L=0.13u W=0.3u
+ AS=0.156p AD=0.156p PS=2.08u PD=2.08u
M$1551 VIN|VOUT$169 VOUT|VSN|VSP$67 VIN|VOUT$170 VBN|VSS sg13_lv_nmos L=0.13u
+ W=0.3u AS=0.201p AD=0.201p PS=2.68u PD=2.68u
M$1553 VBN|VSS \$5233 \$5233 VBN|VSS sg13_lv_nmos L=0.13u W=0.15u AS=0.1005p
+ AD=0.1005p PS=1.34u PD=1.34u
M$1554 VIN|VOUT$169 VOUT|VSN|VSP$66 VIN|VOUT$170 VBN|VSS sg13_lv_nmos L=0.13u
+ W=0.15u AS=0.1005p AD=0.1005p PS=1.34u PD=1.34u
M$1555 VIN|VOUT$170 VOUT|VSN|VSP$68 VIN|VOUT$4 VBN|VSS sg13_lv_nmos L=0.13u
+ W=0.15u AS=0.1005p AD=0.1005p PS=1.34u PD=1.34u
M$1556 VBN|VSS SQ[0]|VIN|VOUT|VS|VSN|VSP|VS[0] VOUT|VSN|VSP$70 VBN|VSS
+ sg13_lv_nmos L=0.13u W=0.15u AS=0.1005p AD=0.1005p PS=1.34u PD=1.34u
M$1557 VBN|VSS PH0|VIN|VINA|VINI|VOUT VIN|VOUT$172 VBN|VSS sg13_lv_nmos L=0.13u
+ W=0.3u AS=0.156p AD=0.156p PS=2.08u PD=2.08u
M$1559 VIN|VOUT$172 VOUT|VSN|VSP$70 VIN|VOUT$173 VBN|VSS sg13_lv_nmos L=0.13u
+ W=0.3u AS=0.201p AD=0.201p PS=2.68u PD=2.68u
M$1561 VBN|VSS \$5316 \$5316 VBN|VSS sg13_lv_nmos L=0.13u W=0.15u AS=0.1005p
+ AD=0.1005p PS=1.34u PD=1.34u
M$1562 VIN|VOUT$172 VOUT|VSN|VSP$69 VIN|VOUT$173 VBN|VSS sg13_lv_nmos L=0.13u
+ W=0.15u AS=0.1005p AD=0.1005p PS=1.34u PD=1.34u
M$1563 VIN|VOUT$173 VOUT|VSN|VSP$71 VIN|VINA|VOUT$7 VBN|VSS sg13_lv_nmos
+ L=0.13u W=0.15u AS=0.1005p AD=0.1005p PS=1.34u PD=1.34u
M$1564 VBP|VDD PH270|VIN|VINB|VIND|VINQB|VOUT VIN|VOUT VBP|VDD sg13_lv_pmos
+ L=0.13u W=0.45u AS=0.2115p AD=0.2115p PS=2.82u PD=2.82u
M$1567 VIN|VOUT VOUT|VSN|VSP$1 VIN|VOUT$1 VBP|VDD sg13_lv_pmos L=0.13u W=0.3u
+ AS=0.156p AD=0.156p PS=2.08u PD=2.08u
M$1569 VIN|VOUT VOUT|VSN|VSP$2 VIN|VOUT$1 VBP|VDD sg13_lv_pmos L=0.13u W=0.6u
+ AS=0.312p AD=0.312p PS=4.16u PD=4.16u
M$1571 VBP|VDD \$16 \$16 VBP|VDD sg13_lv_pmos L=0.13u W=0.15u AS=0.1005p
+ AD=0.1005p PS=1.34u PD=1.34u
M$1574 VIN|VOUT$1 VOUT|VSN|VSP VIN|VINB|VOUT VBP|VDD sg13_lv_pmos L=0.13u
+ W=0.3u AS=0.156p AD=0.156p PS=2.08u PD=2.08u
M$1576 VBP|VDD SQ[1]|VIN|VOUT|VS|VSN|VSP|VS[1] VOUT|VSN|VSP$1 VBP|VDD
+ sg13_lv_pmos L=0.13u W=0.15u AS=0.1005p AD=0.1005p PS=1.34u PD=1.34u
M$1577 VBP|VDD PH90|VIN|VINA|VINC|VINQ|VOUT VIN|VOUT$5 VBP|VDD sg13_lv_pmos
+ L=0.13u W=0.45u AS=0.2115p AD=0.2115p PS=2.82u PD=2.82u
M$1580 VIN|VOUT$5 SQ[1]|VIN|VOUT|VS|VSN|VSP|VS[1] VIN|VOUT$2 VBP|VDD
+ sg13_lv_pmos L=0.13u W=0.6u AS=0.312p AD=0.312p PS=4.16u PD=4.16u
M$1584 VBP|VDD \$24 VOUT|VSN|VSP$2 VBP|VDD sg13_lv_pmos L=0.13u W=0.15u
+ AS=0.1005p AD=0.1005p PS=1.34u PD=1.34u
M$1585 VIN|VOUT$5 VOUT|VSN|VSP$2 VIN|VOUT$2 VBP|VDD sg13_lv_pmos L=0.13u W=0.3u
+ AS=0.156p AD=0.156p PS=2.08u PD=2.08u
M$1587 VIN|VOUT$2 VOUT|VSN|VSP VIN|VINB|VOUT VBP|VDD sg13_lv_pmos L=0.13u
+ W=0.3u AS=0.156p AD=0.156p PS=2.08u PD=2.08u
M$1589 VBP|VDD VIN|VINB|VOUT VIN|VOUT$6 VBP|VDD sg13_lv_pmos L=0.13u W=0.45u
+ AS=0.2115p AD=0.2115p PS=2.82u PD=2.82u
M$1592 VIN|VOUT$6 VOUT|VSN|VSP$4 VIN|VOUT$3 VBP|VDD sg13_lv_pmos L=0.13u W=0.3u
+ AS=0.156p AD=0.156p PS=2.08u PD=2.08u
M$1594 VIN|VOUT$6 VOUT|VSN|VSP$5 VIN|VOUT$3 VBP|VDD sg13_lv_pmos L=0.13u W=0.6u
+ AS=0.312p AD=0.312p PS=4.16u PD=4.16u
M$1596 VBP|VDD \$50 \$50 VBP|VDD sg13_lv_pmos L=0.13u W=0.15u AS=0.1005p
+ AD=0.1005p PS=1.34u PD=1.34u
M$1599 VIN|VOUT$3 VOUT|VSN|VSP$3 VIN|VOUT$4 VBP|VDD sg13_lv_pmos L=0.13u W=0.3u
+ AS=0.156p AD=0.156p PS=2.08u PD=2.08u
M$1601 VBP|VDD PH180|VIN|VINB|VINIB|VOUT VIN|VOUT$9 VBP|VDD sg13_lv_pmos
+ L=0.13u W=0.45u AS=0.2115p AD=0.2115p PS=2.82u PD=2.82u
M$1604 VIN|VOUT$9 VOUT|VSN|VSP$7 VIN|VOUT$7 VBP|VDD sg13_lv_pmos L=0.13u W=0.3u
+ AS=0.156p AD=0.156p PS=2.08u PD=2.08u
M$1606 VIN|VOUT$9 VOUT|VSN|VSP$8 VIN|VOUT$7 VBP|VDD sg13_lv_pmos L=0.13u W=0.6u
+ AS=0.312p AD=0.312p PS=4.16u PD=4.16u
M$1608 VBP|VDD \$97 \$97 VBP|VDD sg13_lv_pmos L=0.13u W=0.15u AS=0.1005p
+ AD=0.1005p PS=1.34u PD=1.34u
M$1611 VIN|VOUT$7 VOUT|VSN|VSP$6 VIN|VINA|VOUT VBP|VDD sg13_lv_pmos L=0.13u
+ W=0.3u AS=0.156p AD=0.156p PS=2.08u PD=2.08u
M$1613 VBP|VDD STQ[7]|VIN|VOUT|VS|VSN|VSP|VST|VST[7] VOUT|VSN|VSP$4 VBP|VDD
+ sg13_lv_pmos L=0.13u W=0.15u AS=0.1005p AD=0.1005p PS=1.34u PD=1.34u
M$1614 VBP|VDD VIN|VINA|VOUT VIN|VOUT$10 VBP|VDD sg13_lv_pmos L=0.13u W=0.45u
+ AS=0.2115p AD=0.2115p PS=2.82u PD=2.82u
M$1617 VIN|VOUT$10 STQ[7]|VIN|VOUT|VS|VSN|VSP|VST|VST[7] VIN|VOUT$8 VBP|VDD
+ sg13_lv_pmos L=0.13u W=0.6u AS=0.312p AD=0.312p PS=4.16u PD=4.16u
M$1621 VBP|VDD \$74 VOUT|VSN|VSP$5 VBP|VDD sg13_lv_pmos L=0.13u W=0.15u
+ AS=0.1005p AD=0.1005p PS=1.34u PD=1.34u
M$1622 VIN|VOUT$10 VOUT|VSN|VSP$5 VIN|VOUT$8 VBP|VDD sg13_lv_pmos L=0.13u
+ W=0.3u AS=0.156p AD=0.156p PS=2.08u PD=2.08u
M$1624 VIN|VOUT$8 VOUT|VSN|VSP$3 VIN|VOUT$4 VBP|VDD sg13_lv_pmos L=0.13u W=0.3u
+ AS=0.156p AD=0.156p PS=2.08u PD=2.08u
M$1626 VBP|VDD CLKN|VIN|VOUT|VOUTDP VIN|VOUT$11 VBP|VDD sg13_lv_pmos L=0.13u
+ W=0.15u AS=0.1005p AD=0.1005p PS=1.34u PD=1.34u
M$1627 VBP|VDD VIN|VOUT$11 VIN|VOUT$14 VBP|VDD sg13_lv_pmos L=0.13u W=0.3u
+ AS=0.156p AD=0.156p PS=2.08u PD=2.08u
M$1629 VBP|VDD VIN|VOUT$14 VIN|VOUT$15 VBP|VDD sg13_lv_pmos L=0.13u W=0.6u
+ AS=0.312p AD=0.312p PS=4.16u PD=4.16u
M$1633 VBP|VDD VIN|VOUT$15 PH0|PH3|V3|VIN|VOUT|VOUTDP VBP|VDD sg13_lv_pmos
+ L=0.13u W=1.2u AS=0.624p AD=0.624p PS=8.32u PD=8.32u
M$1641 VBP|VDD CLKN|VIN|VOUT|VOUTDP$2 VIN|VOUT$12 VBP|VDD sg13_lv_pmos L=0.13u
+ W=0.15u AS=0.1005p AD=0.1005p PS=1.34u PD=1.34u
M$1642 VBP|VDD VIN|VOUT$12 VIN|VOUT$16 VBP|VDD sg13_lv_pmos L=0.13u W=0.3u
+ AS=0.156p AD=0.156p PS=2.08u PD=2.08u
M$1644 VBP|VDD VIN|VOUT$16 VIN|VOUT$17 VBP|VDD sg13_lv_pmos L=0.13u W=0.6u
+ AS=0.312p AD=0.312p PS=4.16u PD=4.16u
M$1648 VBP|VDD VIN|VOUT$17 PH0|PH1|V1|VIN|VOUT|VOUTDN VBP|VDD sg13_lv_pmos
+ L=0.13u W=1.2u AS=0.624p AD=0.624p PS=8.32u PD=8.32u
M$1656 VBP|VDD CLKN|VIN|VOUT|VOUTDP$1 VIN|VOUT$13 VBP|VDD sg13_lv_pmos L=0.13u
+ W=0.15u AS=0.1005p AD=0.1005p PS=1.34u PD=1.34u
M$1657 VBP|VDD VIN|VOUT$13 VIN|VOUT$18 VBP|VDD sg13_lv_pmos L=0.13u W=0.3u
+ AS=0.156p AD=0.156p PS=2.08u PD=2.08u
M$1659 VBP|VDD VIN|VOUT$18 VIN|VOUT$19 VBP|VDD sg13_lv_pmos L=0.13u W=0.6u
+ AS=0.312p AD=0.312p PS=4.16u PD=4.16u
M$1663 VBP|VDD VIN|VOUT$19 PH0|PH1|PH5|V5|VIN|VOUT|VOUTDP VBP|VDD sg13_lv_pmos
+ L=0.13u W=1.2u AS=0.624p AD=0.624p PS=8.32u PD=8.32u
M$1671 VBP|VDD SQ[0]|VIN|VOUT|VS|VSN|VSP|VS[0] VOUT|VSN|VSP$7 VBP|VDD
+ sg13_lv_pmos L=0.13u W=0.15u AS=0.1005p AD=0.1005p PS=1.34u PD=1.34u
M$1672 VBP|VDD PH0|VIN|VINA|VINI|VOUT VIN|VOUT$20 VBP|VDD sg13_lv_pmos L=0.13u
+ W=0.45u AS=0.2115p AD=0.2115p PS=2.82u PD=2.82u
M$1675 VIN|VOUT$20 SQ[0]|VIN|VOUT|VS|VSN|VSP|VS[0] VIN|VOUT$21 VBP|VDD
+ sg13_lv_pmos L=0.13u W=0.6u AS=0.312p AD=0.312p PS=4.16u PD=4.16u
M$1679 VBP|VDD \$135 VOUT|VSN|VSP$8 VBP|VDD sg13_lv_pmos L=0.13u W=0.15u
+ AS=0.1005p AD=0.1005p PS=1.34u PD=1.34u
M$1680 VIN|VOUT$20 VOUT|VSN|VSP$8 VIN|VOUT$21 VBP|VDD sg13_lv_pmos L=0.13u
+ W=0.3u AS=0.156p AD=0.156p PS=2.08u PD=2.08u
M$1682 VIN|VOUT$21 VOUT|VSN|VSP$6 VIN|VINA|VOUT VBP|VDD sg13_lv_pmos L=0.13u
+ W=0.3u AS=0.156p AD=0.156p PS=2.08u PD=2.08u
M$1684 VBP|VDD VIN|VOUT$22 CLKN|VIN|VOUT|VOUTDP VBP|VDD sg13_lv_pmos L=0.13u
+ W=1.2u AS=0.624p AD=0.624p PS=8.32u PD=8.32u
M$1692 VBP|VDD VIN|VOUT$23 VIN|VOUT$22 VBP|VDD sg13_lv_pmos L=0.13u W=0.6u
+ AS=0.312p AD=0.312p PS=4.16u PD=4.16u
M$1696 VBP|VDD VIN|VOUT$24 VIN|VOUT$23 VBP|VDD sg13_lv_pmos L=0.13u W=0.3u
+ AS=0.156p AD=0.156p PS=2.08u PD=2.08u
M$1698 VIN|VOUT$24 VIN$1 VBP|VDD VBP|VDD sg13_lv_pmos L=0.13u W=0.15u
+ AS=0.1005p AD=0.1005p PS=1.34u PD=1.34u
M$1699 VBP|VDD VIN|VOUT$25 CLKN|VIN|VOUT|VOUTDP$2 VBP|VDD sg13_lv_pmos L=0.13u
+ W=1.2u AS=0.624p AD=0.624p PS=8.32u PD=8.32u
M$1707 VBP|VDD VIN|VOUT$26 VIN|VOUT$25 VBP|VDD sg13_lv_pmos L=0.13u W=0.6u
+ AS=0.312p AD=0.312p PS=4.16u PD=4.16u
M$1711 VBP|VDD VIN|VOUT$27 VIN|VOUT$26 VBP|VDD sg13_lv_pmos L=0.13u W=0.3u
+ AS=0.156p AD=0.156p PS=2.08u PD=2.08u
M$1713 VIN|VOUT$27 VIN$3 VBP|VDD VBP|VDD sg13_lv_pmos L=0.13u W=0.15u
+ AS=0.1005p AD=0.1005p PS=1.34u PD=1.34u
M$1714 VBP|VDD VIN|VOUT$28 CLKN|VIN|VOUT|VOUTDP$1 VBP|VDD sg13_lv_pmos L=0.13u
+ W=1.2u AS=0.624p AD=0.624p PS=8.32u PD=8.32u
M$1722 VBP|VDD VIN|VOUT$29 VIN|VOUT$28 VBP|VDD sg13_lv_pmos L=0.13u W=0.6u
+ AS=0.312p AD=0.312p PS=4.16u PD=4.16u
M$1726 VBP|VDD VIN|VOUT$30 VIN|VOUT$29 VBP|VDD sg13_lv_pmos L=0.13u W=0.3u
+ AS=0.156p AD=0.156p PS=2.08u PD=2.08u
M$1728 VIN|VOUT$30 VIN$5 VBP|VDD VBP|VDD sg13_lv_pmos L=0.13u W=0.15u
+ AS=0.1005p AD=0.1005p PS=1.34u PD=1.34u
M$1729 VBP|VDD PH270|VIN|VINB|VIND|VINQB|VOUT VIN|VOUT$32 VBP|VDD sg13_lv_pmos
+ L=0.13u W=0.45u AS=0.2115p AD=0.2115p PS=2.82u PD=2.82u
M$1732 VIN|VOUT$32 VOUT|VSN|VSP$9 VIN|VOUT$31 VBP|VDD sg13_lv_pmos L=0.13u
+ W=0.3u AS=0.156p AD=0.156p PS=2.08u PD=2.08u
M$1734 VIN|VOUT$32 VOUT|VSN|VSP$11 VIN|VOUT$31 VBP|VDD sg13_lv_pmos L=0.13u
+ W=0.6u AS=0.312p AD=0.312p PS=4.16u PD=4.16u
M$1736 VBP|VDD \$991 \$991 VBP|VDD sg13_lv_pmos L=0.13u W=0.15u AS=0.1005p
+ AD=0.1005p PS=1.34u PD=1.34u
M$1739 VIN|VOUT$31 VOUT|VSN|VSP$10 VIN|VINB|VOUT$1 VBP|VDD sg13_lv_pmos L=0.13u
+ W=0.3u AS=0.156p AD=0.156p PS=2.08u PD=2.08u
M$1741 VBP|VDD SQ[1]|VIN|VOUT|VS|VSN|VSP|VS[1] VOUT|VSN|VSP$9 VBP|VDD
+ sg13_lv_pmos L=0.13u W=0.15u AS=0.1005p AD=0.1005p PS=1.34u PD=1.34u
M$1742 VBP|VDD PH90|VIN|VINA|VINC|VINQ|VOUT VIN|VOUT$33 VBP|VDD sg13_lv_pmos
+ L=0.13u W=0.45u AS=0.2115p AD=0.2115p PS=2.82u PD=2.82u
M$1745 VIN|VOUT$33 SQ[1]|VIN|VOUT|VS|VSN|VSP|VS[1] VIN|VOUT$34 VBP|VDD
+ sg13_lv_pmos L=0.13u W=0.6u AS=0.312p AD=0.312p PS=4.16u PD=4.16u
M$1749 VBP|VDD \$1284 VOUT|VSN|VSP$11 VBP|VDD sg13_lv_pmos L=0.13u W=0.15u
+ AS=0.1005p AD=0.1005p PS=1.34u PD=1.34u
M$1750 VIN|VOUT$33 VOUT|VSN|VSP$11 VIN|VOUT$34 VBP|VDD sg13_lv_pmos L=0.13u
+ W=0.3u AS=0.156p AD=0.156p PS=2.08u PD=2.08u
M$1752 VIN|VOUT$34 VOUT|VSN|VSP$10 VIN|VINB|VOUT$1 VBP|VDD sg13_lv_pmos L=0.13u
+ W=0.3u AS=0.156p AD=0.156p PS=2.08u PD=2.08u
M$1754 VBP|VDD VIN|VINB|VOUT$1 VIN|VOUT$35 VBP|VDD sg13_lv_pmos L=0.13u W=0.45u
+ AS=0.2115p AD=0.2115p PS=2.82u PD=2.82u
M$1757 VIN|VOUT$35 VOUT|VSN|VSP$13 VIN|VOUT$36 VBP|VDD sg13_lv_pmos L=0.13u
+ W=0.3u AS=0.156p AD=0.156p PS=2.08u PD=2.08u
M$1759 VIN|VOUT$35 VOUT|VSN|VSP$14 VIN|VOUT$36 VBP|VDD sg13_lv_pmos L=0.13u
+ W=0.6u AS=0.312p AD=0.312p PS=4.16u PD=4.16u
M$1761 VBP|VDD \$1321 \$1321 VBP|VDD sg13_lv_pmos L=0.13u W=0.15u AS=0.1005p
+ AD=0.1005p PS=1.34u PD=1.34u
M$1764 VIN|VOUT$36 VOUT|VSN|VSP$12 VIN|VOUT$4 VBP|VDD sg13_lv_pmos L=0.13u
+ W=0.3u AS=0.156p AD=0.156p PS=2.08u PD=2.08u
M$1766 VBP|VDD \$1313 VIN$1 VBP|VDD sg13_lv_pmos L=0.13u W=1.5u AS=0.6p
+ AD=0.555p PS=8u PD=7.4u
M$1776 VBP|VDD \$1314 VIN VBP|VDD sg13_lv_pmos L=0.13u W=1.5u AS=0.555p AD=0.6p
+ PS=7.4u PD=8u
M$1786 VBP|VDD \$1315 VIN$3 VBP|VDD sg13_lv_pmos L=0.13u W=1.5u AS=0.6p
+ AD=0.555p PS=8u PD=7.4u
M$1796 VBP|VDD \$1316 VIN$2 VBP|VDD sg13_lv_pmos L=0.13u W=1.5u AS=0.555p
+ AD=0.6p PS=7.4u PD=8u
M$1806 VBP|VDD \$1317 VIN$5 VBP|VDD sg13_lv_pmos L=0.13u W=1.5u AS=0.6p
+ AD=0.555p PS=8u PD=7.4u
M$1816 VBP|VDD \$1318 VIN$4 VBP|VDD sg13_lv_pmos L=0.13u W=1.5u AS=0.555p
+ AD=0.6p PS=7.4u PD=8u
M$1826 VBP|VDD VBN|VSS VIN$1 VBP|VDD sg13_lv_pmos L=0.13u W=3u AS=1.2p AD=1.11p
+ PS=16u PD=14.8u
M$1836 VBP|VDD VBN|VSS VIN VBP|VDD sg13_lv_pmos L=0.13u W=3u AS=1.11p AD=1.2p
+ PS=14.8u PD=16u
M$1846 VBP|VDD VBN|VSS VIN$3 VBP|VDD sg13_lv_pmos L=0.13u W=3u AS=1.2p AD=1.11p
+ PS=16u PD=14.8u
M$1856 VBP|VDD VBN|VSS VIN$2 VBP|VDD sg13_lv_pmos L=0.13u W=3u AS=1.11p AD=1.2p
+ PS=14.8u PD=16u
M$1866 VBP|VDD VBN|VSS VIN$5 VBP|VDD sg13_lv_pmos L=0.13u W=3u AS=1.2p AD=1.11p
+ PS=16u PD=14.8u
M$1876 VBP|VDD VBN|VSS VIN$4 VBP|VDD sg13_lv_pmos L=0.13u W=3u AS=1.11p AD=1.2p
+ PS=14.8u PD=16u
M$1946 VBP|VDD PH180|VIN|VINB|VINIB|VOUT VIN|VOUT$37 VBP|VDD sg13_lv_pmos
+ L=0.13u W=0.45u AS=0.2115p AD=0.2115p PS=2.82u PD=2.82u
M$1949 VIN|VOUT$37 VOUT|VSN|VSP$16 VIN|VOUT$38 VBP|VDD sg13_lv_pmos L=0.13u
+ W=0.3u AS=0.156p AD=0.156p PS=2.08u PD=2.08u
M$1951 VIN|VOUT$37 VOUT|VSN|VSP$17 VIN|VOUT$38 VBP|VDD sg13_lv_pmos L=0.13u
+ W=0.6u AS=0.312p AD=0.312p PS=4.16u PD=4.16u
M$1953 VBP|VDD \$1397 \$1397 VBP|VDD sg13_lv_pmos L=0.13u W=0.15u AS=0.1005p
+ AD=0.1005p PS=1.34u PD=1.34u
M$1956 VIN|VOUT$38 VOUT|VSN|VSP$15 VIN|VINA|VOUT$1 VBP|VDD sg13_lv_pmos L=0.13u
+ W=0.3u AS=0.156p AD=0.156p PS=2.08u PD=2.08u
M$1958 VBP|VDD STQ[6]|VIN|VOUT|VS|VSN|VSP|VST|VST[6] VOUT|VSN|VSP$13 VBP|VDD
+ sg13_lv_pmos L=0.13u W=0.15u AS=0.1005p AD=0.1005p PS=1.34u PD=1.34u
M$1959 VBP|VDD VIN|VINA|VOUT$1 VIN|VOUT$39 VBP|VDD sg13_lv_pmos L=0.13u W=0.45u
+ AS=0.2115p AD=0.2115p PS=2.82u PD=2.82u
M$1962 VIN|VOUT$39 STQ[6]|VIN|VOUT|VS|VSN|VSP|VST|VST[6] VIN|VOUT$40 VBP|VDD
+ sg13_lv_pmos L=0.13u W=0.6u AS=0.312p AD=0.312p PS=4.16u PD=4.16u
M$1966 VBP|VDD \$1370 VOUT|VSN|VSP$14 VBP|VDD sg13_lv_pmos L=0.13u W=0.15u
+ AS=0.1005p AD=0.1005p PS=1.34u PD=1.34u
M$1967 VIN|VOUT$39 VOUT|VSN|VSP$14 VIN|VOUT$40 VBP|VDD sg13_lv_pmos L=0.13u
+ W=0.3u AS=0.156p AD=0.156p PS=2.08u PD=2.08u
M$1969 VIN|VOUT$40 VOUT|VSN|VSP$12 VIN|VOUT$4 VBP|VDD sg13_lv_pmos L=0.13u
+ W=0.3u AS=0.156p AD=0.156p PS=2.08u PD=2.08u
M$1971 VBP|VDD VIN VIN|VOUT$41 VBP|VDD sg13_lv_pmos L=0.13u W=0.15u AS=0.1005p
+ AD=0.1005p PS=1.34u PD=1.34u
M$1972 VBP|VDD VIN|VOUT$41 VIN|VOUT$44 VBP|VDD sg13_lv_pmos L=0.13u W=0.3u
+ AS=0.156p AD=0.156p PS=2.08u PD=2.08u
M$1974 VBP|VDD VIN|VOUT$44 VIN|VOUT$45 VBP|VDD sg13_lv_pmos L=0.13u W=0.6u
+ AS=0.312p AD=0.312p PS=4.16u PD=4.16u
M$1978 VBP|VDD VIN|VOUT$45 CLKP|VIN|VOUT|VOUTDN VBP|VDD sg13_lv_pmos L=0.13u
+ W=1.2u AS=0.624p AD=0.624p PS=8.32u PD=8.32u
M$1986 VBP|VDD VIN$2 VIN|VOUT$42 VBP|VDD sg13_lv_pmos L=0.13u W=0.15u
+ AS=0.1005p AD=0.1005p PS=1.34u PD=1.34u
M$1987 VBP|VDD VIN|VOUT$42 VIN|VOUT$46 VBP|VDD sg13_lv_pmos L=0.13u W=0.3u
+ AS=0.156p AD=0.156p PS=2.08u PD=2.08u
M$1989 VBP|VDD VIN|VOUT$46 VIN|VOUT$47 VBP|VDD sg13_lv_pmos L=0.13u W=0.6u
+ AS=0.312p AD=0.312p PS=4.16u PD=4.16u
M$1993 VBP|VDD VIN|VOUT$47 CLKP|VIN|VOUT|VOUTDN$1 VBP|VDD sg13_lv_pmos L=0.13u
+ W=1.2u AS=0.624p AD=0.624p PS=8.32u PD=8.32u
M$2001 VBP|VDD VIN$4 VIN|VOUT$43 VBP|VDD sg13_lv_pmos L=0.13u W=0.15u
+ AS=0.1005p AD=0.1005p PS=1.34u PD=1.34u
M$2002 VBP|VDD VIN|VOUT$43 VIN|VOUT$48 VBP|VDD sg13_lv_pmos L=0.13u W=0.3u
+ AS=0.156p AD=0.156p PS=2.08u PD=2.08u
M$2004 VBP|VDD VIN|VOUT$48 VIN|VOUT$49 VBP|VDD sg13_lv_pmos L=0.13u W=0.6u
+ AS=0.312p AD=0.312p PS=4.16u PD=4.16u
M$2008 VBP|VDD VIN|VOUT$49 CLKP|VIN|VOUT|VOUTDN$2 VBP|VDD sg13_lv_pmos L=0.13u
+ W=1.2u AS=0.624p AD=0.624p PS=8.32u PD=8.32u
M$2016 VBP|VDD SQ[0]|VIN|VOUT|VS|VSN|VSP|VS[0] VOUT|VSN|VSP$16 VBP|VDD
+ sg13_lv_pmos L=0.13u W=0.15u AS=0.1005p AD=0.1005p PS=1.34u PD=1.34u
M$2017 VBP|VDD PH0|VIN|VINA|VINI|VOUT VIN|VOUT$51 VBP|VDD sg13_lv_pmos L=0.13u
+ W=0.45u AS=0.2115p AD=0.2115p PS=2.82u PD=2.82u
M$2020 VIN|VOUT$51 SQ[0]|VIN|VOUT|VS|VSN|VSP|VS[0] VIN|VOUT$50 VBP|VDD
+ sg13_lv_pmos L=0.13u W=0.6u AS=0.312p AD=0.312p PS=4.16u PD=4.16u
M$2024 VBP|VDD \$1700 VOUT|VSN|VSP$17 VBP|VDD sg13_lv_pmos L=0.13u W=0.15u
+ AS=0.1005p AD=0.1005p PS=1.34u PD=1.34u
M$2025 VIN|VOUT$51 VOUT|VSN|VSP$17 VIN|VOUT$50 VBP|VDD sg13_lv_pmos L=0.13u
+ W=0.3u AS=0.156p AD=0.156p PS=2.08u PD=2.08u
M$2027 VIN|VOUT$50 VOUT|VSN|VSP$15 VIN|VINA|VOUT$1 VBP|VDD sg13_lv_pmos L=0.13u
+ W=0.3u AS=0.156p AD=0.156p PS=2.08u PD=2.08u
M$2029 VBP|VDD VIN|VOUT$52 PH0|PH1|V0|VIN|VOUT|VOUTDN VBP|VDD sg13_lv_pmos
+ L=0.13u W=1.2u AS=0.624p AD=0.624p PS=8.32u PD=8.32u
M$2033 CTRL|VCONT PH0|PH1|V0|VIN|VOUT|VOUTDN CTRL|VCONT VBP|VDD sg13_lv_pmos
+ L=0.13u W=32u AS=6.68p AD=6.08p PS=49.36u PD=44.16u
M$2041 CTRL|VCONT PH0|PH3|V3|VIN|VOUT|VOUTDP CTRL|VCONT VBP|VDD sg13_lv_pmos
+ L=0.13u W=32u AS=6.08p AD=6.68p PS=44.16u PD=49.36u
M$2053 VBP|VDD VIN|VOUT$53 VIN|VOUT$52 VBP|VDD sg13_lv_pmos L=0.13u W=0.6u
+ AS=0.312p AD=0.312p PS=4.16u PD=4.16u
M$2057 VBP|VDD VIN|VOUT$54 VIN|VOUT$53 VBP|VDD sg13_lv_pmos L=0.13u W=0.3u
+ AS=0.156p AD=0.156p PS=2.08u PD=2.08u
M$2059 VIN|VOUT$54 CLKP|VIN|VOUT|VOUTDN VBP|VDD VBP|VDD sg13_lv_pmos L=0.13u
+ W=0.15u AS=0.1005p AD=0.1005p PS=1.34u PD=1.34u
M$2060 VBP|VDD VIN|VOUT$55 PH0|PH1|PH4|V4|VIN|VOUT|VOUTDP VBP|VDD sg13_lv_pmos
+ L=0.13u W=1.2u AS=0.624p AD=0.624p PS=8.32u PD=8.32u
M$2064 CTRL|VCONT PH0|PH1|PH4|V4|VIN|VOUT|VOUTDP CTRL|VCONT VBP|VDD
+ sg13_lv_pmos L=0.13u W=32u AS=6.68p AD=6.08p PS=49.36u PD=44.16u
M$2072 CTRL|VCONT PH0|PH1|V1|VIN|VOUT|VOUTDN CTRL|VCONT VBP|VDD sg13_lv_pmos
+ L=0.13u W=32u AS=6.08p AD=6.68p PS=44.16u PD=49.36u
M$2084 VBP|VDD VIN|VOUT$56 VIN|VOUT$55 VBP|VDD sg13_lv_pmos L=0.13u W=0.6u
+ AS=0.312p AD=0.312p PS=4.16u PD=4.16u
M$2088 VBP|VDD VIN|VOUT$57 VIN|VOUT$56 VBP|VDD sg13_lv_pmos L=0.13u W=0.3u
+ AS=0.156p AD=0.156p PS=2.08u PD=2.08u
M$2090 VIN|VOUT$57 CLKP|VIN|VOUT|VOUTDN$1 VBP|VDD VBP|VDD sg13_lv_pmos L=0.13u
+ W=0.15u AS=0.1005p AD=0.1005p PS=1.34u PD=1.34u
M$2091 VBP|VDD VIN|VOUT$58 PH1|PH2|V2|VIN|VOUT|VOUTDN VBP|VDD sg13_lv_pmos
+ L=0.13u W=1.2u AS=0.624p AD=0.624p PS=8.32u PD=8.32u
M$2095 CTRL|VCONT PH1|PH2|V2|VIN|VOUT|VOUTDN CTRL|VCONT VBP|VDD sg13_lv_pmos
+ L=0.13u W=32u AS=6.68p AD=6.08p PS=49.36u PD=44.16u
M$2103 CTRL|VCONT PH0|PH1|PH5|V5|VIN|VOUT|VOUTDP CTRL|VCONT VBP|VDD
+ sg13_lv_pmos L=0.13u W=32u AS=6.08p AD=6.68p PS=44.16u PD=49.36u
M$2115 VBP|VDD VIN|VOUT$59 VIN|VOUT$58 VBP|VDD sg13_lv_pmos L=0.13u W=0.6u
+ AS=0.312p AD=0.312p PS=4.16u PD=4.16u
M$2119 VBP|VDD VIN|VOUT$60 VIN|VOUT$59 VBP|VDD sg13_lv_pmos L=0.13u W=0.3u
+ AS=0.156p AD=0.156p PS=2.08u PD=2.08u
M$2121 VIN|VOUT$60 CLKP|VIN|VOUT|VOUTDN$2 VBP|VDD VBP|VDD sg13_lv_pmos L=0.13u
+ W=0.15u AS=0.1005p AD=0.1005p PS=1.34u PD=1.34u
M$2170 VBP|VDD PH270|VIN|VINB|VIND|VINQB|VOUT VIN|VOUT$62 VBP|VDD sg13_lv_pmos
+ L=0.13u W=0.45u AS=0.2115p AD=0.2115p PS=2.82u PD=2.82u
M$2173 VIN|VOUT$62 VOUT|VSN|VSP$19 VIN|VOUT$61 VBP|VDD sg13_lv_pmos L=0.13u
+ W=0.3u AS=0.156p AD=0.156p PS=2.08u PD=2.08u
M$2175 VIN|VOUT$62 VOUT|VSN|VSP$20 VIN|VOUT$61 VBP|VDD sg13_lv_pmos L=0.13u
+ W=0.6u AS=0.312p AD=0.312p PS=4.16u PD=4.16u
M$2177 VBP|VDD \$2560 \$2560 VBP|VDD sg13_lv_pmos L=0.13u W=0.15u AS=0.1005p
+ AD=0.1005p PS=1.34u PD=1.34u
M$2180 VIN|VOUT$61 VOUT|VSN|VSP$18 VIN|VINB|VOUT$2 VBP|VDD sg13_lv_pmos L=0.13u
+ W=0.3u AS=0.156p AD=0.156p PS=2.08u PD=2.08u
M$2278 VBP|VDD SQ[1]|VIN|VOUT|VS|VSN|VSP|VS[1] VOUT|VSN|VSP$19 VBP|VDD
+ sg13_lv_pmos L=0.13u W=0.15u AS=0.1005p AD=0.1005p PS=1.34u PD=1.34u
M$2279 VBP|VDD PH90|VIN|VINA|VINC|VINQ|VOUT VIN|VOUT$63 VBP|VDD sg13_lv_pmos
+ L=0.13u W=0.45u AS=0.2115p AD=0.2115p PS=2.82u PD=2.82u
M$2282 VIN|VOUT$63 SQ[1]|VIN|VOUT|VS|VSN|VSP|VS[1] VIN|VOUT$64 VBP|VDD
+ sg13_lv_pmos L=0.13u W=0.6u AS=0.312p AD=0.312p PS=4.16u PD=4.16u
M$2286 VBP|VDD \$2581 VOUT|VSN|VSP$20 VBP|VDD sg13_lv_pmos L=0.13u W=0.15u
+ AS=0.1005p AD=0.1005p PS=1.34u PD=1.34u
M$2287 VIN|VOUT$63 VOUT|VSN|VSP$20 VIN|VOUT$64 VBP|VDD sg13_lv_pmos L=0.13u
+ W=0.3u AS=0.156p AD=0.156p PS=2.08u PD=2.08u
M$2289 VIN|VOUT$64 VOUT|VSN|VSP$18 VIN|VINB|VOUT$2 VBP|VDD sg13_lv_pmos L=0.13u
+ W=0.3u AS=0.156p AD=0.156p PS=2.08u PD=2.08u
M$2291 VBP|VDD VIN|VINB|VOUT$2 VIN|VOUT$65 VBP|VDD sg13_lv_pmos L=0.13u W=0.45u
+ AS=0.2115p AD=0.2115p PS=2.82u PD=2.82u
M$2294 VIN|VOUT$65 VOUT|VSN|VSP$22 VIN|VOUT$66 VBP|VDD sg13_lv_pmos L=0.13u
+ W=0.3u AS=0.156p AD=0.156p PS=2.08u PD=2.08u
M$2296 VIN|VOUT$65 VOUT|VSN|VSP$23 VIN|VOUT$66 VBP|VDD sg13_lv_pmos L=0.13u
+ W=0.6u AS=0.312p AD=0.312p PS=4.16u PD=4.16u
M$2298 VBP|VDD \$2618 \$2618 VBP|VDD sg13_lv_pmos L=0.13u W=0.15u AS=0.1005p
+ AD=0.1005p PS=1.34u PD=1.34u
M$2301 VIN|VOUT$66 VOUT|VSN|VSP$21 VIN|VOUT$4 VBP|VDD sg13_lv_pmos L=0.13u
+ W=0.3u AS=0.156p AD=0.156p PS=2.08u PD=2.08u
M$2303 VBP|VDD PH0|PH1|V0|VIN|VOUT|VOUTDN PH0|PH3|V3|VIN|VOUT|VOUTDP VBP|VDD
+ sg13_lv_pmos L=0.13u W=0.3u AS=0.156p AD=0.156p PS=2.08u PD=2.08u
M$2305 VBP|VDD PH0|PH3|V3|VIN|VOUT|VOUTDP PH0|PH1|V0|VIN|VOUT|VOUTDN VBP|VDD
+ sg13_lv_pmos L=0.13u W=0.3u AS=0.156p AD=0.156p PS=2.08u PD=2.08u
M$2307 VBP|VDD PH0|PH1|PH4|V4|VIN|VOUT|VOUTDP PH0|PH1|V1|VIN|VOUT|VOUTDN
+ VBP|VDD sg13_lv_pmos L=0.13u W=0.3u AS=0.156p AD=0.156p PS=2.08u PD=2.08u
M$2309 VBP|VDD PH0|PH1|V1|VIN|VOUT|VOUTDN PH0|PH1|PH4|V4|VIN|VOUT|VOUTDP
+ VBP|VDD sg13_lv_pmos L=0.13u W=0.3u AS=0.156p AD=0.156p PS=2.08u PD=2.08u
M$2311 VBP|VDD PH1|PH2|V2|VIN|VOUT|VOUTDN PH0|PH1|PH5|V5|VIN|VOUT|VOUTDP
+ VBP|VDD sg13_lv_pmos L=0.13u W=0.3u AS=0.156p AD=0.156p PS=2.08u PD=2.08u
M$2313 VBP|VDD PH0|PH1|PH5|V5|VIN|VOUT|VOUTDP PH1|PH2|V2|VIN|VOUT|VOUTDN
+ VBP|VDD sg13_lv_pmos L=0.13u W=0.3u AS=0.156p AD=0.156p PS=2.08u PD=2.08u
M$2315 VBP|VDD PH180|VIN|VINB|VINIB|VOUT VIN|VOUT$67 VBP|VDD sg13_lv_pmos
+ L=0.13u W=0.45u AS=0.2115p AD=0.2115p PS=2.82u PD=2.82u
M$2318 VIN|VOUT$67 VOUT|VSN|VSP$25 VIN|VOUT$68 VBP|VDD sg13_lv_pmos L=0.13u
+ W=0.3u AS=0.156p AD=0.156p PS=2.08u PD=2.08u
M$2320 VIN|VOUT$67 VOUT|VSN|VSP$26 VIN|VOUT$68 VBP|VDD sg13_lv_pmos L=0.13u
+ W=0.6u AS=0.312p AD=0.312p PS=4.16u PD=4.16u
M$2322 VBP|VDD \$2688 \$2688 VBP|VDD sg13_lv_pmos L=0.13u W=0.15u AS=0.1005p
+ AD=0.1005p PS=1.34u PD=1.34u
M$2325 VIN|VOUT$68 VOUT|VSN|VSP$24 VIN|VINA|VOUT$2 VBP|VDD sg13_lv_pmos L=0.13u
+ W=0.3u AS=0.156p AD=0.156p PS=2.08u PD=2.08u
M$2327 VBP|VDD STQ[5]|VIN|VOUT|VS|VSN|VSP|VST|VST[5] VOUT|VSN|VSP$22 VBP|VDD
+ sg13_lv_pmos L=0.13u W=0.15u AS=0.1005p AD=0.1005p PS=1.34u PD=1.34u
M$2328 VBP|VDD VIN|VINA|VOUT$2 VIN|VOUT$69 VBP|VDD sg13_lv_pmos L=0.13u W=0.45u
+ AS=0.2115p AD=0.2115p PS=2.82u PD=2.82u
M$2331 VIN|VOUT$69 STQ[5]|VIN|VOUT|VS|VSN|VSP|VST|VST[5] VIN|VOUT$70 VBP|VDD
+ sg13_lv_pmos L=0.13u W=0.6u AS=0.312p AD=0.312p PS=4.16u PD=4.16u
M$2335 VBP|VDD \$2666 VOUT|VSN|VSP$23 VBP|VDD sg13_lv_pmos L=0.13u W=0.15u
+ AS=0.1005p AD=0.1005p PS=1.34u PD=1.34u
M$2336 VIN|VOUT$69 VOUT|VSN|VSP$23 VIN|VOUT$70 VBP|VDD sg13_lv_pmos L=0.13u
+ W=0.3u AS=0.156p AD=0.156p PS=2.08u PD=2.08u
M$2338 VIN|VOUT$70 VOUT|VSN|VSP$21 VIN|VOUT$4 VBP|VDD sg13_lv_pmos L=0.13u
+ W=0.3u AS=0.156p AD=0.156p PS=2.08u PD=2.08u
M$2340 VBP|VDD VIN|VOUT$73 PH180|VIN|VINB|VINIB|VOUT VBP|VDD sg13_lv_pmos
+ L=0.13u W=14.4u AS=6.768p AD=6.768p PS=90.24u PD=90.24u
M$2364 VBP|VDD SQ[0]|VIN|VOUT|VS|VSN|VSP|VS[0] VOUT|VSN|VSP$25 VBP|VDD
+ sg13_lv_pmos L=0.13u W=0.15u AS=0.1005p AD=0.1005p PS=1.34u PD=1.34u
M$2365 VBP|VDD PH0|VIN|VINA|VINI|VOUT VIN|VOUT$71 VBP|VDD sg13_lv_pmos L=0.13u
+ W=0.45u AS=0.2115p AD=0.2115p PS=2.82u PD=2.82u
M$2368 VIN|VOUT$71 SQ[0]|VIN|VOUT|VS|VSN|VSP|VS[0] VIN|VOUT$72 VBP|VDD
+ sg13_lv_pmos L=0.13u W=0.6u AS=0.312p AD=0.312p PS=4.16u PD=4.16u
M$2372 VBP|VDD \$2854 VOUT|VSN|VSP$26 VBP|VDD sg13_lv_pmos L=0.13u W=0.15u
+ AS=0.1005p AD=0.1005p PS=1.34u PD=1.34u
M$2373 VIN|VOUT$71 VOUT|VSN|VSP$26 VIN|VOUT$72 VBP|VDD sg13_lv_pmos L=0.13u
+ W=0.3u AS=0.156p AD=0.156p PS=2.08u PD=2.08u
M$2375 VIN|VOUT$72 VOUT|VSN|VSP$24 VIN|VINA|VOUT$2 VBP|VDD sg13_lv_pmos L=0.13u
+ W=0.3u AS=0.156p AD=0.156p PS=2.08u PD=2.08u
M$2401 VBP|VDD PH270|VIN|VINB|VIND|VINQB|VOUT VIN|VOUT$75 VBP|VDD sg13_lv_pmos
+ L=0.13u W=0.45u AS=0.2115p AD=0.2115p PS=2.82u PD=2.82u
M$2404 VIN|VOUT$75 VOUT|VSN|VSP$29 VIN|VOUT$74 VBP|VDD sg13_lv_pmos L=0.13u
+ W=0.3u AS=0.156p AD=0.156p PS=2.08u PD=2.08u
M$2406 VIN|VOUT$75 VOUT|VSN|VSP$28 VIN|VOUT$74 VBP|VDD sg13_lv_pmos L=0.13u
+ W=0.6u AS=0.312p AD=0.312p PS=4.16u PD=4.16u
M$2408 VBP|VDD \$2914 \$2914 VBP|VDD sg13_lv_pmos L=0.13u W=0.15u AS=0.1005p
+ AD=0.1005p PS=1.34u PD=1.34u
M$2411 VIN|VOUT$74 VOUT|VSN|VSP$27 VIN|VINB|VOUT$3 VBP|VDD sg13_lv_pmos L=0.13u
+ W=0.3u AS=0.156p AD=0.156p PS=2.08u PD=2.08u
M$2413 VBP|VDD PH0|PH3|V3|VIN|VOUT|VOUTDP VIN|VOUT$79 VBP|VDD sg13_lv_pmos
+ L=0.13u W=0.9u AS=0.423p AD=0.423p PS=5.64u PD=5.64u
M$2419 VBP|VDD VIN|VOUT$79 PH1|VIN|VOUT VBP|VDD sg13_lv_pmos L=0.13u W=0.9u
+ AS=0.423p AD=0.423p PS=5.64u PD=5.64u
M$2425 VBP|VDD PH1|VIN|VOUT VIN|VOUT$80 VBP|VDD sg13_lv_pmos L=0.13u W=0.9u
+ AS=0.423p AD=0.423p PS=5.64u PD=5.64u
M$2431 VBP|VDD VIN|VOUT$80 VIN|VOUT$78 VBP|VDD sg13_lv_pmos L=0.13u W=1.8u
+ AS=0.846p AD=0.846p PS=11.28u PD=11.28u
M$2443 VBP|VDD VIN|VOUT$81 VIN|VOUT$82 VBP|VDD sg13_lv_pmos L=0.13u W=7.2u
+ AS=3.384p AD=3.384p PS=45.12u PD=45.12u
M$2467 VBP|VDD VIN|VOUT$82 VIN|VOUT$73 VBP|VDD sg13_lv_pmos L=0.13u W=7.2u
+ AS=3.384p AD=3.384p PS=45.12u PD=45.12u
M$2515 VBP|VDD SQ[1]|VIN|VOUT|VS|VSN|VSP|VS[1] VOUT|VSN|VSP$29 VBP|VDD
+ sg13_lv_pmos L=0.13u W=0.15u AS=0.1005p AD=0.1005p PS=1.34u PD=1.34u
M$2516 VBP|VDD PH90|VIN|VINA|VINC|VINQ|VOUT VIN|VOUT$83 VBP|VDD sg13_lv_pmos
+ L=0.13u W=0.45u AS=0.2115p AD=0.2115p PS=2.82u PD=2.82u
M$2519 VIN|VOUT$83 SQ[1]|VIN|VOUT|VS|VSN|VSP|VS[1] VIN|VOUT$76 VBP|VDD
+ sg13_lv_pmos L=0.13u W=0.6u AS=0.312p AD=0.312p PS=4.16u PD=4.16u
M$2523 VBP|VDD \$2932 VOUT|VSN|VSP$28 VBP|VDD sg13_lv_pmos L=0.13u W=0.15u
+ AS=0.1005p AD=0.1005p PS=1.34u PD=1.34u
M$2524 VIN|VOUT$83 VOUT|VSN|VSP$28 VIN|VOUT$76 VBP|VDD sg13_lv_pmos L=0.13u
+ W=0.3u AS=0.156p AD=0.156p PS=2.08u PD=2.08u
M$2526 VIN|VOUT$76 VOUT|VSN|VSP$27 VIN|VINB|VOUT$3 VBP|VDD sg13_lv_pmos L=0.13u
+ W=0.3u AS=0.156p AD=0.156p PS=2.08u PD=2.08u
M$2528 VBP|VDD VIN|VINB|VOUT$3 VIN|VOUT$84 VBP|VDD sg13_lv_pmos L=0.13u W=0.45u
+ AS=0.2115p AD=0.2115p PS=2.82u PD=2.82u
M$2531 VIN|VOUT$84 VOUT|VSN|VSP$32 VIN|VOUT$77 VBP|VDD sg13_lv_pmos L=0.13u
+ W=0.3u AS=0.156p AD=0.156p PS=2.08u PD=2.08u
M$2533 VIN|VOUT$84 VOUT|VSN|VSP$31 VIN|VOUT$77 VBP|VDD sg13_lv_pmos L=0.13u
+ W=0.6u AS=0.312p AD=0.312p PS=4.16u PD=4.16u
M$2535 VBP|VDD \$2996 \$2996 VBP|VDD sg13_lv_pmos L=0.13u W=0.15u AS=0.1005p
+ AD=0.1005p PS=1.34u PD=1.34u
M$2538 VIN|VOUT$77 VOUT|VSN|VSP$30 VIN|VOUT$4 VBP|VDD sg13_lv_pmos L=0.13u
+ W=0.3u AS=0.156p AD=0.156p PS=2.08u PD=2.08u
M$2540 VBP|VDD VIN|VOUT$78 VIN|VOUT$81 VBP|VDD sg13_lv_pmos L=0.13u W=3.6u
+ AS=1.692p AD=1.692p PS=22.56u PD=22.56u
M$2636 VBP|VDD PH180|VIN|VINB|VINIB|VOUT VIN|VOUT$87 VBP|VDD sg13_lv_pmos
+ L=0.13u W=0.45u AS=0.2115p AD=0.2115p PS=2.82u PD=2.82u
M$2639 VIN|VOUT$87 VOUT|VSN|VSP$34 VIN|VOUT$85 VBP|VDD sg13_lv_pmos L=0.13u
+ W=0.3u AS=0.156p AD=0.156p PS=2.08u PD=2.08u
M$2641 VIN|VOUT$87 VOUT|VSN|VSP$35 VIN|VOUT$85 VBP|VDD sg13_lv_pmos L=0.13u
+ W=0.6u AS=0.312p AD=0.312p PS=4.16u PD=4.16u
M$2643 VBP|VDD \$3074 \$3074 VBP|VDD sg13_lv_pmos L=0.13u W=0.15u AS=0.1005p
+ AD=0.1005p PS=1.34u PD=1.34u
M$2646 VIN|VOUT$85 VOUT|VSN|VSP$33 VIN|VINA|VOUT$3 VBP|VDD sg13_lv_pmos L=0.13u
+ W=0.3u AS=0.156p AD=0.156p PS=2.08u PD=2.08u
M$2648 VBP|VDD STQ[4]|VIN|VOUT|VS|VSN|VSP|VST|VST[4] VOUT|VSN|VSP$32 VBP|VDD
+ sg13_lv_pmos L=0.13u W=0.15u AS=0.1005p AD=0.1005p PS=1.34u PD=1.34u
M$2649 VBP|VDD VIN|VINA|VOUT$3 VIN|VOUT$88 VBP|VDD sg13_lv_pmos L=0.13u W=0.45u
+ AS=0.2115p AD=0.2115p PS=2.82u PD=2.82u
M$2652 VIN|VOUT$88 STQ[4]|VIN|VOUT|VS|VSN|VSP|VST|VST[4] VIN|VOUT$86 VBP|VDD
+ sg13_lv_pmos L=0.13u W=0.6u AS=0.312p AD=0.312p PS=4.16u PD=4.16u
M$2656 VBP|VDD \$3054 VOUT|VSN|VSP$31 VBP|VDD sg13_lv_pmos L=0.13u W=0.15u
+ AS=0.1005p AD=0.1005p PS=1.34u PD=1.34u
M$2657 VIN|VOUT$88 VOUT|VSN|VSP$31 VIN|VOUT$86 VBP|VDD sg13_lv_pmos L=0.13u
+ W=0.3u AS=0.156p AD=0.156p PS=2.08u PD=2.08u
M$2659 VIN|VOUT$86 VOUT|VSN|VSP$30 VIN|VOUT$4 VBP|VDD sg13_lv_pmos L=0.13u
+ W=0.3u AS=0.156p AD=0.156p PS=2.08u PD=2.08u
M$2661 VBP|VDD SQ[0]|VIN|VOUT|VS|VSN|VSP|VS[0] VOUT|VSN|VSP$34 VBP|VDD
+ sg13_lv_pmos L=0.13u W=0.15u AS=0.1005p AD=0.1005p PS=1.34u PD=1.34u
M$2662 VBP|VDD PH0|VIN|VINA|VINI|VOUT VIN|VOUT$90 VBP|VDD sg13_lv_pmos L=0.13u
+ W=0.45u AS=0.2115p AD=0.2115p PS=2.82u PD=2.82u
M$2665 VIN|VOUT$90 SQ[0]|VIN|VOUT|VS|VSN|VSP|VS[0] VIN|VOUT$89 VBP|VDD
+ sg13_lv_pmos L=0.13u W=0.6u AS=0.312p AD=0.312p PS=4.16u PD=4.16u
M$2669 VBP|VDD \$3163 VOUT|VSN|VSP$35 VBP|VDD sg13_lv_pmos L=0.13u W=0.15u
+ AS=0.1005p AD=0.1005p PS=1.34u PD=1.34u
M$2670 VIN|VOUT$90 VOUT|VSN|VSP$35 VIN|VOUT$89 VBP|VDD sg13_lv_pmos L=0.13u
+ W=0.3u AS=0.156p AD=0.156p PS=2.08u PD=2.08u
M$2672 VIN|VOUT$89 VOUT|VSN|VSP$33 VIN|VINA|VOUT$3 VBP|VDD sg13_lv_pmos L=0.13u
+ W=0.3u AS=0.156p AD=0.156p PS=2.08u PD=2.08u
M$2674 VBP|VDD VIN|VOUT$4 VIN|VOUT$91 VBP|VDD sg13_lv_pmos L=0.13u W=0.45u
+ AS=0.2115p AD=0.2115p PS=2.82u PD=2.82u
M$2677 VBP|VDD VIN|VOUT$91 VIN|VOUT$94 VBP|VDD sg13_lv_pmos L=0.13u W=0.9u
+ AS=0.423p AD=0.423p PS=5.64u PD=5.64u
M$2683 VBP|VDD VIN|VOUT$94 VIN|VOUT$92 VBP|VDD sg13_lv_pmos L=0.13u W=1.8u
+ AS=0.846p AD=0.846p PS=11.28u PD=11.28u
M$2695 VBP|VDD VIN|VOUT$95 VOUT VBP|VDD sg13_lv_pmos L=0.13u W=7.2u AS=3.384p
+ AD=3.384p PS=45.12u PD=45.12u
M$2719 VBP|VDD VIN|VOUT$93 PH0|VIN|VINA|VINI|VOUT VBP|VDD sg13_lv_pmos L=0.13u
+ W=14.4u AS=6.768p AD=6.768p PS=90.24u PD=90.24u
M$2743 VBP|VDD PH270|VIN|VINB|VIND|VINQB|VOUT VIN|VOUT$96 VBP|VDD sg13_lv_pmos
+ L=0.13u W=0.45u AS=0.2115p AD=0.2115p PS=2.82u PD=2.82u
M$2746 VIN|VOUT$96 VOUT|VSN|VSP$38 VIN|VOUT$97 VBP|VDD sg13_lv_pmos L=0.13u
+ W=0.3u AS=0.156p AD=0.156p PS=2.08u PD=2.08u
M$2748 VIN|VOUT$96 VOUT|VSN|VSP$37 VIN|VOUT$97 VBP|VDD sg13_lv_pmos L=0.13u
+ W=0.6u AS=0.312p AD=0.312p PS=4.16u PD=4.16u
M$2750 VBP|VDD \$3249 \$3249 VBP|VDD sg13_lv_pmos L=0.13u W=0.15u AS=0.1005p
+ AD=0.1005p PS=1.34u PD=1.34u
M$2753 VIN|VOUT$97 VOUT|VSN|VSP$36 VIN|VINB|VOUT$4 VBP|VDD sg13_lv_pmos L=0.13u
+ W=0.3u AS=0.156p AD=0.156p PS=2.08u PD=2.08u
M$2755 VBP|VDD VIN|VOUT$92 VIN|VOUT$95 VBP|VDD sg13_lv_pmos L=0.13u W=3.6u
+ AS=1.692p AD=1.692p PS=22.56u PD=22.56u
M$2803 VBP|VDD PH0|VIN|VOUT PH1|VIN|VOUT VBP|VDD sg13_lv_pmos L=0.13u W=0.6u
+ AS=0.312p AD=0.312p PS=4.16u PD=4.16u
M$2807 VBP|VDD PH1|VIN|VOUT PH0|VIN|VOUT VBP|VDD sg13_lv_pmos L=0.13u W=0.3u
+ AS=0.156p AD=0.156p PS=2.08u PD=2.08u
M$2833 VBP|VDD PH0|PH1|V0|VIN|VOUT|VOUTDN VIN|VOUT$103 VBP|VDD sg13_lv_pmos
+ L=0.13u W=0.9u AS=0.423p AD=0.423p PS=5.64u PD=5.64u
M$2839 VBP|VDD VIN|VOUT$103 PH0|VIN|VOUT VBP|VDD sg13_lv_pmos L=0.13u W=0.9u
+ AS=0.423p AD=0.423p PS=5.64u PD=5.64u
M$2845 VBP|VDD PH0|VIN|VOUT VIN|VOUT$104 VBP|VDD sg13_lv_pmos L=0.13u W=0.9u
+ AS=0.423p AD=0.423p PS=5.64u PD=5.64u
M$2851 VBP|VDD VIN|VOUT$104 VIN|VOUT$110 VBP|VDD sg13_lv_pmos L=0.13u W=1.8u
+ AS=0.846p AD=0.846p PS=11.28u PD=11.28u
M$2863 VBP|VDD VIN|VOUT$105 VIN|VOUT$100 VBP|VDD sg13_lv_pmos L=0.13u W=7.2u
+ AS=3.384p AD=3.384p PS=45.12u PD=45.12u
M$2887 VBP|VDD VIN|VOUT$100 VIN|VOUT$93 VBP|VDD sg13_lv_pmos L=0.13u W=7.2u
+ AS=3.384p AD=3.384p PS=45.12u PD=45.12u
M$2935 VBP|VDD SQ[1]|VIN|VOUT|VS|VSN|VSP|VS[1] VOUT|VSN|VSP$38 VBP|VDD
+ sg13_lv_pmos L=0.13u W=0.15u AS=0.1005p AD=0.1005p PS=1.34u PD=1.34u
M$2936 VBP|VDD PH90|VIN|VINA|VINC|VINQ|VOUT VIN|VOUT$101 VBP|VDD sg13_lv_pmos
+ L=0.13u W=0.45u AS=0.2115p AD=0.2115p PS=2.82u PD=2.82u
M$2939 VIN|VOUT$101 SQ[1]|VIN|VOUT|VS|VSN|VSP|VS[1] VIN|VOUT$99 VBP|VDD
+ sg13_lv_pmos L=0.13u W=0.6u AS=0.312p AD=0.312p PS=4.16u PD=4.16u
M$2943 VBP|VDD \$3384 VOUT|VSN|VSP$37 VBP|VDD sg13_lv_pmos L=0.13u W=0.15u
+ AS=0.1005p AD=0.1005p PS=1.34u PD=1.34u
M$2944 VIN|VOUT$101 VOUT|VSN|VSP$37 VIN|VOUT$99 VBP|VDD sg13_lv_pmos L=0.13u
+ W=0.3u AS=0.156p AD=0.156p PS=2.08u PD=2.08u
M$2946 VIN|VOUT$99 VOUT|VSN|VSP$36 VIN|VINB|VOUT$4 VBP|VDD sg13_lv_pmos L=0.13u
+ W=0.3u AS=0.156p AD=0.156p PS=2.08u PD=2.08u
M$2948 VBP|VDD VIN|VINB|VOUT$4 VIN|VOUT$102 VBP|VDD sg13_lv_pmos L=0.13u
+ W=0.45u AS=0.2115p AD=0.2115p PS=2.82u PD=2.82u
M$2951 VIN|VOUT$102 VOUT|VSN|VSP$41 VIN|VOUT$98 VBP|VDD sg13_lv_pmos L=0.13u
+ W=0.3u AS=0.156p AD=0.156p PS=2.08u PD=2.08u
M$2953 VIN|VOUT$102 VOUT|VSN|VSP$40 VIN|VOUT$98 VBP|VDD sg13_lv_pmos L=0.13u
+ W=0.6u AS=0.312p AD=0.312p PS=4.16u PD=4.16u
M$2955 VBP|VDD \$3407 \$3407 VBP|VDD sg13_lv_pmos L=0.13u W=0.15u AS=0.1005p
+ AD=0.1005p PS=1.34u PD=1.34u
M$2958 VIN|VOUT$98 VOUT|VSN|VSP$39 VIN|VOUT$4 VBP|VDD sg13_lv_pmos L=0.13u
+ W=0.3u AS=0.156p AD=0.156p PS=2.08u PD=2.08u
M$2960 VBP|VDD VIN|VOUT$110 VIN|VOUT$105 VBP|VDD sg13_lv_pmos L=0.13u W=3.6u
+ AS=1.692p AD=1.692p PS=22.56u PD=22.56u
M$3056 VBP|VDD PH180|VIN|VINB|VINIB|VOUT VIN|VOUT$108 VBP|VDD sg13_lv_pmos
+ L=0.13u W=0.45u AS=0.2115p AD=0.2115p PS=2.82u PD=2.82u
M$3059 VIN|VOUT$108 VOUT|VSN|VSP$43 VIN|VOUT$106 VBP|VDD sg13_lv_pmos L=0.13u
+ W=0.3u AS=0.156p AD=0.156p PS=2.08u PD=2.08u
M$3061 VIN|VOUT$108 VOUT|VSN|VSP$44 VIN|VOUT$106 VBP|VDD sg13_lv_pmos L=0.13u
+ W=0.6u AS=0.312p AD=0.312p PS=4.16u PD=4.16u
M$3063 VBP|VDD \$3558 \$3558 VBP|VDD sg13_lv_pmos L=0.13u W=0.15u AS=0.1005p
+ AD=0.1005p PS=1.34u PD=1.34u
M$3066 VIN|VOUT$106 VOUT|VSN|VSP$42 VIN|VINA|VOUT$4 VBP|VDD sg13_lv_pmos
+ L=0.13u W=0.3u AS=0.156p AD=0.156p PS=2.08u PD=2.08u
M$3068 VBP|VDD STQ[3]|VIN|VOUT|VS|VSN|VSP|VST|VST[3] VOUT|VSN|VSP$41 VBP|VDD
+ sg13_lv_pmos L=0.13u W=0.15u AS=0.1005p AD=0.1005p PS=1.34u PD=1.34u
M$3069 VBP|VDD VIN|VINA|VOUT$4 VIN|VOUT$109 VBP|VDD sg13_lv_pmos L=0.13u
+ W=0.45u AS=0.2115p AD=0.2115p PS=2.82u PD=2.82u
M$3072 VIN|VOUT$109 STQ[3]|VIN|VOUT|VS|VSN|VSP|VST|VST[3] VIN|VOUT$107 VBP|VDD
+ sg13_lv_pmos L=0.13u W=0.6u AS=0.312p AD=0.312p PS=4.16u PD=4.16u
M$3076 VBP|VDD \$3501 VOUT|VSN|VSP$40 VBP|VDD sg13_lv_pmos L=0.13u W=0.15u
+ AS=0.1005p AD=0.1005p PS=1.34u PD=1.34u
M$3077 VIN|VOUT$109 VOUT|VSN|VSP$40 VIN|VOUT$107 VBP|VDD sg13_lv_pmos L=0.13u
+ W=0.3u AS=0.156p AD=0.156p PS=2.08u PD=2.08u
M$3079 VIN|VOUT$107 VOUT|VSN|VSP$39 VIN|VOUT$4 VBP|VDD sg13_lv_pmos L=0.13u
+ W=0.3u AS=0.156p AD=0.156p PS=2.08u PD=2.08u
M$3081 VBP|VDD PH0|PH1|PH5|V5|VIN|VOUT|VOUTDP VIN|VOUT$111 VBP|VDD sg13_lv_pmos
+ L=0.13u W=0.9u AS=0.423p AD=0.423p PS=5.64u PD=5.64u
M$3087 VBP|VDD VIN|VOUT$114 PH270|VIN|VINB|VIND|VINQB|VOUT VBP|VDD sg13_lv_pmos
+ L=0.13u W=14.4u AS=6.768p AD=6.768p PS=90.24u PD=90.24u
M$3111 VBP|VDD SQ[0]|VIN|VOUT|VS|VSN|VSP|VS[0] VOUT|VSN|VSP$43 VBP|VDD
+ sg13_lv_pmos L=0.13u W=0.15u AS=0.1005p AD=0.1005p PS=1.34u PD=1.34u
M$3112 VBP|VDD PH0|VIN|VINA|VINI|VOUT VIN|VOUT$112 VBP|VDD sg13_lv_pmos L=0.13u
+ W=0.45u AS=0.2115p AD=0.2115p PS=2.82u PD=2.82u
M$3115 VIN|VOUT$112 SQ[0]|VIN|VOUT|VS|VSN|VSP|VS[0] VIN|VOUT$113 VBP|VDD
+ sg13_lv_pmos L=0.13u W=0.6u AS=0.312p AD=0.312p PS=4.16u PD=4.16u
M$3119 VBP|VDD \$3612 VOUT|VSN|VSP$44 VBP|VDD sg13_lv_pmos L=0.13u W=0.15u
+ AS=0.1005p AD=0.1005p PS=1.34u PD=1.34u
M$3120 VIN|VOUT$112 VOUT|VSN|VSP$44 VIN|VOUT$113 VBP|VDD sg13_lv_pmos L=0.13u
+ W=0.3u AS=0.156p AD=0.156p PS=2.08u PD=2.08u
M$3122 VIN|VOUT$113 VOUT|VSN|VSP$42 VIN|VINA|VOUT$4 VBP|VDD sg13_lv_pmos
+ L=0.13u W=0.3u AS=0.156p AD=0.156p PS=2.08u PD=2.08u
M$3124 SQ[1]|VIN|VOUT|VS|VSN|VSP|VS[1] VIN|VOUT$116 VBP|VDD VBP|VDD
+ sg13_lv_pmos L=0.13u W=0.15u AS=0.1005p AD=0.1005p PS=1.34u PD=1.34u
M$3125 VIN|VOUT$116 A|S[4]|VIN|VOUT|VS[4] VBP|VDD VBP|VDD sg13_lv_pmos L=0.13u
+ W=0.15u AS=0.1005p AD=0.1005p PS=1.34u PD=1.34u
M$3126 VBP|VDD VIN|VOUT$111 PH1|PHOUT|VIN|VOUT VBP|VDD sg13_lv_pmos L=0.13u
+ W=0.9u AS=0.423p AD=0.423p PS=5.64u PD=5.64u
M$3156 VBP|VDD PH270|VIN|VINB|VIND|VINQB|VOUT VIN|VOUT$117 VBP|VDD sg13_lv_pmos
+ L=0.13u W=0.45u AS=0.2115p AD=0.2115p PS=2.82u PD=2.82u
M$3159 VIN|VOUT$117 VOUT|VSN|VSP$46 VIN|VOUT$115 VBP|VDD sg13_lv_pmos L=0.13u
+ W=0.3u AS=0.156p AD=0.156p PS=2.08u PD=2.08u
M$3161 VIN|VOUT$117 VOUT|VSN|VSP$47 VIN|VOUT$115 VBP|VDD sg13_lv_pmos L=0.13u
+ W=0.6u AS=0.312p AD=0.312p PS=4.16u PD=4.16u
M$3163 VBP|VDD \$3705 \$3705 VBP|VDD sg13_lv_pmos L=0.13u W=0.15u AS=0.1005p
+ AD=0.1005p PS=1.34u PD=1.34u
M$3166 VIN|VOUT$115 VOUT|VSN|VSP$45 VIN|VINB|VOUT$5 VBP|VDD sg13_lv_pmos
+ L=0.13u W=0.3u AS=0.156p AD=0.156p PS=2.08u PD=2.08u
M$3168 VOUT|VSN|VSS B|S[3]|VDD|VIN|VSP|VS[3] VBP|VDD VBP|VDD sg13_lv_pmos
+ L=0.13u W=0.15u AS=0.1005p AD=0.1005p PS=1.34u PD=1.34u
M$3169 SQ[0]|VIN|VOUT|VS|VSN|VSP|VS[0] B|S[3]|VDD|VIN|VSP|VS[3]
+ A|S[4]|VIN|VOUT|VS[4] VBP|VDD sg13_lv_pmos L=0.13u W=0.3u AS=0.156p AD=0.156p
+ PS=2.08u PD=2.08u
M$3171 SQ[0]|VIN|VOUT|VS|VSN|VSP|VS[0] A|S[4]|VIN|VOUT|VS[4]
+ B|S[3]|VDD|VIN|VSP|VS[3] VBP|VDD sg13_lv_pmos L=0.13u W=0.15u AS=0.1005p
+ AD=0.1005p PS=1.34u PD=1.34u
M$3172 VBP|VDD PH0|PH1|PH4|V4|VIN|VOUT|VOUTDP VIN|VOUT$111 VBP|VDD sg13_lv_pmos
+ L=0.13u W=0.9u AS=0.423p AD=0.423p PS=5.64u PD=5.64u
M$3178 VBP|VDD PH1|PHOUT|VIN|VOUT VIN|VOUT$122 VBP|VDD sg13_lv_pmos L=0.13u
+ W=0.9u AS=0.423p AD=0.423p PS=5.64u PD=5.64u
M$3184 VBP|VDD VIN|VOUT$122 VIN|VOUT$129 VBP|VDD sg13_lv_pmos L=0.13u W=1.8u
+ AS=0.846p AD=0.846p PS=11.28u PD=11.28u
M$3196 VBP|VDD VIN|VOUT$123 VIN|VOUT$124 VBP|VDD sg13_lv_pmos L=0.13u W=7.2u
+ AS=3.384p AD=3.384p PS=45.12u PD=45.12u
M$3220 VBP|VDD VIN|VOUT$124 VIN|VOUT$114 VBP|VDD sg13_lv_pmos L=0.13u W=7.2u
+ AS=3.384p AD=3.384p PS=45.12u PD=45.12u
M$3268 VBP|VDD SQ[1]|VIN|VOUT|VS|VSN|VSP|VS[1] VOUT|VSN|VSP$46 VBP|VDD
+ sg13_lv_pmos L=0.13u W=0.15u AS=0.1005p AD=0.1005p PS=1.34u PD=1.34u
M$3269 VBP|VDD PH90|VIN|VINA|VINC|VINQ|VOUT VIN|VOUT$118 VBP|VDD sg13_lv_pmos
+ L=0.13u W=0.45u AS=0.2115p AD=0.2115p PS=2.82u PD=2.82u
M$3272 VIN|VOUT$118 SQ[1]|VIN|VOUT|VS|VSN|VSP|VS[1] VIN|VOUT$119 VBP|VDD
+ sg13_lv_pmos L=0.13u W=0.6u AS=0.312p AD=0.312p PS=4.16u PD=4.16u
M$3276 VBP|VDD \$3735 VOUT|VSN|VSP$47 VBP|VDD sg13_lv_pmos L=0.13u W=0.15u
+ AS=0.1005p AD=0.1005p PS=1.34u PD=1.34u
M$3277 VIN|VOUT$118 VOUT|VSN|VSP$47 VIN|VOUT$119 VBP|VDD sg13_lv_pmos L=0.13u
+ W=0.3u AS=0.156p AD=0.156p PS=2.08u PD=2.08u
M$3279 VIN|VOUT$119 VOUT|VSN|VSP$45 VIN|VINB|VOUT$5 VBP|VDD sg13_lv_pmos
+ L=0.13u W=0.3u AS=0.156p AD=0.156p PS=2.08u PD=2.08u
M$3281 VBP|VDD VIN|VINB|VOUT$5 VIN|VOUT$120 VBP|VDD sg13_lv_pmos L=0.13u
+ W=0.45u AS=0.2115p AD=0.2115p PS=2.82u PD=2.82u
M$3284 VIN|VOUT$120 VOUT|VSN|VSP$49 VIN|VOUT$121 VBP|VDD sg13_lv_pmos L=0.13u
+ W=0.3u AS=0.156p AD=0.156p PS=2.08u PD=2.08u
M$3286 VIN|VOUT$120 VOUT|VSN|VSP$50 VIN|VOUT$121 VBP|VDD sg13_lv_pmos L=0.13u
+ W=0.6u AS=0.312p AD=0.312p PS=4.16u PD=4.16u
M$3288 VBP|VDD \$3759 \$3759 VBP|VDD sg13_lv_pmos L=0.13u W=0.15u AS=0.1005p
+ AD=0.1005p PS=1.34u PD=1.34u
M$3291 VIN|VOUT$121 VOUT|VSN|VSP$48 VIN|VOUT$4 VBP|VDD sg13_lv_pmos L=0.13u
+ W=0.3u AS=0.156p AD=0.156p PS=2.08u PD=2.08u
M$3293 SQ[2]|VIN|VOUT|VS|VSN|VSP|VST|VST[0] VIN|VOUT$127 VBP|VDD VBP|VDD
+ sg13_lv_pmos L=0.13u W=0.15u AS=0.1005p AD=0.1005p PS=1.34u PD=1.34u
M$3294 VIN|VOUT$127 B|S[3]|VDD|VIN|VSP|VS[3] VBP|VDD VBP|VDD sg13_lv_pmos
+ L=0.13u W=0.15u AS=0.1005p AD=0.1005p PS=1.34u PD=1.34u
M$3295 VBP|VDD VIN|VOUT$129 VIN|VOUT$123 VBP|VDD sg13_lv_pmos L=0.13u W=3.6u
+ AS=1.692p AD=1.692p PS=22.56u PD=22.56u
M$3391 VBP|VDD PH180|VIN|VINB|VINIB|VOUT VIN|VOUT$128 VBP|VDD sg13_lv_pmos
+ L=0.13u W=0.45u AS=0.2115p AD=0.2115p PS=2.82u PD=2.82u
M$3394 VIN|VOUT$128 VOUT|VSN|VSP$52 VIN|VOUT$125 VBP|VDD sg13_lv_pmos L=0.13u
+ W=0.3u AS=0.156p AD=0.156p PS=2.08u PD=2.08u
M$3396 VIN|VOUT$128 VOUT|VSN|VSP$53 VIN|VOUT$125 VBP|VDD sg13_lv_pmos L=0.13u
+ W=0.6u AS=0.312p AD=0.312p PS=4.16u PD=4.16u
M$3398 VBP|VDD \$3938 \$3938 VBP|VDD sg13_lv_pmos L=0.13u W=0.15u AS=0.1005p
+ AD=0.1005p PS=1.34u PD=1.34u
M$3401 VIN|VOUT$125 VOUT|VSN|VSP$51 VIN|VINA|VOUT$5 VBP|VDD sg13_lv_pmos
+ L=0.13u W=0.3u AS=0.156p AD=0.156p PS=2.08u PD=2.08u
M$3403 VBP|VDD STQ[2]|VIN|VOUT|VS|VSN|VSP|VST|VST[2] VOUT|VSN|VSP$49 VBP|VDD
+ sg13_lv_pmos L=0.13u W=0.15u AS=0.1005p AD=0.1005p PS=1.34u PD=1.34u
M$3404 VBP|VDD VIN|VINA|VOUT$5 VIN|VOUT$130 VBP|VDD sg13_lv_pmos L=0.13u
+ W=0.45u AS=0.2115p AD=0.2115p PS=2.82u PD=2.82u
M$3407 VIN|VOUT$130 STQ[2]|VIN|VOUT|VS|VSN|VSP|VST|VST[2] VIN|VOUT$126 VBP|VDD
+ sg13_lv_pmos L=0.13u W=0.6u AS=0.312p AD=0.312p PS=4.16u PD=4.16u
M$3411 VBP|VDD \$3869 VOUT|VSN|VSP$50 VBP|VDD sg13_lv_pmos L=0.13u W=0.15u
+ AS=0.1005p AD=0.1005p PS=1.34u PD=1.34u
M$3412 VIN|VOUT$130 VOUT|VSN|VSP$50 VIN|VOUT$126 VBP|VDD sg13_lv_pmos L=0.13u
+ W=0.3u AS=0.156p AD=0.156p PS=2.08u PD=2.08u
M$3414 VIN|VOUT$126 VOUT|VSN|VSP$48 VIN|VOUT$4 VBP|VDD sg13_lv_pmos L=0.13u
+ W=0.3u AS=0.156p AD=0.156p PS=2.08u PD=2.08u
M$3416 VOUT|VSN|VSS$1 B|OUT|ST[7]|VDD|VIN|VSP VBP|VDD VBP|VDD sg13_lv_pmos
+ L=0.13u W=0.15u AS=0.1005p AD=0.1005p PS=1.34u PD=1.34u
M$3417 STQ[7]|VIN|VOUT|VS|VSN|VSP|VST|VST[7] B|OUT|ST[7]|VDD|VIN|VSP A|VIN|VOUT
+ VBP|VDD sg13_lv_pmos L=0.13u W=0.3u AS=0.156p AD=0.156p PS=2.08u PD=2.08u
M$3419 STQ[7]|VIN|VOUT|VS|VSN|VSP|VST|VST[7] A|VIN|VOUT B|OUT|ST[7]|VDD|VIN|VSP
+ VBP|VDD sg13_lv_pmos L=0.13u W=0.15u AS=0.1005p AD=0.1005p PS=1.34u PD=1.34u
M$3420 A|VIN|VOUT VIN|VOUT$132 VBP|VDD VBP|VDD sg13_lv_pmos L=0.13u W=0.15u
+ AS=0.1005p AD=0.1005p PS=1.34u PD=1.34u
M$3421 VIN|VOUT$132 VIN|VOUT$133 VBP|VDD VBP|VDD sg13_lv_pmos L=0.13u W=0.15u
+ AS=0.1005p AD=0.1005p PS=1.34u PD=1.34u
M$3422 VBP|VDD PH1|PH2|V2|VIN|VOUT|VOUTDN VIN|VOUT$134 VBP|VDD sg13_lv_pmos
+ L=0.13u W=0.9u AS=0.423p AD=0.423p PS=5.64u PD=5.64u
M$3428 VBP|VDD VIN|VOUT$135 PH90|VIN|VINA|VINC|VINQ|VOUT VBP|VDD sg13_lv_pmos
+ L=0.13u W=14.4u AS=6.768p AD=6.768p PS=90.24u PD=90.24u
M$3452 VBP|VDD SQ[0]|VIN|VOUT|VS|VSN|VSP|VS[0] VOUT|VSN|VSP$52 VBP|VDD
+ sg13_lv_pmos L=0.13u W=0.15u AS=0.1005p AD=0.1005p PS=1.34u PD=1.34u
M$3453 VBP|VDD PH0|VIN|VINA|VINI|VOUT VIN|VOUT$136 VBP|VDD sg13_lv_pmos L=0.13u
+ W=0.45u AS=0.2115p AD=0.2115p PS=2.82u PD=2.82u
M$3456 VIN|VOUT$136 SQ[0]|VIN|VOUT|VS|VSN|VSP|VS[0] VIN|VOUT$131 VBP|VDD
+ sg13_lv_pmos L=0.13u W=0.6u AS=0.312p AD=0.312p PS=4.16u PD=4.16u
M$3460 VBP|VDD \$3992 VOUT|VSN|VSP$53 VBP|VDD sg13_lv_pmos L=0.13u W=0.15u
+ AS=0.1005p AD=0.1005p PS=1.34u PD=1.34u
M$3461 VIN|VOUT$136 VOUT|VSN|VSP$53 VIN|VOUT$131 VBP|VDD sg13_lv_pmos L=0.13u
+ W=0.3u AS=0.156p AD=0.156p PS=2.08u PD=2.08u
M$3463 VIN|VOUT$131 VOUT|VSN|VSP$51 VIN|VINA|VOUT$5 VBP|VDD sg13_lv_pmos
+ L=0.13u W=0.3u AS=0.156p AD=0.156p PS=2.08u PD=2.08u
M$3465 VOUT|VSN|VSS$2 B|OUT|ST[6]|VDD|VIN|VSP VBP|VDD VBP|VDD sg13_lv_pmos
+ L=0.13u W=0.15u AS=0.1005p AD=0.1005p PS=1.34u PD=1.34u
M$3466 STQ[6]|VIN|VOUT|VS|VSN|VSP|VST|VST[6] B|OUT|ST[6]|VDD|VIN|VSP
+ A|VIN|VOUT$1 VBP|VDD sg13_lv_pmos L=0.13u W=0.3u AS=0.156p AD=0.156p PS=2.08u
+ PD=2.08u
M$3468 STQ[6]|VIN|VOUT|VS|VSN|VSP|VST|VST[6] A|VIN|VOUT$1
+ B|OUT|ST[6]|VDD|VIN|VSP VBP|VDD sg13_lv_pmos L=0.13u W=0.15u AS=0.1005p
+ AD=0.1005p PS=1.34u PD=1.34u
M$3469 A|VIN|VOUT$1 VIN|VOUT$137 VBP|VDD VBP|VDD sg13_lv_pmos L=0.13u W=0.15u
+ AS=0.1005p AD=0.1005p PS=1.34u PD=1.34u
M$3470 VIN|VOUT$137 VIN|VOUT$133 VBP|VDD VBP|VDD sg13_lv_pmos L=0.13u W=0.15u
+ AS=0.1005p AD=0.1005p PS=1.34u PD=1.34u
M$3471 VBP|VDD VIN|VOUT$134 PH0|PHOUT|VIN|VOUT VBP|VDD sg13_lv_pmos L=0.13u
+ W=0.9u AS=0.423p AD=0.423p PS=5.64u PD=5.64u
M$3477 VBP|VDD PH0|PHOUT|VIN|VOUT PH1|PHOUT|VIN|VOUT VBP|VDD sg13_lv_pmos
+ L=0.13u W=0.6u AS=0.312p AD=0.312p PS=4.16u PD=4.16u
M$3481 VBP|VDD PH1|PHOUT|VIN|VOUT PH0|PHOUT|VIN|VOUT VBP|VDD sg13_lv_pmos
+ L=0.13u W=0.3u AS=0.156p AD=0.156p PS=2.08u PD=2.08u
M$3507 VBP|VDD PH270|VIN|VINB|VIND|VINQB|VOUT VIN|VOUT$139 VBP|VDD sg13_lv_pmos
+ L=0.13u W=0.45u AS=0.2115p AD=0.2115p PS=2.82u PD=2.82u
M$3510 VIN|VOUT$139 VOUT|VSN|VSP$56 VIN|VOUT$138 VBP|VDD sg13_lv_pmos L=0.13u
+ W=0.3u AS=0.156p AD=0.156p PS=2.08u PD=2.08u
M$3512 VIN|VOUT$139 VOUT|VSN|VSP$55 VIN|VOUT$138 VBP|VDD sg13_lv_pmos L=0.13u
+ W=0.6u AS=0.312p AD=0.312p PS=4.16u PD=4.16u
M$3514 VBP|VDD \$4278 \$4278 VBP|VDD sg13_lv_pmos L=0.13u W=0.15u AS=0.1005p
+ AD=0.1005p PS=1.34u PD=1.34u
M$3517 VIN|VOUT$138 VOUT|VSN|VSP$54 VIN|VINB|VOUT$6 VBP|VDD sg13_lv_pmos
+ L=0.13u W=0.3u AS=0.156p AD=0.156p PS=2.08u PD=2.08u
M$3519 VBP|VDD VIN|VOUT$140 VIN|VOUT$133 VBP|VDD sg13_lv_pmos L=0.13u W=1.2u
+ AS=0.624p AD=0.624p PS=8.32u PD=8.32u
M$3527 VBP|VDD VIN|VOUT$141 VIN|VOUT$140 VBP|VDD sg13_lv_pmos L=0.13u W=0.6u
+ AS=0.312p AD=0.312p PS=4.16u PD=4.16u
M$3531 VBP|VDD VIN|VOUT$142 VIN|VOUT$141 VBP|VDD sg13_lv_pmos L=0.13u W=0.3u
+ AS=0.156p AD=0.156p PS=2.08u PD=2.08u
M$3533 VIN|VOUT$142 B|S[3]|VDD|VIN|VSP|VS[3] VBP|VDD VBP|VDD sg13_lv_pmos
+ L=0.13u W=0.15u AS=0.1005p AD=0.1005p PS=1.34u PD=1.34u
M$3534 VOUT|VSN|VSS$3 B|OUT|ST[5]|VDD|VIN|VSP VBP|VDD VBP|VDD sg13_lv_pmos
+ L=0.13u W=0.15u AS=0.1005p AD=0.1005p PS=1.34u PD=1.34u
M$3535 STQ[5]|VIN|VOUT|VS|VSN|VSP|VST|VST[5] B|OUT|ST[5]|VDD|VIN|VSP
+ A|VIN|VOUT$2 VBP|VDD sg13_lv_pmos L=0.13u W=0.3u AS=0.156p AD=0.156p PS=2.08u
+ PD=2.08u
M$3537 STQ[5]|VIN|VOUT|VS|VSN|VSP|VST|VST[5] A|VIN|VOUT$2
+ B|OUT|ST[5]|VDD|VIN|VSP VBP|VDD sg13_lv_pmos L=0.13u W=0.15u AS=0.1005p
+ AD=0.1005p PS=1.34u PD=1.34u
M$3538 A|VIN|VOUT$2 VIN|VOUT$143 VBP|VDD VBP|VDD sg13_lv_pmos L=0.13u W=0.15u
+ AS=0.1005p AD=0.1005p PS=1.34u PD=1.34u
M$3539 VIN|VOUT$143 VIN|VOUT$133 VBP|VDD VBP|VDD sg13_lv_pmos L=0.13u W=0.15u
+ AS=0.1005p AD=0.1005p PS=1.34u PD=1.34u
M$3540 VBP|VDD PH0|PH1|V1|VIN|VOUT|VOUTDN VIN|VOUT$134 VBP|VDD sg13_lv_pmos
+ L=0.13u W=0.9u AS=0.423p AD=0.423p PS=5.64u PD=5.64u
M$3546 VBP|VDD PH0|PHOUT|VIN|VOUT VIN|VOUT$148 VBP|VDD sg13_lv_pmos L=0.13u
+ W=0.9u AS=0.423p AD=0.423p PS=5.64u PD=5.64u
M$3552 VBP|VDD VIN|VOUT$148 VIN|VOUT$156 VBP|VDD sg13_lv_pmos L=0.13u W=1.8u
+ AS=0.846p AD=0.846p PS=11.28u PD=11.28u
M$3564 VBP|VDD VIN|VOUT$149 VIN|VOUT$150 VBP|VDD sg13_lv_pmos L=0.13u W=7.2u
+ AS=3.384p AD=3.384p PS=45.12u PD=45.12u
M$3588 VBP|VDD VIN|VOUT$150 VIN|VOUT$135 VBP|VDD sg13_lv_pmos L=0.13u W=7.2u
+ AS=3.384p AD=3.384p PS=45.12u PD=45.12u
M$3636 VBP|VDD SQ[1]|VIN|VOUT|VS|VSN|VSP|VS[1] VOUT|VSN|VSP$56 VBP|VDD
+ sg13_lv_pmos L=0.13u W=0.15u AS=0.1005p AD=0.1005p PS=1.34u PD=1.34u
M$3637 VBP|VDD PH90|VIN|VINA|VINC|VINQ|VOUT VIN|VOUT$144 VBP|VDD sg13_lv_pmos
+ L=0.13u W=0.45u AS=0.2115p AD=0.2115p PS=2.82u PD=2.82u
M$3640 VIN|VOUT$144 SQ[1]|VIN|VOUT|VS|VSN|VSP|VS[1] VIN|VOUT$145 VBP|VDD
+ sg13_lv_pmos L=0.13u W=0.6u AS=0.312p AD=0.312p PS=4.16u PD=4.16u
M$3644 VBP|VDD \$4450 VOUT|VSN|VSP$55 VBP|VDD sg13_lv_pmos L=0.13u W=0.15u
+ AS=0.1005p AD=0.1005p PS=1.34u PD=1.34u
M$3645 VIN|VOUT$144 VOUT|VSN|VSP$55 VIN|VOUT$145 VBP|VDD sg13_lv_pmos L=0.13u
+ W=0.3u AS=0.156p AD=0.156p PS=2.08u PD=2.08u
M$3647 VIN|VOUT$145 VOUT|VSN|VSP$54 VIN|VINB|VOUT$6 VBP|VDD sg13_lv_pmos
+ L=0.13u W=0.3u AS=0.156p AD=0.156p PS=2.08u PD=2.08u
M$3649 VBP|VDD VIN|VINB|VOUT$6 VIN|VOUT$146 VBP|VDD sg13_lv_pmos L=0.13u
+ W=0.45u AS=0.2115p AD=0.2115p PS=2.82u PD=2.82u
M$3652 VIN|VOUT$146 VOUT|VSN|VSP$58 VIN|VOUT$147 VBP|VDD sg13_lv_pmos L=0.13u
+ W=0.3u AS=0.156p AD=0.156p PS=2.08u PD=2.08u
M$3654 VIN|VOUT$146 VOUT|VSN|VSP$59 VIN|VOUT$147 VBP|VDD sg13_lv_pmos L=0.13u
+ W=0.6u AS=0.312p AD=0.312p PS=4.16u PD=4.16u
M$3656 VBP|VDD \$4474 \$4474 VBP|VDD sg13_lv_pmos L=0.13u W=0.15u AS=0.1005p
+ AD=0.1005p PS=1.34u PD=1.34u
M$3659 VIN|VOUT$147 VOUT|VSN|VSP$57 VIN|VOUT$4 VBP|VDD sg13_lv_pmos L=0.13u
+ W=0.3u AS=0.156p AD=0.156p PS=2.08u PD=2.08u
M$3661 VOUT|VSN|VSS$4 B|ST[4]|VDD|VIN|VOUT|VSP VBP|VDD VBP|VDD sg13_lv_pmos
+ L=0.13u W=0.15u AS=0.1005p AD=0.1005p PS=1.34u PD=1.34u
M$3662 STQ[4]|VIN|VOUT|VS|VSN|VSP|VST|VST[4] B|ST[4]|VDD|VIN|VOUT|VSP
+ A|VIN|VOUT$3 VBP|VDD sg13_lv_pmos L=0.13u W=0.3u AS=0.156p AD=0.156p PS=2.08u
+ PD=2.08u
M$3664 STQ[4]|VIN|VOUT|VS|VSN|VSP|VST|VST[4] A|VIN|VOUT$3
+ B|ST[4]|VDD|VIN|VOUT|VSP VBP|VDD sg13_lv_pmos L=0.13u W=0.15u AS=0.1005p
+ AD=0.1005p PS=1.34u PD=1.34u
M$3665 A|VIN|VOUT$3 VIN|VOUT$151 VBP|VDD VBP|VDD sg13_lv_pmos L=0.13u W=0.15u
+ AS=0.1005p AD=0.1005p PS=1.34u PD=1.34u
M$3666 VIN|VOUT$151 VIN|VOUT$133 VBP|VDD VBP|VDD sg13_lv_pmos L=0.13u W=0.15u
+ AS=0.1005p AD=0.1005p PS=1.34u PD=1.34u
M$3667 VBP|VDD VIN|VOUT$156 VIN|VOUT$149 VBP|VDD sg13_lv_pmos L=0.13u W=3.6u
+ AS=1.692p AD=1.692p PS=22.56u PD=22.56u
M$3763 VBP|VDD SQ[0]|VIN|VOUT|VS|VSN|VSP|VS[0] VOUT|VSN|VSP$62 VBP|VDD
+ sg13_lv_pmos L=0.13u W=0.15u AS=0.1005p AD=0.1005p PS=1.34u PD=1.34u
M$3764 VBP|VDD PH180|VIN|VINB|VINIB|VOUT VIN|VOUT$154 VBP|VDD sg13_lv_pmos
+ L=0.13u W=0.45u AS=0.2115p AD=0.2115p PS=2.82u PD=2.82u
M$3767 VBP|VDD PH0|VIN|VINA|VINI|VOUT VIN|VOUT$159 VBP|VDD sg13_lv_pmos L=0.13u
+ W=0.45u AS=0.2115p AD=0.2115p PS=2.82u PD=2.82u
M$3770 VIN|VOUT$154 VOUT|VSN|VSP$62 VIN|VOUT$152 VBP|VDD sg13_lv_pmos L=0.13u
+ W=0.3u AS=0.156p AD=0.156p PS=2.08u PD=2.08u
M$3772 VIN|VOUT$159 SQ[0]|VIN|VOUT|VS|VSN|VSP|VS[0] VIN|VOUT$158 VBP|VDD
+ sg13_lv_pmos L=0.13u W=0.6u AS=0.312p AD=0.312p PS=4.16u PD=4.16u
M$3776 VIN|VOUT$154 VOUT|VSN|VSP$61 VIN|VOUT$152 VBP|VDD sg13_lv_pmos L=0.13u
+ W=0.6u AS=0.312p AD=0.312p PS=4.16u PD=4.16u
M$3778 VBP|VDD \$4761 VOUT|VSN|VSP$61 VBP|VDD sg13_lv_pmos L=0.13u W=0.15u
+ AS=0.1005p AD=0.1005p PS=1.34u PD=1.34u
M$3779 VBP|VDD \$4685 \$4685 VBP|VDD sg13_lv_pmos L=0.13u W=0.15u AS=0.1005p
+ AD=0.1005p PS=1.34u PD=1.34u
M$3780 VIN|VOUT$159 VOUT|VSN|VSP$61 VIN|VOUT$158 VBP|VDD sg13_lv_pmos L=0.13u
+ W=0.3u AS=0.156p AD=0.156p PS=2.08u PD=2.08u
M$3784 VIN|VOUT$152 VOUT|VSN|VSP$60 VIN|VINA|VOUT$6 VBP|VDD sg13_lv_pmos
+ L=0.13u W=0.3u AS=0.156p AD=0.156p PS=2.08u PD=2.08u
M$3786 VIN|VOUT$158 VOUT|VSN|VSP$60 VIN|VINA|VOUT$6 VBP|VDD sg13_lv_pmos
+ L=0.13u W=0.3u AS=0.156p AD=0.156p PS=2.08u PD=2.08u
M$3788 VBP|VDD STQ[1]|VIN|VOUT|VS|VSN|VSP|VST|VST[1] VOUT|VSN|VSP$58 VBP|VDD
+ sg13_lv_pmos L=0.13u W=0.15u AS=0.1005p AD=0.1005p PS=1.34u PD=1.34u
M$3789 VBP|VDD VIN|VINA|VOUT$6 VIN|VOUT$155 VBP|VDD sg13_lv_pmos L=0.13u
+ W=0.45u AS=0.2115p AD=0.2115p PS=2.82u PD=2.82u
M$3792 VIN|VOUT$155 STQ[1]|VIN|VOUT|VS|VSN|VSP|VST|VST[1] VIN|VOUT$153 VBP|VDD
+ sg13_lv_pmos L=0.13u W=0.6u AS=0.312p AD=0.312p PS=4.16u PD=4.16u
M$3796 VBP|VDD \$4608 VOUT|VSN|VSP$59 VBP|VDD sg13_lv_pmos L=0.13u W=0.15u
+ AS=0.1005p AD=0.1005p PS=1.34u PD=1.34u
M$3797 VIN|VOUT$155 VOUT|VSN|VSP$59 VIN|VOUT$153 VBP|VDD sg13_lv_pmos L=0.13u
+ W=0.3u AS=0.156p AD=0.156p PS=2.08u PD=2.08u
M$3799 VIN|VOUT$153 VOUT|VSN|VSP$57 VIN|VOUT$4 VBP|VDD sg13_lv_pmos L=0.13u
+ W=0.3u AS=0.156p AD=0.156p PS=2.08u PD=2.08u
M$3801 VOUT|VSN|VSS$5 B|OUT|ST[3]|VDD|VIN|VSP VBP|VDD VBP|VDD sg13_lv_pmos
+ L=0.13u W=0.15u AS=0.1005p AD=0.1005p PS=1.34u PD=1.34u
M$3802 STQ[3]|VIN|VOUT|VS|VSN|VSP|VST|VST[3] B|OUT|ST[3]|VDD|VIN|VSP
+ A|VIN|VOUT$4 VBP|VDD sg13_lv_pmos L=0.13u W=0.3u AS=0.156p AD=0.156p PS=2.08u
+ PD=2.08u
M$3804 STQ[3]|VIN|VOUT|VS|VSN|VSP|VST|VST[3] A|VIN|VOUT$4
+ B|OUT|ST[3]|VDD|VIN|VSP VBP|VDD sg13_lv_pmos L=0.13u W=0.15u AS=0.1005p
+ AD=0.1005p PS=1.34u PD=1.34u
M$3805 A|VIN|VOUT$4 VIN|VOUT$157 VBP|VDD VBP|VDD sg13_lv_pmos L=0.13u W=0.15u
+ AS=0.1005p AD=0.1005p PS=1.34u PD=1.34u
M$3806 VIN|VOUT$157 VIN|VOUT$133 VBP|VDD VBP|VDD sg13_lv_pmos L=0.13u W=0.15u
+ AS=0.1005p AD=0.1005p PS=1.34u PD=1.34u
M$3807 VOUT|VSN|VSS$6 B|OUT|ST[2]|VDD|VIN|VSP VBP|VDD VBP|VDD sg13_lv_pmos
+ L=0.13u W=0.15u AS=0.1005p AD=0.1005p PS=1.34u PD=1.34u
M$3808 STQ[2]|VIN|VOUT|VS|VSN|VSP|VST|VST[2] B|OUT|ST[2]|VDD|VIN|VSP
+ A|VIN|VOUT$5 VBP|VDD sg13_lv_pmos L=0.13u W=0.3u AS=0.156p AD=0.156p PS=2.08u
+ PD=2.08u
M$3810 STQ[2]|VIN|VOUT|VS|VSN|VSP|VST|VST[2] A|VIN|VOUT$5
+ B|OUT|ST[2]|VDD|VIN|VSP VBP|VDD sg13_lv_pmos L=0.13u W=0.15u AS=0.1005p
+ AD=0.1005p PS=1.34u PD=1.34u
M$3811 A|VIN|VOUT$5 VIN|VOUT$160 VBP|VDD VBP|VDD sg13_lv_pmos L=0.13u W=0.15u
+ AS=0.1005p AD=0.1005p PS=1.34u PD=1.34u
M$3812 VIN|VOUT$160 VIN|VOUT$133 VBP|VDD VBP|VDD sg13_lv_pmos L=0.13u W=0.15u
+ AS=0.1005p AD=0.1005p PS=1.34u PD=1.34u
M$3813 VBP|VDD A|B|VOUT \$4931 VBP|VDD sg13_lv_pmos L=0.13u W=0.15u AS=0.1005p
+ AD=0.0555p PS=1.34u PD=0.74u
M$3814 \$4931 A|B|VOUT$1 \$4932 VBP|VDD sg13_lv_pmos L=0.13u W=0.15u AS=0.0555p
+ AD=0.0555p PS=0.74u PD=0.74u
M$3815 \$4932 B|C|VIN|VOUT B|OUT|ST[1]|VDD|VIN|VSP VBP|VDD sg13_lv_pmos L=0.13u
+ W=0.15u AS=0.0555p AD=0.1005p PS=0.74u PD=1.34u
M$3816 B|OUT|ST[2]|VDD|VIN|VSP B|C|VIN|VOUT \$4933 VBP|VDD sg13_lv_pmos L=0.13u
+ W=0.15u AS=0.1005p AD=0.0555p PS=1.34u PD=0.74u
M$3817 \$4933 A|B|VOUT$1 VBP|VDD VBP|VDD sg13_lv_pmos L=0.13u W=0.15u
+ AS=0.0555p AD=0.1005p PS=0.74u PD=1.34u
M$3818 B|OUT|ST[3]|VDD|VIN|VSP B|C|VIN|VOUT \$4934 VBP|VDD sg13_lv_pmos L=0.13u
+ W=0.15u AS=0.1005p AD=0.0555p PS=1.34u PD=0.74u
M$3819 \$4934 A|OUT|VOUT VBP|VDD VBP|VDD sg13_lv_pmos L=0.13u W=0.15u
+ AS=0.0555p AD=0.1005p PS=0.74u PD=1.34u
M$3820 B|ST[4]|VDD|VIN|VOUT|VSP B|C|VIN|VOUT VBP|VDD VBP|VDD sg13_lv_pmos
+ L=0.13u W=0.15u AS=0.1005p AD=0.1005p PS=1.34u PD=1.34u
M$3821 VBP|VDD B|C|VIN|VOUT B|OUT|ST[5]|VDD|VIN|VSP VBP|VDD sg13_lv_pmos
+ L=0.13u W=0.15u AS=0.1005p AD=0.0555p PS=1.34u PD=0.74u
M$3822 B|OUT|ST[5]|VDD|VIN|VSP A|OUT|VOUT$1 VBP|VDD VBP|VDD sg13_lv_pmos
+ L=0.13u W=0.15u AS=0.0555p AD=0.1005p PS=0.74u PD=1.34u
M$3823 VBP|VDD A|B|VOUT$1 B|OUT|ST[6]|VDD|VIN|VSP VBP|VDD sg13_lv_pmos L=0.13u
+ W=0.15u AS=0.1005p AD=0.0555p PS=1.34u PD=0.74u
M$3824 B|OUT|ST[6]|VDD|VIN|VSP B|C|VIN|VOUT VBP|VDD VBP|VDD sg13_lv_pmos
+ L=0.13u W=0.15u AS=0.0555p AD=0.1005p PS=0.74u PD=1.34u
M$3825 B|OUT|ST[7]|VDD|VIN|VSP B|C|VIN|VOUT VBP|VDD VBP|VDD sg13_lv_pmos
+ L=0.13u W=0.15u AS=0.1005p AD=0.0555p PS=1.34u PD=0.74u
M$3826 VBP|VDD A|B|VOUT$1 B|OUT|ST[7]|VDD|VIN|VSP VBP|VDD sg13_lv_pmos L=0.13u
+ W=0.15u AS=0.0555p AD=0.0555p PS=0.74u PD=0.74u
M$3827 B|OUT|ST[7]|VDD|VIN|VSP A|B|VOUT VBP|VDD VBP|VDD sg13_lv_pmos L=0.13u
+ W=0.15u AS=0.0555p AD=0.1005p PS=0.74u PD=1.34u
M$3828 VBP|VDD PH270|VIN|VINB|VIND|VINQB|VOUT VIN|VOUT$162 VBP|VDD sg13_lv_pmos
+ L=0.13u W=0.45u AS=0.2115p AD=0.2115p PS=2.82u PD=2.82u
M$3831 VIN|VOUT$162 VOUT|VSN|VSP$64 VIN|VOUT$161 VBP|VDD sg13_lv_pmos L=0.13u
+ W=0.3u AS=0.156p AD=0.156p PS=2.08u PD=2.08u
M$3833 VIN|VOUT$162 VOUT|VSN|VSP$65 VIN|VOUT$161 VBP|VDD sg13_lv_pmos L=0.13u
+ W=0.6u AS=0.312p AD=0.312p PS=4.16u PD=4.16u
M$3835 VBP|VDD \$4938 \$4938 VBP|VDD sg13_lv_pmos L=0.13u W=0.15u AS=0.1005p
+ AD=0.1005p PS=1.34u PD=1.34u
M$3838 VIN|VOUT$161 VOUT|VSN|VSP$63 VIN|VINB|VOUT$7 VBP|VDD sg13_lv_pmos
+ L=0.13u W=0.3u AS=0.156p AD=0.156p PS=2.08u PD=2.08u
M$3840 VOUT|VSN|VSS$7 B|OUT|ST[1]|VDD|VIN|VSP VBP|VDD VBP|VDD sg13_lv_pmos
+ L=0.13u W=0.15u AS=0.1005p AD=0.1005p PS=1.34u PD=1.34u
M$3841 STQ[1]|VIN|VOUT|VS|VSN|VSP|VST|VST[1] B|OUT|ST[1]|VDD|VIN|VSP
+ A|VIN|VOUT$6 VBP|VDD sg13_lv_pmos L=0.13u W=0.3u AS=0.156p AD=0.156p PS=2.08u
+ PD=2.08u
M$3843 STQ[1]|VIN|VOUT|VS|VSN|VSP|VST|VST[1] A|VIN|VOUT$6
+ B|OUT|ST[1]|VDD|VIN|VSP VBP|VDD sg13_lv_pmos L=0.13u W=0.15u AS=0.1005p
+ AD=0.1005p PS=1.34u PD=1.34u
M$3844 A|VIN|VOUT$6 VIN|VOUT$163 VBP|VDD VBP|VDD sg13_lv_pmos L=0.13u W=0.15u
+ AS=0.1005p AD=0.1005p PS=1.34u PD=1.34u
M$3845 VIN|VOUT$163 VIN|VOUT$133 VBP|VDD VBP|VDD sg13_lv_pmos L=0.13u W=0.15u
+ AS=0.1005p AD=0.1005p PS=1.34u PD=1.34u
M$3846 A|OUT|VOUT OUT|VIN VBP|VDD VBP|VDD sg13_lv_pmos L=0.13u W=0.15u
+ AS=0.1005p AD=0.1005p PS=1.34u PD=1.34u
M$3847 VBP|VDD A|B|VOUT OUT|VIN VBP|VDD sg13_lv_pmos L=0.13u W=0.15u AS=0.1005p
+ AD=0.0555p PS=1.34u PD=0.74u
M$3848 OUT|VIN A|B|VOUT$1 VBP|VDD VBP|VDD sg13_lv_pmos L=0.13u W=0.15u
+ AS=0.0555p AD=0.1005p PS=0.74u PD=1.34u
M$3849 A|OUT|VOUT$1 OUT|VIN$1 VBP|VDD VBP|VDD sg13_lv_pmos L=0.13u W=0.15u
+ AS=0.1005p AD=0.1005p PS=1.34u PD=1.34u
M$3850 OUT|VIN$1 A|B|VOUT$1 \$5130 VBP|VDD sg13_lv_pmos L=0.13u W=0.15u
+ AS=0.1005p AD=0.0555p PS=1.34u PD=0.74u
M$3851 \$5130 A|B|VOUT VBP|VDD VBP|VDD sg13_lv_pmos L=0.13u W=0.15u AS=0.0555p
+ AD=0.1005p PS=0.74u PD=1.34u
M$3852 VBP|VDD SQ[1]|VIN|VOUT|VS|VSN|VSP|VS[1] VOUT|VSN|VSP$64 VBP|VDD
+ sg13_lv_pmos L=0.13u W=0.15u AS=0.1005p AD=0.1005p PS=1.34u PD=1.34u
M$3853 VBP|VDD PH90|VIN|VINA|VINC|VINQ|VOUT VIN|VOUT$167 VBP|VDD sg13_lv_pmos
+ L=0.13u W=0.45u AS=0.2115p AD=0.2115p PS=2.82u PD=2.82u
M$3856 VIN|VOUT$167 SQ[1]|VIN|VOUT|VS|VSN|VSP|VS[1] VIN|VOUT$165 VBP|VDD
+ sg13_lv_pmos L=0.13u W=0.6u AS=0.312p AD=0.312p PS=4.16u PD=4.16u
M$3860 VBP|VDD \$5128 VOUT|VSN|VSP$65 VBP|VDD sg13_lv_pmos L=0.13u W=0.15u
+ AS=0.1005p AD=0.1005p PS=1.34u PD=1.34u
M$3861 VIN|VOUT$167 VOUT|VSN|VSP$65 VIN|VOUT$165 VBP|VDD sg13_lv_pmos L=0.13u
+ W=0.3u AS=0.156p AD=0.156p PS=2.08u PD=2.08u
M$3863 VIN|VOUT$165 VOUT|VSN|VSP$63 VIN|VINB|VOUT$7 VBP|VDD sg13_lv_pmos
+ L=0.13u W=0.3u AS=0.156p AD=0.156p PS=2.08u PD=2.08u
M$3865 VBP|VDD VIN|VINB|VOUT$7 VIN|VOUT$166 VBP|VDD sg13_lv_pmos L=0.13u
+ W=0.45u AS=0.2115p AD=0.2115p PS=2.82u PD=2.82u
M$3868 VIN|VOUT$166 VOUT|VSN|VSP$67 VIN|VOUT$164 VBP|VDD sg13_lv_pmos L=0.13u
+ W=0.3u AS=0.156p AD=0.156p PS=2.08u PD=2.08u
M$3870 VIN|VOUT$166 VOUT|VSN|VSP$68 VIN|VOUT$164 VBP|VDD sg13_lv_pmos L=0.13u
+ W=0.6u AS=0.312p AD=0.312p PS=4.16u PD=4.16u
M$3872 VBP|VDD \$5209 \$5209 VBP|VDD sg13_lv_pmos L=0.13u W=0.15u AS=0.1005p
+ AD=0.1005p PS=1.34u PD=1.34u
M$3875 VIN|VOUT$164 VOUT|VSN|VSP$66 VIN|VOUT$4 VBP|VDD sg13_lv_pmos L=0.13u
+ W=0.3u AS=0.156p AD=0.156p PS=2.08u PD=2.08u
M$3877 VBP|VDD S[2]|VIN|VS[2] B|C|VIN|VOUT VBP|VDD sg13_lv_pmos L=0.13u W=0.15u
+ AS=0.1005p AD=0.1005p PS=1.34u PD=1.34u
M$3878 VBP|VDD S[1]|VIN|VS[1] A|B|VOUT$1 VBP|VDD sg13_lv_pmos L=0.13u W=0.15u
+ AS=0.1005p AD=0.1005p PS=1.34u PD=1.34u
M$3879 VBP|VDD S[0]|VIN|VS[0] A|B|VOUT VBP|VDD sg13_lv_pmos L=0.13u W=0.15u
+ AS=0.1005p AD=0.1005p PS=1.34u PD=1.34u
M$3880 VBP|VDD SQ[0]|VIN|VOUT|VS|VSN|VSP|VS[0] VOUT|VSN|VSP$70 VBP|VDD
+ sg13_lv_pmos L=0.13u W=0.15u AS=0.1005p AD=0.1005p PS=1.34u PD=1.34u
M$3881 VBP|VDD PH180|VIN|VINB|VINIB|VOUT VIN|VOUT$171 VBP|VDD sg13_lv_pmos
+ L=0.13u W=0.45u AS=0.2115p AD=0.2115p PS=2.82u PD=2.82u
M$3884 VBP|VDD PH0|VIN|VINA|VINI|VOUT VIN|VOUT$172 VBP|VDD sg13_lv_pmos L=0.13u
+ W=0.45u AS=0.2115p AD=0.2115p PS=2.82u PD=2.82u
M$3887 VIN|VOUT$172 SQ[0]|VIN|VOUT|VS|VSN|VSP|VS[0] VIN|VOUT$173 VBP|VDD
+ sg13_lv_pmos L=0.13u W=0.6u AS=0.312p AD=0.312p PS=4.16u PD=4.16u
M$3889 VIN|VOUT$171 VOUT|VSN|VSP$70 VIN|VOUT$168 VBP|VDD sg13_lv_pmos L=0.13u
+ W=0.3u AS=0.156p AD=0.156p PS=2.08u PD=2.08u
M$3893 VIN|VOUT$171 VOUT|VSN|VSP$71 VIN|VOUT$168 VBP|VDD sg13_lv_pmos L=0.13u
+ W=0.6u AS=0.312p AD=0.312p PS=4.16u PD=4.16u
M$3895 VBP|VDD \$5316 VOUT|VSN|VSP$71 VBP|VDD sg13_lv_pmos L=0.13u W=0.15u
+ AS=0.1005p AD=0.1005p PS=1.34u PD=1.34u
M$3896 VBP|VDD \$5273 \$5273 VBP|VDD sg13_lv_pmos L=0.13u W=0.15u AS=0.1005p
+ AD=0.1005p PS=1.34u PD=1.34u
M$3899 VIN|VOUT$172 VOUT|VSN|VSP$71 VIN|VOUT$173 VBP|VDD sg13_lv_pmos L=0.13u
+ W=0.3u AS=0.156p AD=0.156p PS=2.08u PD=2.08u
M$3901 VIN|VOUT$173 VOUT|VSN|VSP$69 VIN|VINA|VOUT$7 VBP|VDD sg13_lv_pmos
+ L=0.13u W=0.3u AS=0.156p AD=0.156p PS=2.08u PD=2.08u
M$3903 VIN|VOUT$168 VOUT|VSN|VSP$69 VIN|VINA|VOUT$7 VBP|VDD sg13_lv_pmos
+ L=0.13u W=0.3u AS=0.156p AD=0.156p PS=2.08u PD=2.08u
M$3905 VBP|VDD SQ[2]|VIN|VOUT|VS|VSN|VSP|VST|VST[0] VOUT|VSN|VSP$67 VBP|VDD
+ sg13_lv_pmos L=0.13u W=0.15u AS=0.1005p AD=0.1005p PS=1.34u PD=1.34u
M$3906 VBP|VDD VIN|VINA|VOUT$7 VIN|VOUT$169 VBP|VDD sg13_lv_pmos L=0.13u
+ W=0.45u AS=0.2115p AD=0.2115p PS=2.82u PD=2.82u
M$3909 VIN|VOUT$169 SQ[2]|VIN|VOUT|VS|VSN|VSP|VST|VST[0] VIN|VOUT$170 VBP|VDD
+ sg13_lv_pmos L=0.13u W=0.6u AS=0.312p AD=0.312p PS=4.16u PD=4.16u
M$3913 VBP|VDD \$5233 VOUT|VSN|VSP$68 VBP|VDD sg13_lv_pmos L=0.13u W=0.15u
+ AS=0.1005p AD=0.1005p PS=1.34u PD=1.34u
M$3914 VIN|VOUT$169 VOUT|VSN|VSP$68 VIN|VOUT$170 VBP|VDD sg13_lv_pmos L=0.13u
+ W=0.3u AS=0.156p AD=0.156p PS=2.08u PD=2.08u
M$3916 VIN|VOUT$170 VOUT|VSN|VSP$66 VIN|VOUT$4 VBP|VDD sg13_lv_pmos L=0.13u
+ W=0.3u AS=0.156p AD=0.156p PS=2.08u PD=2.08u
.ENDS 8xPI_top

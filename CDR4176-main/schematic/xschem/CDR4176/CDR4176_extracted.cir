* Extracted by KLayout with SG13G2 LVS runset on : 28/03/2026 23:43

.SUBCKT CDR4176 VBN|VSS VIN|VOUT VIN|VINB|VOUT
+ PH270|VIN|VINB|VIND|VINQB|VOUT VIN|VOUT$1 SQ[1]|VIN|VOUT|VS|VSN|VSP|VS[1]
+ VOUT|VSN|VSP VOUT|VSN|VSP$1 VOUT|VSN|VSP$2 VIN|VOUT$2 VIN|VOUT$3 VIN|VOUT$4
+ STQ[7]|VIN|VOUT|VS|VSN|VSP|VST|VST[7] VOUT|VSN|VSP$3 VOUT|VSN|VSP$4
+ VOUT|VSN|VSP$5 PH90|VIN|VINA|VINC|VINQ|VOUT VIN|VOUT$5 VIN|VOUT$6 VIN|VOUT$7
+ VIN|VOUT$8 VIN|VINA|VOUT VIN|VOUT$9 SQ[0]|VIN|VOUT|VS|VSN|VSP|VS[0]
+ VOUT|VSN|VSP$6 VOUT|VSN|VSP$7 VOUT|VSN|VSP$8 CLKN|VIN|VOUT|VOUTDP
+ CLKN|VIN|VOUT|VOUTDP$1 VIN|VOUT$10 VIN|VOUT$11 PH0|PH3|V3|VIN|VOUT|VOUTDP
+ VIN|VOUT$12 PH0|PH1|V1|VIN|VOUT|VOUTDN VIN|VOUT$13
+ PH0|PH1|PH5|V5|VIN|VOUT|VOUTDP VIN|VOUT$14 VIN|VOUT$15 CLKN|VIN|VOUT|VOUTDP$2
+ VIN|VOUT$16 VIN|VOUT$17 VIN|VOUT$18 VIN|VOUT$19 VIN|VOUT$20 VIN|VOUT$21
+ VBP|VDD VIN|VOUT$22 VIN|VOUT$23 VIN|VOUT$24 VIN|VOUT$25 VIN|VOUT$26
+ VIN|VOUT$27 VIN|VOUT$28 VIN|VOUT$29 VIN|VOUT$30 VIN|VOUT$31 VIN|VOUT$32
+ VIN|VINB|VOUT$1 VOUT|VSN|VSP$9 VOUT|VSN|VSP$10 VOUT|VSN|VSP$11 VIN VIN$1
+ VIN$2 VIN$3 VIN$4 VIN$5 VIN|VOUT$33 VIN|VOUT$34 VIN|VOUT$35
+ STQ[6]|VIN|VOUT|VS|VSN|VSP|VST|VST[6] VOUT|VSN|VSP$12 VOUT|VSN|VSP$13
+ VOUT|VSN|VSP$14 VIN|VOUT$36 VIN|VOUT$37 VIN|VOUT$38 VOUT|VSN|VSP$15
+ VIN|VINA|VOUT$1 VOUT|VSN|VSP$16 VIN|VOUT$39 VIN|VOUT$40 VOUT|VSN|VSP$17
+ VIN|VOUT$41 CLKP|VIN|VOUT|VOUTDN VIN|VOUT$42 CLKP|VIN|VOUT|VOUTDN$1
+ VIN|VOUT$43 CLKP|VIN|VOUT|VOUTDN$2 VIN|VOUT$44 VIN|VOUT$45 VIN|VOUT$46
+ VIN|VOUT$47 VIN|VOUT$48 VIN|VOUT$49 VIN|VOUT$50 VIN|VOUT$51
+ PH0|PH1|V0|VIN|VOUT|VOUTDN PH0|PH1|PH4|V4|VIN|VOUT|VOUTDP
+ PH1|PH2|V2|VIN|VOUT|VOUTDN VIN|VOUT$52 VIN|VOUT$53 VIN|VOUT$54 VIN|VOUT$55
+ VIN|VOUT$56 VIN|VOUT$57 VIN|VOUT$58 VIN|VOUT$59 VIN|VOUT$60 VIN|VOUT$61
+ VIN|VINB|VOUT$2 VIN|VOUT$62 VOUT|VSN|VSP$18 CTRL|VCONT VOUT|VSN|VSP$19
+ VOUT|VSN|VSP$20 VIN|VOUT$63 VIN|VOUT$64 VIN|VOUT$65 VIN|VOUT$66
+ STQ[5]|VIN|VOUT|VS|VSN|VSP|VST|VST[5] VOUT|VSN|VSP$21 VOUT|VSN|VSP$22
+ VOUT|VSN|VSP$23 VIN|VOUT$67 VIN|VOUT$68 VIN|VINA|VOUT$2 VIN|VOUT$69
+ VIN|VOUT$70 VOUT|VSN|VSP$24 VOUT|VSN|VSP$25 VOUT|VSN|VSP$26
+ PH180|VIN|VINB|VINIB|VOUT VIN|VOUT$71 VIN|VOUT$72 VIN|VOUT$73 VIN|VOUT$74
+ VOUT|VSN|VSP$27 VIN|VINB|VOUT$3 VOUT|VSN|VSP$28 VOUT|VSN|VSP$29 VIN|VOUT$75
+ VIN|VOUT$76 VIN|VOUT$77 VIN|VOUT$78 VIN|VOUT$79 VIN|VOUT$80 VIN|VOUT$81
+ VIN|VOUT$82 VIN|VOUT$83 VIN|VOUT$84 STQ[4]|VIN|VOUT|VS|VSN|VSP|VST|VST[4]
+ VOUT|VSN|VSP$30 VOUT|VSN|VSP$31 VOUT|VSN|VSP$32 VIN|VOUT$85 VIN|VOUT$86
+ VIN|VINA|VOUT$3 VIN|VOUT$87 VIN|VOUT$88 VOUT|VSN|VSP$33 VOUT|VSN|VSP$34
+ VOUT|VSN|VSP$35 VIN|VOUT$89 D|VIN|VOUT D|VIN|VOUT$1 D|VIN|VOUT$2
+ PH0|VIN|VINA|VINI|VOUT VIN|VOUT$90 CLK|CLKIN|VIN|VINPI|VOUT|VSN|VSP
+ VIN|VOUT$91 VIN|VOUT$92 VIN|VOUT$93 VIN|VOUT$94 VIN|VOUT$95 VIN|VOUT$96
+ VIN|VOUT$97 VIN|VOUT$98 VIN|VOUT$99 VIN|VOUT$100 VIN|VOUT$101 VIN|VOUT$102
+ VIN|VOUT$103 VIN|VOUT$104 VIN|VOUT$105 VIN|VOUT$106 VIN|VOUT$107 VIN|VOUT$108
+ VIN|VOUT$109 CLKOUT|Q|VIN|VOUT VOUT|VSN|VSP$36 VOUT|VSN|VSP$37
+ CLK|CLKIN|CLKOUT|Q|VIN|VOUT|VSN|VSP VOUT|VSN|VSP$38
+ CLK|CLKIN|CLKOUT|Q|VIN|VOUT|VSN|VSP$1 PH1|VIN|VOUT VIN|VOUT$110
+ VIN|VINB|VOUT$4 VIN|VOUT$111 VIN|VOUT$112 VIN|VOUT$113 VIN|VOUT$114
+ VIN|VOUT$115 VIN|VOUT$116 VIN|VOUT$117 VOUT|VSN|VSP$39 VOUT|VSN|VSP$40 VOUT
+ PH0|VIN|VOUT VOUT|VSN|VSP$41 VIN|VOUT$118 VIN|VOUT$119 VIN|VOUT$120
+ VIN|VOUT$121 VIN|VOUT$122 VIN|VOUT$123 VIN|VOUT$124
+ STQ[3]|VIN|VOUT|VS|VSN|VSP|VST|VST[3] VOUT|VSN|VSP$42 VOUT|VSN|VSP$43
+ VIN|VOUT$125 VIN|VOUT$126 VIN|VOUT$127 VIN|VOUT$128 VIN|VOUT$129
+ VOUT|VSN|VSP$44 VIN|VOUT$130 VIN|VINA|VOUT$4 VIN|VOUT$131 VIN|VOUT$132
+ VOUT|VSN|VSP$45 VIN|VOUT$133 VIN|VOUT$134 VOUT|VSN|VSP$46 VOUT|VSN|VSP$47
+ VIN|VOUT$135 VIN|VOUT$136 VIN|VOUT$137 VIN|VOUT$138 VIN|VOUT$139 VIN|VOUT$140
+ VIN|VOUT$141 VIN|VINB|VOUT$5 VOUT|VSN|VSP$48 VOUT|VSN|VSP$49 VOUT|VSN|VSP$50
+ VOUT|VSN|VSS A|S[4]|VIN|VOUT|VS[4] B|S[3]|VDD|VIN|VSP|VS[3] VIN|VOUT$142
+ VIN|VOUT$143 VIN|VOUT$144 VIN|VOUT$145 VIN|VOUT$146 VIN|VOUT$147 VIN|VOUT$148
+ STQ[2]|VIN|VOUT|VS|VSN|VSP|VST|VST[2] VOUT|VSN|VSP$51 VOUT|VSN|VSP$52
+ VOUT|VSN|VSP$53 VIN|VOUT$149 VIN|VINA|VOUT$5 VIN|VOUT$150 VIN|VOUT$151
+ VOUT|VSN|VSP$54 VIN|VOUT$152 VOUT|VSN|VSP$55 VOUT|VSN|VSP$56 VIN|VOUT$153
+ VIN|VOUT$154 B|OUT|ST[7]|VDD|VIN|VSP VOUT|VSN|VSS$1 VIN|VOUT$155 A|VIN|VOUT
+ VIN|VOUT$156 VIN|VOUT$157 VIN|VOUT$158 VIN|VOUT$159 VIN|VOUT$160
+ VOUT|VSN|VSS$2 A|VIN|VOUT$1 B|OUT|ST[6]|VDD|VIN|VSP VIN|VOUT$161 VIN|VOUT$162
+ VIN|VINB|VOUT$6 PH1|PHOUT|VIN|VOUT VIN|VOUT$163 VOUT|VSN|VSP$57
+ VOUT|VSN|VSP$58 PH0|PHOUT|VIN|VOUT VOUT|VSN|VSP$59 VIN|VOUT$164 VIN|VOUT$165
+ VIN|VOUT$166 B|OUT|ST[5]|VDD|VIN|VSP VOUT|VSN|VSS$3 A|VIN|VOUT$2 VIN|VOUT$167
+ VIN|VOUT$168 VIN|VOUT$169 VIN|VOUT$170 VIN|VOUT$171 VIN|VOUT$172 VIN|VOUT$173
+ VIN|VOUT$174 STQ[1]|VIN|VOUT|VS|VSN|VSP|VST|VST[1] VOUT|VSN|VSP$60
+ VOUT|VSN|VSP$61 VOUT|VSN|VSP$62 B|ST[4]|VDD|VIN|VOUT|VSP VOUT|VSN|VSS$4
+ A|VIN|VOUT$3 VIN|VOUT$175 VIN|VOUT$176 VIN|VINA|VOUT$6 VIN|VOUT$177
+ VIN|VOUT$178 VOUT|VSN|VSP$63 VOUT|VSN|VSP$64 VIN|VOUT$179 VIN|VOUT$180
+ VOUT|VSN|VSP$65 VOUT|VSN|VSS$5 B|OUT|ST[3]|VDD|VIN|VSP A|VIN|VOUT$4
+ VIN|VOUT$181 VIN|VOUT$182 VIN|VOUT$183 B|OUT|ST[1]|VDD|VIN|VSP
+ B|OUT|ST[2]|VDD|VIN|VSP VOUT|VSN|VSS$6 A|VIN|VOUT$5 A|OUT|VOUT VIN|VOUT$184
+ A|B|VOUT A|B|VOUT$1 B|C|VIN|VOUT A|OUT|VOUT$1 VIN|VOUT$185 VIN|VOUT$186
+ VOUT|VSN|VSP$66 VIN|VINB|VOUT$7 VOUT|VSN|VSP$67 VOUT|VSN|VSP$68
+ VOUT|VSN|VSS$7 A|VIN|VOUT$6 VIN|VOUT$187 OUT|VIN OUT|VIN$1 VIN|VOUT$188
+ VIN|VOUT$189 SQ[2]|VIN|VOUT|VS|VSN|VSP|VST|VST[0] VOUT|VSN|VSP$69
+ VOUT|VSN|VSP$70 VOUT|VSN|VSP$71 VIN|VOUT$190 VIN|VOUT$191 VIN|VOUT$192
+ VIN|VINA|VOUT$7 VIN|VOUT$193 VIN|VOUT$194 VOUT|VSN|VSP$72 VIN|VOUT$195
+ VOUT|VSN|VSP$73 VOUT|VSN|VSP$74 S[2]|VIN|VS[2] S[1]|VIN|VS[1] S[0]|VIN|VS[0]
+ VIN|VOUT$196 VIN|VOUT$197
M$1 VBN|VSS PH270|VIN|VINB|VIND|VINQB|VOUT VIN|VOUT$1 VBN|VSS sg13_lv_nmos
+ L=0.13u W=0.3u AS=0.156p AD=0.156p PS=2.08u PD=2.08u
M$3 VIN|VOUT$1 SQ[1]|VIN|VOUT|VS|VSN|VSP|VS[1] VIN|VOUT VBN|VSS sg13_lv_nmos
+ L=0.13u W=0.15u AS=0.1005p AD=0.1005p PS=1.34u PD=1.34u
M$4 VIN|VOUT$1 VOUT|VSN|VSP VIN|VOUT VBN|VSS sg13_lv_nmos L=0.13u W=0.3u
+ AS=0.201p AD=0.201p PS=2.68u PD=2.68u
M$5 VBN|VSS \$16 VOUT|VSN|VSP VBN|VSS sg13_lv_nmos L=0.13u W=0.15u AS=0.1005p
+ AD=0.1005p PS=1.34u PD=1.34u
M$7 VIN|VOUT VOUT|VSN|VSP$2 VIN|VINB|VOUT VBN|VSS sg13_lv_nmos L=0.13u W=0.15u
+ AS=0.1005p AD=0.1005p PS=1.34u PD=1.34u
M$8 VBN|VSS SQ[1]|VIN|VOUT|VS|VSN|VSP|VS[1] VOUT|VSN|VSP$1 VBN|VSS sg13_lv_nmos
+ L=0.13u W=0.15u AS=0.1005p AD=0.1005p PS=1.34u PD=1.34u
M$9 VBN|VSS PH90|VIN|VINA|VINC|VINQ|VOUT VIN|VOUT$5 VBN|VSS sg13_lv_nmos
+ L=0.13u W=0.3u AS=0.156p AD=0.156p PS=2.08u PD=2.08u
M$11 VIN|VOUT$5 VOUT|VSN|VSP$1 VIN|VOUT$2 VBN|VSS sg13_lv_nmos L=0.13u W=0.3u
+ AS=0.201p AD=0.201p PS=2.68u PD=2.68u
M$13 VBN|VSS \$24 \$24 VBN|VSS sg13_lv_nmos L=0.13u W=0.15u AS=0.1005p
+ AD=0.1005p PS=1.34u PD=1.34u
M$14 VIN|VOUT$5 VOUT|VSN|VSP VIN|VOUT$2 VBN|VSS sg13_lv_nmos L=0.13u W=0.15u
+ AS=0.1005p AD=0.1005p PS=1.34u PD=1.34u
M$15 VIN|VOUT$2 VOUT|VSN|VSP$2 VIN|VINB|VOUT VBN|VSS sg13_lv_nmos L=0.13u
+ W=0.15u AS=0.1005p AD=0.1005p PS=1.34u PD=1.34u
M$16 VBN|VSS VIN|VINB|VOUT VIN|VOUT$6 VBN|VSS sg13_lv_nmos L=0.13u W=0.3u
+ AS=0.156p AD=0.156p PS=2.08u PD=2.08u
M$18 VIN|VOUT$6 STQ[7]|VIN|VOUT|VS|VSN|VSP|VST|VST[7] VIN|VOUT$3 VBN|VSS
+ sg13_lv_nmos L=0.13u W=0.15u AS=0.1005p AD=0.1005p PS=1.34u PD=1.34u
M$19 VIN|VOUT$6 VOUT|VSN|VSP$3 VIN|VOUT$3 VBN|VSS sg13_lv_nmos L=0.13u W=0.3u
+ AS=0.201p AD=0.201p PS=2.68u PD=2.68u
M$20 VBN|VSS \$49 VOUT|VSN|VSP$3 VBN|VSS sg13_lv_nmos L=0.13u W=0.15u
+ AS=0.1005p AD=0.1005p PS=1.34u PD=1.34u
M$22 VIN|VOUT$3 VOUT|VSN|VSP$5 VIN|VOUT$4 VBN|VSS sg13_lv_nmos L=0.13u W=0.15u
+ AS=0.1005p AD=0.1005p PS=1.34u PD=1.34u
M$23 VBN|VSS PH180|VIN|VINB|VINIB|VOUT VIN|VOUT$7 VBN|VSS sg13_lv_nmos L=0.13u
+ W=0.3u AS=0.156p AD=0.156p PS=2.08u PD=2.08u
M$25 VIN|VOUT$7 SQ[0]|VIN|VOUT|VS|VSN|VSP|VS[0] VIN|VOUT$8 VBN|VSS sg13_lv_nmos
+ L=0.13u W=0.15u AS=0.1005p AD=0.1005p PS=1.34u PD=1.34u
M$26 VIN|VOUT$7 VOUT|VSN|VSP$6 VIN|VOUT$8 VBN|VSS sg13_lv_nmos L=0.13u W=0.3u
+ AS=0.201p AD=0.201p PS=2.68u PD=2.68u
M$27 VBN|VSS \$98 VOUT|VSN|VSP$6 VBN|VSS sg13_lv_nmos L=0.13u W=0.15u
+ AS=0.1005p AD=0.1005p PS=1.34u PD=1.34u
M$29 VIN|VOUT$8 VOUT|VSN|VSP$7 VIN|VINA|VOUT VBN|VSS sg13_lv_nmos L=0.13u
+ W=0.15u AS=0.1005p AD=0.1005p PS=1.34u PD=1.34u
M$30 VBN|VSS STQ[7]|VIN|VOUT|VS|VSN|VSP|VST|VST[7] VOUT|VSN|VSP$4 VBN|VSS
+ sg13_lv_nmos L=0.13u W=0.15u AS=0.1005p AD=0.1005p PS=1.34u PD=1.34u
M$31 VBN|VSS VIN|VINA|VOUT VIN|VOUT$10 VBN|VSS sg13_lv_nmos L=0.13u W=0.3u
+ AS=0.156p AD=0.156p PS=2.08u PD=2.08u
M$33 VIN|VOUT$10 VOUT|VSN|VSP$4 VIN|VOUT$9 VBN|VSS sg13_lv_nmos L=0.13u W=0.3u
+ AS=0.201p AD=0.201p PS=2.68u PD=2.68u
M$35 VBN|VSS \$75 \$75 VBN|VSS sg13_lv_nmos L=0.13u W=0.15u AS=0.1005p
+ AD=0.1005p PS=1.34u PD=1.34u
M$36 VIN|VOUT$10 VOUT|VSN|VSP$3 VIN|VOUT$9 VBN|VSS sg13_lv_nmos L=0.13u W=0.15u
+ AS=0.1005p AD=0.1005p PS=1.34u PD=1.34u
M$37 VIN|VOUT$9 VOUT|VSN|VSP$5 VIN|VOUT$4 VBN|VSS sg13_lv_nmos L=0.13u W=0.15u
+ AS=0.1005p AD=0.1005p PS=1.34u PD=1.34u
M$38 VBN|VSS CLKN|VIN|VOUT|VOUTDP VIN|VOUT$11 VBN|VSS sg13_lv_nmos L=0.13u
+ W=0.15u AS=0.1005p AD=0.1005p PS=1.34u PD=1.34u
M$39 VBN|VSS VIN|VOUT$11 VIN|VOUT$14 VBN|VSS sg13_lv_nmos L=0.13u W=0.3u
+ AS=0.156p AD=0.156p PS=2.08u PD=2.08u
M$41 VBN|VSS VIN|VOUT$14 VIN|VOUT$15 VBN|VSS sg13_lv_nmos L=0.13u W=0.6u
+ AS=0.312p AD=0.312p PS=4.16u PD=4.16u
M$45 VBN|VSS VIN|VOUT$15 PH0|PH3|V3|VIN|VOUT|VOUTDP VBN|VSS sg13_lv_nmos
+ L=0.13u W=1.2u AS=0.624p AD=0.624p PS=8.32u PD=8.32u
M$53 VBN|VSS CLKN|VIN|VOUT|VOUTDP$1 VIN|VOUT$12 VBN|VSS sg13_lv_nmos L=0.13u
+ W=0.15u AS=0.1005p AD=0.1005p PS=1.34u PD=1.34u
M$54 VBN|VSS VIN|VOUT$12 VIN|VOUT$16 VBN|VSS sg13_lv_nmos L=0.13u W=0.3u
+ AS=0.156p AD=0.156p PS=2.08u PD=2.08u
M$56 VBN|VSS VIN|VOUT$16 VIN|VOUT$17 VBN|VSS sg13_lv_nmos L=0.13u W=0.6u
+ AS=0.312p AD=0.312p PS=4.16u PD=4.16u
M$60 VBN|VSS VIN|VOUT$17 PH0|PH1|V1|VIN|VOUT|VOUTDN VBN|VSS sg13_lv_nmos
+ L=0.13u W=1.2u AS=0.624p AD=0.624p PS=8.32u PD=8.32u
M$68 VBN|VSS CLKN|VIN|VOUT|VOUTDP$2 VIN|VOUT$13 VBN|VSS sg13_lv_nmos L=0.13u
+ W=0.15u AS=0.1005p AD=0.1005p PS=1.34u PD=1.34u
M$69 VBN|VSS VIN|VOUT$13 VIN|VOUT$18 VBN|VSS sg13_lv_nmos L=0.13u W=0.3u
+ AS=0.156p AD=0.156p PS=2.08u PD=2.08u
M$71 VBN|VSS VIN|VOUT$18 VIN|VOUT$19 VBN|VSS sg13_lv_nmos L=0.13u W=0.6u
+ AS=0.312p AD=0.312p PS=4.16u PD=4.16u
M$75 VBN|VSS VIN|VOUT$19 PH0|PH1|PH5|V5|VIN|VOUT|VOUTDP VBN|VSS sg13_lv_nmos
+ L=0.13u W=1.2u AS=0.624p AD=0.624p PS=8.32u PD=8.32u
M$83 VBN|VSS SQ[0]|VIN|VOUT|VS|VSN|VSP|VS[0] VOUT|VSN|VSP$8 VBN|VSS
+ sg13_lv_nmos L=0.13u W=0.15u AS=0.1005p AD=0.1005p PS=1.34u PD=1.34u
M$84 VBN|VSS PH0|VIN|VINA|VINI|VOUT VIN|VOUT$20 VBN|VSS sg13_lv_nmos L=0.13u
+ W=0.3u AS=0.156p AD=0.156p PS=2.08u PD=2.08u
M$86 VIN|VOUT$20 VOUT|VSN|VSP$8 VIN|VOUT$21 VBN|VSS sg13_lv_nmos L=0.13u W=0.3u
+ AS=0.201p AD=0.201p PS=2.68u PD=2.68u
M$88 VBN|VSS \$135 \$135 VBN|VSS sg13_lv_nmos L=0.13u W=0.15u AS=0.1005p
+ AD=0.1005p PS=1.34u PD=1.34u
M$89 VIN|VOUT$20 VOUT|VSN|VSP$6 VIN|VOUT$21 VBN|VSS sg13_lv_nmos L=0.13u
+ W=0.15u AS=0.1005p AD=0.1005p PS=1.34u PD=1.34u
M$90 VIN|VOUT$21 VOUT|VSN|VSP$7 VIN|VINA|VOUT VBN|VSS sg13_lv_nmos L=0.13u
+ W=0.15u AS=0.1005p AD=0.1005p PS=1.34u PD=1.34u
M$91 VBN|VSS VIN|VOUT$22 CLKN|VIN|VOUT|VOUTDP VBN|VSS sg13_lv_nmos L=0.13u
+ W=1.2u AS=0.624p AD=0.624p PS=8.32u PD=8.32u
M$99 VBN|VSS VIN|VOUT$23 VIN|VOUT$22 VBN|VSS sg13_lv_nmos L=0.13u W=0.6u
+ AS=0.312p AD=0.312p PS=4.16u PD=4.16u
M$103 VBN|VSS VIN|VOUT$24 VIN|VOUT$23 VBN|VSS sg13_lv_nmos L=0.13u W=0.3u
+ AS=0.156p AD=0.156p PS=2.08u PD=2.08u
M$105 VIN|VOUT$24 VIN$1 VBN|VSS VBN|VSS sg13_lv_nmos L=0.13u W=0.15u AS=0.1005p
+ AD=0.1005p PS=1.34u PD=1.34u
M$106 VBN|VSS VIN|VOUT$25 CLKN|VIN|VOUT|VOUTDP$1 VBN|VSS sg13_lv_nmos L=0.13u
+ W=1.2u AS=0.624p AD=0.624p PS=8.32u PD=8.32u
M$114 VBN|VSS VIN|VOUT$26 VIN|VOUT$25 VBN|VSS sg13_lv_nmos L=0.13u W=0.6u
+ AS=0.312p AD=0.312p PS=4.16u PD=4.16u
M$118 VBN|VSS VIN|VOUT$27 VIN|VOUT$26 VBN|VSS sg13_lv_nmos L=0.13u W=0.3u
+ AS=0.156p AD=0.156p PS=2.08u PD=2.08u
M$120 VIN|VOUT$27 VIN$3 VBN|VSS VBN|VSS sg13_lv_nmos L=0.13u W=0.15u AS=0.1005p
+ AD=0.1005p PS=1.34u PD=1.34u
M$121 VBN|VSS VIN|VOUT$28 CLKN|VIN|VOUT|VOUTDP$2 VBN|VSS sg13_lv_nmos L=0.13u
+ W=1.2u AS=0.624p AD=0.624p PS=8.32u PD=8.32u
M$129 VBN|VSS VIN|VOUT$29 VIN|VOUT$28 VBN|VSS sg13_lv_nmos L=0.13u W=0.6u
+ AS=0.312p AD=0.312p PS=4.16u PD=4.16u
M$133 VBN|VSS VIN|VOUT$30 VIN|VOUT$29 VBN|VSS sg13_lv_nmos L=0.13u W=0.3u
+ AS=0.156p AD=0.156p PS=2.08u PD=2.08u
M$135 VIN|VOUT$30 VIN$5 VBN|VSS VBN|VSS sg13_lv_nmos L=0.13u W=0.15u AS=0.1005p
+ AD=0.1005p PS=1.34u PD=1.34u
M$136 VBN|VSS PH270|VIN|VINB|VIND|VINQB|VOUT VIN|VOUT$31 VBN|VSS sg13_lv_nmos
+ L=0.13u W=0.3u AS=0.156p AD=0.156p PS=2.08u PD=2.08u
M$138 VIN|VOUT$31 SQ[1]|VIN|VOUT|VS|VSN|VSP|VS[1] VIN|VOUT$32 VBN|VSS
+ sg13_lv_nmos L=0.13u W=0.15u AS=0.1005p AD=0.1005p PS=1.34u PD=1.34u
M$139 VIN|VOUT$31 VOUT|VSN|VSP$10 VIN|VOUT$32 VBN|VSS sg13_lv_nmos L=0.13u
+ W=0.3u AS=0.201p AD=0.201p PS=2.68u PD=2.68u
M$140 VBN|VSS \$991 VOUT|VSN|VSP$10 VBN|VSS sg13_lv_nmos L=0.13u W=0.15u
+ AS=0.1005p AD=0.1005p PS=1.34u PD=1.34u
M$142 VIN|VOUT$32 VOUT|VSN|VSP$11 VIN|VINB|VOUT$1 VBN|VSS sg13_lv_nmos L=0.13u
+ W=0.15u AS=0.1005p AD=0.1005p PS=1.34u PD=1.34u
M$143 VBN|VSS CLKP|VIN|VOUT|VOUTDN$2 VIN VBN|VSS sg13_lv_nmos L=0.13u W=4.5u
+ AS=1.8p AD=1.665p PS=24u PD=22.2u
M$153 VBN|VSS CLKN|VIN|VOUT|VOUTDP$2 VIN$1 VBN|VSS sg13_lv_nmos L=0.13u W=4.5u
+ AS=1.665p AD=1.8p PS=22.2u PD=24u
M$163 VBN|VSS CLKP|VIN|VOUT|VOUTDN VIN$2 VBN|VSS sg13_lv_nmos L=0.13u W=4.5u
+ AS=1.8p AD=1.665p PS=24u PD=22.2u
M$173 VBN|VSS CLKN|VIN|VOUT|VOUTDP VIN$3 VBN|VSS sg13_lv_nmos L=0.13u W=4.5u
+ AS=1.665p AD=1.8p PS=22.2u PD=24u
M$183 VBN|VSS CLKP|VIN|VOUT|VOUTDN$1 VIN$4 VBN|VSS sg13_lv_nmos L=0.13u W=4.5u
+ AS=1.8p AD=1.665p PS=24u PD=22.2u
M$193 VBN|VSS CLKN|VIN|VOUT|VOUTDP$1 VIN$5 VBN|VSS sg13_lv_nmos L=0.13u W=4.5u
+ AS=1.665p AD=1.8p PS=22.2u PD=24u
M$323 VBN|VSS SQ[1]|VIN|VOUT|VS|VSN|VSP|VS[1] VOUT|VSN|VSP$9 VBN|VSS
+ sg13_lv_nmos L=0.13u W=0.15u AS=0.1005p AD=0.1005p PS=1.34u PD=1.34u
M$324 VBN|VSS PH90|VIN|VINA|VINC|VINQ|VOUT VIN|VOUT$34 VBN|VSS sg13_lv_nmos
+ L=0.13u W=0.3u AS=0.156p AD=0.156p PS=2.08u PD=2.08u
M$326 VIN|VOUT$34 VOUT|VSN|VSP$9 VIN|VOUT$33 VBN|VSS sg13_lv_nmos L=0.13u
+ W=0.3u AS=0.201p AD=0.201p PS=2.68u PD=2.68u
M$328 VBN|VSS \$1283 \$1283 VBN|VSS sg13_lv_nmos L=0.13u W=0.15u AS=0.1005p
+ AD=0.1005p PS=1.34u PD=1.34u
M$329 VIN|VOUT$34 VOUT|VSN|VSP$10 VIN|VOUT$33 VBN|VSS sg13_lv_nmos L=0.13u
+ W=0.15u AS=0.1005p AD=0.1005p PS=1.34u PD=1.34u
M$330 VIN|VOUT$33 VOUT|VSN|VSP$11 VIN|VINB|VOUT$1 VBN|VSS sg13_lv_nmos L=0.13u
+ W=0.15u AS=0.1005p AD=0.1005p PS=1.34u PD=1.34u
M$331 VBN|VSS VIN|VINB|VOUT$1 VIN|VOUT$36 VBN|VSS sg13_lv_nmos L=0.13u W=0.3u
+ AS=0.156p AD=0.156p PS=2.08u PD=2.08u
M$333 VIN|VOUT$36 STQ[6]|VIN|VOUT|VS|VSN|VSP|VST|VST[6] VIN|VOUT$35 VBN|VSS
+ sg13_lv_nmos L=0.13u W=0.15u AS=0.1005p AD=0.1005p PS=1.34u PD=1.34u
M$334 VIN|VOUT$36 VOUT|VSN|VSP$12 VIN|VOUT$35 VBN|VSS sg13_lv_nmos L=0.13u
+ W=0.3u AS=0.201p AD=0.201p PS=2.68u PD=2.68u
M$335 VBN|VSS \$1313 VOUT|VSN|VSP$12 VBN|VSS sg13_lv_nmos L=0.13u W=0.15u
+ AS=0.1005p AD=0.1005p PS=1.34u PD=1.34u
M$337 VIN|VOUT$35 VOUT|VSN|VSP$14 VIN|VOUT$4 VBN|VSS sg13_lv_nmos L=0.13u
+ W=0.15u AS=0.1005p AD=0.1005p PS=1.34u PD=1.34u
M$338 VIN CTRL|VCONT \$1320 VBN|VSS sg13_lv_nmos L=0.13u W=0.3u AS=0.156p
+ AD=0.156p PS=2.08u PD=2.08u
M$340 VIN$1 CTRL|VCONT \$1321 VBN|VSS sg13_lv_nmos L=0.13u W=0.3u AS=0.156p
+ AD=0.156p PS=2.08u PD=2.08u
M$342 VIN$2 CTRL|VCONT \$1322 VBN|VSS sg13_lv_nmos L=0.13u W=0.3u AS=0.156p
+ AD=0.156p PS=2.08u PD=2.08u
M$344 VIN$3 CTRL|VCONT \$1323 VBN|VSS sg13_lv_nmos L=0.13u W=0.3u AS=0.156p
+ AD=0.156p PS=2.08u PD=2.08u
M$346 VIN$4 CTRL|VCONT \$1324 VBN|VSS sg13_lv_nmos L=0.13u W=0.3u AS=0.156p
+ AD=0.156p PS=2.08u PD=2.08u
M$348 VIN$5 CTRL|VCONT \$1325 VBN|VSS sg13_lv_nmos L=0.13u W=0.3u AS=0.156p
+ AD=0.156p PS=2.08u PD=2.08u
M$350 VBN|VSS PH180|VIN|VINB|VINIB|VOUT VIN|VOUT$37 VBN|VSS sg13_lv_nmos
+ L=0.13u W=0.3u AS=0.156p AD=0.156p PS=2.08u PD=2.08u
M$352 VIN|VOUT$37 SQ[0]|VIN|VOUT|VS|VSN|VSP|VS[0] VIN|VOUT$38 VBN|VSS
+ sg13_lv_nmos L=0.13u W=0.15u AS=0.1005p AD=0.1005p PS=1.34u PD=1.34u
M$353 VIN|VOUT$37 VOUT|VSN|VSP$15 VIN|VOUT$38 VBN|VSS sg13_lv_nmos L=0.13u
+ W=0.3u AS=0.201p AD=0.201p PS=2.68u PD=2.68u
M$354 VBN|VSS \$1396 VOUT|VSN|VSP$15 VBN|VSS sg13_lv_nmos L=0.13u W=0.15u
+ AS=0.1005p AD=0.1005p PS=1.34u PD=1.34u
M$356 VIN|VOUT$38 VOUT|VSN|VSP$16 VIN|VINA|VOUT$1 VBN|VSS sg13_lv_nmos L=0.13u
+ W=0.15u AS=0.1005p AD=0.1005p PS=1.34u PD=1.34u
M$357 VBN|VSS STQ[6]|VIN|VOUT|VS|VSN|VSP|VST|VST[6] VOUT|VSN|VSP$13 VBN|VSS
+ sg13_lv_nmos L=0.13u W=0.15u AS=0.1005p AD=0.1005p PS=1.34u PD=1.34u
M$358 VBN|VSS VIN|VINA|VOUT$1 VIN|VOUT$39 VBN|VSS sg13_lv_nmos L=0.13u W=0.3u
+ AS=0.156p AD=0.156p PS=2.08u PD=2.08u
M$360 VIN|VOUT$39 VOUT|VSN|VSP$13 VIN|VOUT$40 VBN|VSS sg13_lv_nmos L=0.13u
+ W=0.3u AS=0.201p AD=0.201p PS=2.68u PD=2.68u
M$362 VBN|VSS \$1370 \$1370 VBN|VSS sg13_lv_nmos L=0.13u W=0.15u AS=0.1005p
+ AD=0.1005p PS=1.34u PD=1.34u
M$363 VIN|VOUT$39 VOUT|VSN|VSP$12 VIN|VOUT$40 VBN|VSS sg13_lv_nmos L=0.13u
+ W=0.15u AS=0.1005p AD=0.1005p PS=1.34u PD=1.34u
M$364 VIN|VOUT$40 VOUT|VSN|VSP$14 VIN|VOUT$4 VBN|VSS sg13_lv_nmos L=0.13u
+ W=0.15u AS=0.1005p AD=0.1005p PS=1.34u PD=1.34u
M$365 VBN|VSS VIN VIN|VOUT$41 VBN|VSS sg13_lv_nmos L=0.13u W=0.15u AS=0.1005p
+ AD=0.1005p PS=1.34u PD=1.34u
M$366 VBN|VSS VIN|VOUT$41 VIN|VOUT$44 VBN|VSS sg13_lv_nmos L=0.13u W=0.3u
+ AS=0.156p AD=0.156p PS=2.08u PD=2.08u
M$368 VBN|VSS VIN|VOUT$44 VIN|VOUT$45 VBN|VSS sg13_lv_nmos L=0.13u W=0.6u
+ AS=0.312p AD=0.312p PS=4.16u PD=4.16u
M$372 VBN|VSS VIN|VOUT$45 CLKP|VIN|VOUT|VOUTDN VBN|VSS sg13_lv_nmos L=0.13u
+ W=1.2u AS=0.624p AD=0.624p PS=8.32u PD=8.32u
M$380 VBN|VSS VIN$2 VIN|VOUT$42 VBN|VSS sg13_lv_nmos L=0.13u W=0.15u AS=0.1005p
+ AD=0.1005p PS=1.34u PD=1.34u
M$381 VBN|VSS VIN|VOUT$42 VIN|VOUT$46 VBN|VSS sg13_lv_nmos L=0.13u W=0.3u
+ AS=0.156p AD=0.156p PS=2.08u PD=2.08u
M$383 VBN|VSS VIN|VOUT$46 VIN|VOUT$47 VBN|VSS sg13_lv_nmos L=0.13u W=0.6u
+ AS=0.312p AD=0.312p PS=4.16u PD=4.16u
M$387 VBN|VSS VIN|VOUT$47 CLKP|VIN|VOUT|VOUTDN$1 VBN|VSS sg13_lv_nmos L=0.13u
+ W=1.2u AS=0.624p AD=0.624p PS=8.32u PD=8.32u
M$395 VBN|VSS VIN$4 VIN|VOUT$43 VBN|VSS sg13_lv_nmos L=0.13u W=0.15u AS=0.1005p
+ AD=0.1005p PS=1.34u PD=1.34u
M$396 VBN|VSS VIN|VOUT$43 VIN|VOUT$48 VBN|VSS sg13_lv_nmos L=0.13u W=0.3u
+ AS=0.156p AD=0.156p PS=2.08u PD=2.08u
M$398 VBN|VSS VIN|VOUT$48 VIN|VOUT$49 VBN|VSS sg13_lv_nmos L=0.13u W=0.6u
+ AS=0.312p AD=0.312p PS=4.16u PD=4.16u
M$402 VBN|VSS VIN|VOUT$49 CLKP|VIN|VOUT|VOUTDN$2 VBN|VSS sg13_lv_nmos L=0.13u
+ W=1.2u AS=0.624p AD=0.624p PS=8.32u PD=8.32u
M$410 VBN|VSS SQ[0]|VIN|VOUT|VS|VSN|VSP|VS[0] VOUT|VSN|VSP$17 VBN|VSS
+ sg13_lv_nmos L=0.13u W=0.15u AS=0.1005p AD=0.1005p PS=1.34u PD=1.34u
M$411 VBN|VSS PH0|VIN|VINA|VINI|VOUT VIN|VOUT$51 VBN|VSS sg13_lv_nmos L=0.13u
+ W=0.3u AS=0.156p AD=0.156p PS=2.08u PD=2.08u
M$413 VIN|VOUT$51 VOUT|VSN|VSP$17 VIN|VOUT$50 VBN|VSS sg13_lv_nmos L=0.13u
+ W=0.3u AS=0.201p AD=0.201p PS=2.68u PD=2.68u
M$415 VBN|VSS \$1699 \$1699 VBN|VSS sg13_lv_nmos L=0.13u W=0.15u AS=0.1005p
+ AD=0.1005p PS=1.34u PD=1.34u
M$416 VIN|VOUT$51 VOUT|VSN|VSP$15 VIN|VOUT$50 VBN|VSS sg13_lv_nmos L=0.13u
+ W=0.15u AS=0.1005p AD=0.1005p PS=1.34u PD=1.34u
M$417 VIN|VOUT$50 VOUT|VSN|VSP$16 VIN|VINA|VOUT$1 VBN|VSS sg13_lv_nmos L=0.13u
+ W=0.15u AS=0.1005p AD=0.1005p PS=1.34u PD=1.34u
M$418 VBN|VSS VIN|VOUT$52 PH0|PH1|V0|VIN|VOUT|VOUTDN VBN|VSS sg13_lv_nmos
+ L=0.13u W=1.2u AS=0.624p AD=0.624p PS=8.32u PD=8.32u
M$426 VBN|VSS VIN|VOUT$53 VIN|VOUT$52 VBN|VSS sg13_lv_nmos L=0.13u W=0.6u
+ AS=0.312p AD=0.312p PS=4.16u PD=4.16u
M$430 VBN|VSS VIN|VOUT$54 VIN|VOUT$53 VBN|VSS sg13_lv_nmos L=0.13u W=0.3u
+ AS=0.156p AD=0.156p PS=2.08u PD=2.08u
M$432 VIN|VOUT$54 CLKP|VIN|VOUT|VOUTDN VBN|VSS VBN|VSS sg13_lv_nmos L=0.13u
+ W=0.15u AS=0.1005p AD=0.1005p PS=1.34u PD=1.34u
M$433 VBN|VSS VIN|VOUT$55 PH0|PH1|PH4|V4|VIN|VOUT|VOUTDP VBN|VSS sg13_lv_nmos
+ L=0.13u W=1.2u AS=0.624p AD=0.624p PS=8.32u PD=8.32u
M$441 VBN|VSS VIN|VOUT$56 VIN|VOUT$55 VBN|VSS sg13_lv_nmos L=0.13u W=0.6u
+ AS=0.312p AD=0.312p PS=4.16u PD=4.16u
M$445 VBN|VSS VIN|VOUT$57 VIN|VOUT$56 VBN|VSS sg13_lv_nmos L=0.13u W=0.3u
+ AS=0.156p AD=0.156p PS=2.08u PD=2.08u
M$447 VIN|VOUT$57 CLKP|VIN|VOUT|VOUTDN$1 VBN|VSS VBN|VSS sg13_lv_nmos L=0.13u
+ W=0.15u AS=0.1005p AD=0.1005p PS=1.34u PD=1.34u
M$448 VBN|VSS VIN|VOUT$58 PH1|PH2|V2|VIN|VOUT|VOUTDN VBN|VSS sg13_lv_nmos
+ L=0.13u W=1.2u AS=0.624p AD=0.624p PS=8.32u PD=8.32u
M$456 VBN|VSS VIN|VOUT$59 VIN|VOUT$58 VBN|VSS sg13_lv_nmos L=0.13u W=0.6u
+ AS=0.312p AD=0.312p PS=4.16u PD=4.16u
M$460 VBN|VSS VIN|VOUT$60 VIN|VOUT$59 VBN|VSS sg13_lv_nmos L=0.13u W=0.3u
+ AS=0.156p AD=0.156p PS=2.08u PD=2.08u
M$462 VIN|VOUT$60 CLKP|VIN|VOUT|VOUTDN$2 VBN|VSS VBN|VSS sg13_lv_nmos L=0.13u
+ W=0.15u AS=0.1005p AD=0.1005p PS=1.34u PD=1.34u
M$463 VBN|VSS PH270|VIN|VINB|VIND|VINQB|VOUT VIN|VOUT$62 VBN|VSS sg13_lv_nmos
+ L=0.13u W=0.3u AS=0.156p AD=0.156p PS=2.08u PD=2.08u
M$465 VIN|VOUT$62 SQ[1]|VIN|VOUT|VS|VSN|VSP|VS[1] VIN|VOUT$61 VBN|VSS
+ sg13_lv_nmos L=0.13u W=0.15u AS=0.1005p AD=0.1005p PS=1.34u PD=1.34u
M$466 VIN|VOUT$62 VOUT|VSN|VSP$18 VIN|VOUT$61 VBN|VSS sg13_lv_nmos L=0.13u
+ W=0.3u AS=0.201p AD=0.201p PS=2.68u PD=2.68u
M$467 VBN|VSS \$2559 VOUT|VSN|VSP$18 VBN|VSS sg13_lv_nmos L=0.13u W=0.15u
+ AS=0.1005p AD=0.1005p PS=1.34u PD=1.34u
M$469 VIN|VOUT$61 VOUT|VSN|VSP$20 VIN|VINB|VOUT$2 VBN|VSS sg13_lv_nmos L=0.13u
+ W=0.15u AS=0.1005p AD=0.1005p PS=1.34u PD=1.34u
M$470 VBN|VSS SQ[1]|VIN|VOUT|VS|VSN|VSP|VS[1] VOUT|VSN|VSP$19 VBN|VSS
+ sg13_lv_nmos L=0.13u W=0.15u AS=0.1005p AD=0.1005p PS=1.34u PD=1.34u
M$471 VBN|VSS PH90|VIN|VINA|VINC|VINQ|VOUT VIN|VOUT$63 VBN|VSS sg13_lv_nmos
+ L=0.13u W=0.3u AS=0.156p AD=0.156p PS=2.08u PD=2.08u
M$473 VIN|VOUT$63 VOUT|VSN|VSP$19 VIN|VOUT$64 VBN|VSS sg13_lv_nmos L=0.13u
+ W=0.3u AS=0.201p AD=0.201p PS=2.68u PD=2.68u
M$475 VBN|VSS \$2580 \$2580 VBN|VSS sg13_lv_nmos L=0.13u W=0.15u AS=0.1005p
+ AD=0.1005p PS=1.34u PD=1.34u
M$476 VIN|VOUT$63 VOUT|VSN|VSP$18 VIN|VOUT$64 VBN|VSS sg13_lv_nmos L=0.13u
+ W=0.15u AS=0.1005p AD=0.1005p PS=1.34u PD=1.34u
M$477 VIN|VOUT$64 VOUT|VSN|VSP$20 VIN|VINB|VOUT$2 VBN|VSS sg13_lv_nmos L=0.13u
+ W=0.15u AS=0.1005p AD=0.1005p PS=1.34u PD=1.34u
M$478 VBN|VSS VIN|VINB|VOUT$2 VIN|VOUT$65 VBN|VSS sg13_lv_nmos L=0.13u W=0.3u
+ AS=0.156p AD=0.156p PS=2.08u PD=2.08u
M$480 VIN|VOUT$65 STQ[5]|VIN|VOUT|VS|VSN|VSP|VST|VST[5] VIN|VOUT$66 VBN|VSS
+ sg13_lv_nmos L=0.13u W=0.15u AS=0.1005p AD=0.1005p PS=1.34u PD=1.34u
M$481 VIN|VOUT$65 VOUT|VSN|VSP$21 VIN|VOUT$66 VBN|VSS sg13_lv_nmos L=0.13u
+ W=0.3u AS=0.201p AD=0.201p PS=2.68u PD=2.68u
M$482 VBN|VSS \$2617 VOUT|VSN|VSP$21 VBN|VSS sg13_lv_nmos L=0.13u W=0.15u
+ AS=0.1005p AD=0.1005p PS=1.34u PD=1.34u
M$484 VIN|VOUT$66 VOUT|VSN|VSP$23 VIN|VOUT$4 VBN|VSS sg13_lv_nmos L=0.13u
+ W=0.15u AS=0.1005p AD=0.1005p PS=1.34u PD=1.34u
M$485 VBN|VSS PH180|VIN|VINB|VINIB|VOUT VIN|VOUT$67 VBN|VSS sg13_lv_nmos
+ L=0.13u W=0.3u AS=0.156p AD=0.156p PS=2.08u PD=2.08u
M$487 VIN|VOUT$67 SQ[0]|VIN|VOUT|VS|VSN|VSP|VS[0] VIN|VOUT$68 VBN|VSS
+ sg13_lv_nmos L=0.13u W=0.15u AS=0.1005p AD=0.1005p PS=1.34u PD=1.34u
M$488 VIN|VOUT$67 VOUT|VSN|VSP$24 VIN|VOUT$68 VBN|VSS sg13_lv_nmos L=0.13u
+ W=0.3u AS=0.201p AD=0.201p PS=2.68u PD=2.68u
M$489 VBN|VSS \$2685 VOUT|VSN|VSP$24 VBN|VSS sg13_lv_nmos L=0.13u W=0.15u
+ AS=0.1005p AD=0.1005p PS=1.34u PD=1.34u
M$491 VIN|VOUT$68 VOUT|VSN|VSP$25 VIN|VINA|VOUT$2 VBN|VSS sg13_lv_nmos L=0.13u
+ W=0.15u AS=0.1005p AD=0.1005p PS=1.34u PD=1.34u
M$492 VBN|VSS STQ[5]|VIN|VOUT|VS|VSN|VSP|VST|VST[5] VOUT|VSN|VSP$22 VBN|VSS
+ sg13_lv_nmos L=0.13u W=0.15u AS=0.1005p AD=0.1005p PS=1.34u PD=1.34u
M$493 VBN|VSS VIN|VINA|VOUT$2 VIN|VOUT$69 VBN|VSS sg13_lv_nmos L=0.13u W=0.3u
+ AS=0.156p AD=0.156p PS=2.08u PD=2.08u
M$495 VIN|VOUT$69 VOUT|VSN|VSP$22 VIN|VOUT$70 VBN|VSS sg13_lv_nmos L=0.13u
+ W=0.3u AS=0.201p AD=0.201p PS=2.68u PD=2.68u
M$497 VBN|VSS \$2665 \$2665 VBN|VSS sg13_lv_nmos L=0.13u W=0.15u AS=0.1005p
+ AD=0.1005p PS=1.34u PD=1.34u
M$498 VIN|VOUT$69 VOUT|VSN|VSP$21 VIN|VOUT$70 VBN|VSS sg13_lv_nmos L=0.13u
+ W=0.15u AS=0.1005p AD=0.1005p PS=1.34u PD=1.34u
M$499 VIN|VOUT$70 VOUT|VSN|VSP$23 VIN|VOUT$4 VBN|VSS sg13_lv_nmos L=0.13u
+ W=0.15u AS=0.1005p AD=0.1005p PS=1.34u PD=1.34u
M$500 VBN|VSS PH0|PH1|V0|VIN|VOUT|VOUTDN PH0|PH3|V3|VIN|VOUT|VOUTDP VBN|VSS
+ sg13_lv_nmos L=0.13u W=0.3u AS=0.156p AD=0.156p PS=2.08u PD=2.08u
M$502 VBN|VSS PH0|PH3|V3|VIN|VOUT|VOUTDP PH0|PH1|V0|VIN|VOUT|VOUTDN VBN|VSS
+ sg13_lv_nmos L=0.13u W=0.3u AS=0.156p AD=0.156p PS=2.08u PD=2.08u
M$504 VBN|VSS PH0|PH1|PH4|V4|VIN|VOUT|VOUTDP PH0|PH1|V1|VIN|VOUT|VOUTDN VBN|VSS
+ sg13_lv_nmos L=0.13u W=0.3u AS=0.156p AD=0.156p PS=2.08u PD=2.08u
M$506 VBN|VSS PH0|PH1|V1|VIN|VOUT|VOUTDN PH0|PH1|PH4|V4|VIN|VOUT|VOUTDP VBN|VSS
+ sg13_lv_nmos L=0.13u W=0.3u AS=0.156p AD=0.156p PS=2.08u PD=2.08u
M$508 VBN|VSS PH1|PH2|V2|VIN|VOUT|VOUTDN PH0|PH1|PH5|V5|VIN|VOUT|VOUTDP VBN|VSS
+ sg13_lv_nmos L=0.13u W=0.3u AS=0.156p AD=0.156p PS=2.08u PD=2.08u
M$510 VBN|VSS PH0|PH1|PH5|V5|VIN|VOUT|VOUTDP PH1|PH2|V2|VIN|VOUT|VOUTDN VBN|VSS
+ sg13_lv_nmos L=0.13u W=0.3u AS=0.156p AD=0.156p PS=2.08u PD=2.08u
M$512 VBN|VSS SQ[0]|VIN|VOUT|VS|VSN|VSP|VS[0] VOUT|VSN|VSP$26 VBN|VSS
+ sg13_lv_nmos L=0.13u W=0.15u AS=0.1005p AD=0.1005p PS=1.34u PD=1.34u
M$513 VIN|VOUT$71 VOUT|VSN|VSP$26 VIN|VOUT$72 VBN|VSS sg13_lv_nmos L=0.13u
+ W=0.3u AS=0.201p AD=0.201p PS=2.68u PD=2.68u
M$515 VBN|VSS \$2853 \$2853 VBN|VSS sg13_lv_nmos L=0.13u W=0.15u AS=0.1005p
+ AD=0.1005p PS=1.34u PD=1.34u
M$516 VIN|VOUT$71 VOUT|VSN|VSP$24 VIN|VOUT$72 VBN|VSS sg13_lv_nmos L=0.13u
+ W=0.15u AS=0.1005p AD=0.1005p PS=1.34u PD=1.34u
M$517 VIN|VOUT$72 VOUT|VSN|VSP$25 VIN|VINA|VOUT$2 VBN|VSS sg13_lv_nmos L=0.13u
+ W=0.15u AS=0.1005p AD=0.1005p PS=1.34u PD=1.34u
M$518 VBN|VSS VIN|VOUT$73 PH180|VIN|VINB|VINIB|VOUT VBN|VSS sg13_lv_nmos
+ L=0.13u W=9.6u AS=4.992p AD=4.992p PS=66.56u PD=66.56u
M$534 VBN|VSS PH0|VIN|VINA|VINI|VOUT VIN|VOUT$71 VBN|VSS sg13_lv_nmos L=0.13u
+ W=0.3u AS=0.156p AD=0.156p PS=2.08u PD=2.08u
M$536 VIN|VOUT$75 SQ[1]|VIN|VOUT|VS|VSN|VSP|VS[1] VIN|VOUT$74 VBN|VSS
+ sg13_lv_nmos L=0.13u W=0.15u AS=0.1005p AD=0.1005p PS=1.34u PD=1.34u
M$537 VIN|VOUT$75 VOUT|VSN|VSP$27 VIN|VOUT$74 VBN|VSS sg13_lv_nmos L=0.13u
+ W=0.3u AS=0.201p AD=0.201p PS=2.68u PD=2.68u
M$538 VBN|VSS \$2914 VOUT|VSN|VSP$27 VBN|VSS sg13_lv_nmos L=0.13u W=0.15u
+ AS=0.1005p AD=0.1005p PS=1.34u PD=1.34u
M$540 VIN|VOUT$74 VOUT|VSN|VSP$29 VIN|VINB|VOUT$3 VBN|VSS sg13_lv_nmos L=0.13u
+ W=0.15u AS=0.1005p AD=0.1005p PS=1.34u PD=1.34u
M$557 VBN|VSS SQ[1]|VIN|VOUT|VS|VSN|VSP|VS[1] VOUT|VSN|VSP$28 VBN|VSS
+ sg13_lv_nmos L=0.13u W=0.15u AS=0.1005p AD=0.1005p PS=1.34u PD=1.34u
M$558 VBN|VSS PH270|VIN|VINB|VIND|VINQB|VOUT VIN|VOUT$75 VBN|VSS sg13_lv_nmos
+ L=0.13u W=0.3u AS=0.156p AD=0.156p PS=2.08u PD=2.08u
M$560 VIN|VOUT$77 VOUT|VSN|VSP$28 VIN|VOUT$78 VBN|VSS sg13_lv_nmos L=0.13u
+ W=0.3u AS=0.201p AD=0.201p PS=2.68u PD=2.68u
M$562 VBN|VSS \$2933 \$2933 VBN|VSS sg13_lv_nmos L=0.13u W=0.15u AS=0.1005p
+ AD=0.1005p PS=1.34u PD=1.34u
M$563 VIN|VOUT$77 VOUT|VSN|VSP$27 VIN|VOUT$78 VBN|VSS sg13_lv_nmos L=0.13u
+ W=0.15u AS=0.1005p AD=0.1005p PS=1.34u PD=1.34u
M$564 VIN|VOUT$78 VOUT|VSN|VSP$29 VIN|VINB|VOUT$3 VBN|VSS sg13_lv_nmos L=0.13u
+ W=0.15u AS=0.1005p AD=0.1005p PS=1.34u PD=1.34u
M$565 VIN|VOUT$79 STQ[4]|VIN|VOUT|VS|VSN|VSP|VST|VST[4] VIN|VOUT$80 VBN|VSS
+ sg13_lv_nmos L=0.13u W=0.15u AS=0.1005p AD=0.1005p PS=1.34u PD=1.34u
M$566 VIN|VOUT$79 VOUT|VSN|VSP$30 VIN|VOUT$80 VBN|VSS sg13_lv_nmos L=0.13u
+ W=0.3u AS=0.201p AD=0.201p PS=2.68u PD=2.68u
M$567 VBN|VSS \$2994 VOUT|VSN|VSP$30 VBN|VSS sg13_lv_nmos L=0.13u W=0.15u
+ AS=0.1005p AD=0.1005p PS=1.34u PD=1.34u
M$569 VIN|VOUT$80 VOUT|VSN|VSP$32 VIN|VOUT$4 VBN|VSS sg13_lv_nmos L=0.13u
+ W=0.15u AS=0.1005p AD=0.1005p PS=1.34u PD=1.34u
M$570 VBN|VSS PH0|PH3|V3|VIN|VOUT|VOUTDP VIN|VOUT$81 VBN|VSS sg13_lv_nmos
+ L=0.13u W=0.6u AS=0.312p AD=0.312p PS=4.16u PD=4.16u
M$574 VBN|VSS VIN|VOUT$81 PH1|VIN|VOUT VBN|VSS sg13_lv_nmos L=0.13u W=0.6u
+ AS=0.312p AD=0.312p PS=4.16u PD=4.16u
M$578 VBN|VSS PH1|VIN|VOUT VIN|VOUT$82 VBN|VSS sg13_lv_nmos L=0.13u W=0.6u
+ AS=0.312p AD=0.312p PS=4.16u PD=4.16u
M$582 VBN|VSS VIN|VOUT$82 VIN|VOUT$76 VBN|VSS sg13_lv_nmos L=0.13u W=1.2u
+ AS=0.624p AD=0.624p PS=8.32u PD=8.32u
M$590 VBN|VSS VIN|VOUT$83 VIN|VOUT$84 VBN|VSS sg13_lv_nmos L=0.13u W=4.8u
+ AS=2.496p AD=2.496p PS=33.28u PD=33.28u
M$606 VBN|VSS VIN|VOUT$84 VIN|VOUT$73 VBN|VSS sg13_lv_nmos L=0.13u W=4.8u
+ AS=2.496p AD=2.496p PS=33.28u PD=33.28u
M$638 VBN|VSS PH90|VIN|VINA|VINC|VINQ|VOUT VIN|VOUT$77 VBN|VSS sg13_lv_nmos
+ L=0.13u W=0.3u AS=0.156p AD=0.156p PS=2.08u PD=2.08u
M$640 VIN|VOUT$85 SQ[0]|VIN|VOUT|VS|VSN|VSP|VS[0] VIN|VOUT$86 VBN|VSS
+ sg13_lv_nmos L=0.13u W=0.15u AS=0.1005p AD=0.1005p PS=1.34u PD=1.34u
M$641 VIN|VOUT$85 VOUT|VSN|VSP$33 VIN|VOUT$86 VBN|VSS sg13_lv_nmos L=0.13u
+ W=0.3u AS=0.201p AD=0.201p PS=2.68u PD=2.68u
M$642 VBN|VSS \$3072 VOUT|VSN|VSP$33 VBN|VSS sg13_lv_nmos L=0.13u W=0.15u
+ AS=0.1005p AD=0.1005p PS=1.34u PD=1.34u
M$644 VIN|VOUT$86 VOUT|VSN|VSP$35 VIN|VINA|VOUT$3 VBN|VSS sg13_lv_nmos L=0.13u
+ W=0.15u AS=0.1005p AD=0.1005p PS=1.34u PD=1.34u
M$645 VBN|VSS STQ[4]|VIN|VOUT|VS|VSN|VSP|VST|VST[4] VOUT|VSN|VSP$31 VBN|VSS
+ sg13_lv_nmos L=0.13u W=0.15u AS=0.1005p AD=0.1005p PS=1.34u PD=1.34u
M$646 VBN|VSS VIN|VINB|VOUT$3 VIN|VOUT$79 VBN|VSS sg13_lv_nmos L=0.13u W=0.3u
+ AS=0.156p AD=0.156p PS=2.08u PD=2.08u
M$648 VIN|VOUT$87 VOUT|VSN|VSP$31 VIN|VOUT$88 VBN|VSS sg13_lv_nmos L=0.13u
+ W=0.3u AS=0.201p AD=0.201p PS=2.68u PD=2.68u
M$650 VBN|VSS \$3054 \$3054 VBN|VSS sg13_lv_nmos L=0.13u W=0.15u AS=0.1005p
+ AD=0.1005p PS=1.34u PD=1.34u
M$651 VIN|VOUT$87 VOUT|VSN|VSP$30 VIN|VOUT$88 VBN|VSS sg13_lv_nmos L=0.13u
+ W=0.15u AS=0.1005p AD=0.1005p PS=1.34u PD=1.34u
M$652 VIN|VOUT$88 VOUT|VSN|VSP$32 VIN|VOUT$4 VBN|VSS sg13_lv_nmos L=0.13u
+ W=0.15u AS=0.1005p AD=0.1005p PS=1.34u PD=1.34u
M$653 VBN|VSS VIN|VOUT$76 VIN|VOUT$83 VBN|VSS sg13_lv_nmos L=0.13u W=2.4u
+ AS=1.248p AD=1.248p PS=16.64u PD=16.64u
M$717 VBN|VSS SQ[0]|VIN|VOUT|VS|VSN|VSP|VS[0] VOUT|VSN|VSP$34 VBN|VSS
+ sg13_lv_nmos L=0.13u W=0.15u AS=0.1005p AD=0.1005p PS=1.34u PD=1.34u
M$718 VBN|VSS PH180|VIN|VINB|VINIB|VOUT VIN|VOUT$85 VBN|VSS sg13_lv_nmos
+ L=0.13u W=0.3u AS=0.156p AD=0.156p PS=2.08u PD=2.08u
M$720 VIN|VOUT$106 VOUT|VSN|VSP$34 VIN|VOUT$89 VBN|VSS sg13_lv_nmos L=0.13u
+ W=0.3u AS=0.201p AD=0.201p PS=2.68u PD=2.68u
M$722 VBN|VSS \$3160 \$3160 VBN|VSS sg13_lv_nmos L=0.13u W=0.15u AS=0.1005p
+ AD=0.1005p PS=1.34u PD=1.34u
M$723 VIN|VOUT$106 VOUT|VSN|VSP$33 VIN|VOUT$89 VBN|VSS sg13_lv_nmos L=0.13u
+ W=0.15u AS=0.1005p AD=0.1005p PS=1.34u PD=1.34u
M$724 VIN|VOUT$89 VOUT|VSN|VSP$35 VIN|VINA|VOUT$3 VBN|VSS sg13_lv_nmos L=0.13u
+ W=0.15u AS=0.1005p AD=0.1005p PS=1.34u PD=1.34u
M$725 VBN|VSS VIN|VINA|VOUT$3 VIN|VOUT$87 VBN|VSS sg13_lv_nmos L=0.13u W=0.3u
+ AS=0.156p AD=0.156p PS=2.08u PD=2.08u
M$727 VBN|VSS VIN|VOUT$91 PH0|VIN|VINA|VINI|VOUT VBN|VSS sg13_lv_nmos L=0.13u
+ W=9.6u AS=4.992p AD=4.992p PS=66.56u PD=66.56u
M$743 VBN|VSS PH0|VIN|VINA|VINI|VOUT VIN|VOUT$106 VBN|VSS sg13_lv_nmos L=0.13u
+ W=0.3u AS=0.156p AD=0.156p PS=2.08u PD=2.08u
M$745 VBN|VSS VIN|VOUT$4 VIN|VOUT$90 VBN|VSS sg13_lv_nmos L=0.13u W=0.3u
+ AS=0.156p AD=0.156p PS=2.08u PD=2.08u
M$747 VBN|VSS VIN|VOUT$90 VIN|VOUT$92 VBN|VSS sg13_lv_nmos L=0.13u W=0.6u
+ AS=0.312p AD=0.312p PS=4.16u PD=4.16u
M$751 VBN|VSS VIN|VOUT$92 VIN|VOUT$118 VBN|VSS sg13_lv_nmos L=0.13u W=1.2u
+ AS=0.624p AD=0.624p PS=8.32u PD=8.32u
M$759 VBN|VSS VIN|VOUT$93 CLK|CLKIN|VIN|VINPI|VOUT|VSN|VSP VBN|VSS sg13_lv_nmos
+ L=0.13u W=4.8u AS=2.496p AD=2.496p PS=33.28u PD=33.28u
M$775 VBN|VSS D|VIN|VOUT VIN|VOUT$94 VBN|VSS sg13_lv_nmos L=0.13u W=0.15u
+ AS=0.1005p AD=0.1005p PS=1.34u PD=1.34u
M$776 VIN|VOUT$95 VOUT|VSN|VSP$36 VIN|VOUT$94 VBN|VSS sg13_lv_nmos L=0.13u
+ W=0.15u AS=0.1005p AD=0.1005p PS=1.34u PD=1.34u
M$777 VBN|VSS VIN|VOUT$107 VIN|VOUT$96 VBN|VSS sg13_lv_nmos L=0.13u W=0.15u
+ AS=0.1005p AD=0.1005p PS=1.34u PD=1.34u
M$778 VIN|VOUT$97 CLK|CLKIN|VIN|VINPI|VOUT|VSN|VSP VIN|VOUT$96 VBN|VSS
+ sg13_lv_nmos L=0.13u W=0.15u AS=0.1005p AD=0.1005p PS=1.34u PD=1.34u
M$779 VBN|VSS CLK|CLKIN|CLKOUT|Q|VIN|VOUT|VSN|VSP D|VIN|VOUT VBN|VSS
+ sg13_lv_nmos L=0.13u W=0.15u AS=0.1005p AD=0.1005p PS=1.34u PD=1.34u
M$780 VBN|VSS D|VIN|VOUT$1 VIN|VOUT$98 VBN|VSS sg13_lv_nmos L=0.13u W=0.15u
+ AS=0.1005p AD=0.1005p PS=1.34u PD=1.34u
M$781 VIN|VOUT$99 VOUT|VSN|VSP$37 VIN|VOUT$98 VBN|VSS sg13_lv_nmos L=0.13u
+ W=0.15u AS=0.1005p AD=0.1005p PS=1.34u PD=1.34u
M$782 VBN|VSS VIN|VOUT$108 VIN|VOUT$100 VBN|VSS sg13_lv_nmos L=0.13u W=0.15u
+ AS=0.1005p AD=0.1005p PS=1.34u PD=1.34u
M$783 VIN|VOUT$101 CLK|CLKIN|CLKOUT|Q|VIN|VOUT|VSN|VSP VIN|VOUT$100 VBN|VSS
+ sg13_lv_nmos L=0.13u W=0.15u AS=0.1005p AD=0.1005p PS=1.34u PD=1.34u
M$784 VBN|VSS CLK|CLKIN|CLKOUT|Q|VIN|VOUT|VSN|VSP$1 D|VIN|VOUT$1 VBN|VSS
+ sg13_lv_nmos L=0.13u W=0.15u AS=0.1005p AD=0.1005p PS=1.34u PD=1.34u
M$785 VBN|VSS D|VIN|VOUT$2 VIN|VOUT$102 VBN|VSS sg13_lv_nmos L=0.13u W=0.15u
+ AS=0.1005p AD=0.1005p PS=1.34u PD=1.34u
M$786 VIN|VOUT$103 VOUT|VSN|VSP$38 VIN|VOUT$102 VBN|VSS sg13_lv_nmos L=0.13u
+ W=0.15u AS=0.1005p AD=0.1005p PS=1.34u PD=1.34u
M$787 VBN|VSS VIN|VOUT$109 VIN|VOUT$104 VBN|VSS sg13_lv_nmos L=0.13u W=0.15u
+ AS=0.1005p AD=0.1005p PS=1.34u PD=1.34u
M$788 VIN|VOUT$105 CLK|CLKIN|CLKOUT|Q|VIN|VOUT|VSN|VSP$1 VIN|VOUT$104 VBN|VSS
+ sg13_lv_nmos L=0.13u W=0.15u AS=0.1005p AD=0.1005p PS=1.34u PD=1.34u
M$789 VBN|VSS CLKOUT|Q|VIN|VOUT D|VIN|VOUT$2 VBN|VSS sg13_lv_nmos L=0.13u
+ W=0.15u AS=0.1005p AD=0.1005p PS=1.34u PD=1.34u
M$790 VIN|VOUT$117 SQ[1]|VIN|VOUT|VS|VSN|VSP|VS[1] VIN|VOUT$110 VBN|VSS
+ sg13_lv_nmos L=0.13u W=0.15u AS=0.1005p AD=0.1005p PS=1.34u PD=1.34u
M$791 VIN|VOUT$117 VOUT|VSN|VSP$39 VIN|VOUT$110 VBN|VSS sg13_lv_nmos L=0.13u
+ W=0.3u AS=0.201p AD=0.201p PS=2.68u PD=2.68u
M$792 VBN|VSS \$3573 VOUT|VSN|VSP$39 VBN|VSS sg13_lv_nmos L=0.13u W=0.15u
+ AS=0.1005p AD=0.1005p PS=1.34u PD=1.34u
M$794 VIN|VOUT$110 VOUT|VSN|VSP$40 VIN|VINB|VOUT$4 VBN|VSS sg13_lv_nmos L=0.13u
+ W=0.15u AS=0.1005p AD=0.1005p PS=1.34u PD=1.34u
M$795 VBN|VSS CLK|CLKIN|VIN|VINPI|VOUT|VSN|VSP VOUT|VSN|VSP$36 VBN|VSS
+ sg13_lv_nmos L=0.13u W=0.15u AS=0.1005p AD=0.1005p PS=1.34u PD=1.34u
M$796 VBN|VSS VIN|VOUT$107 VIN|VOUT$111 VBN|VSS sg13_lv_nmos L=0.13u W=0.15u
+ AS=0.1005p AD=0.1005p PS=1.34u PD=1.34u
M$797 VIN|VOUT$95 CLK|CLKIN|VIN|VINPI|VOUT|VSN|VSP VIN|VOUT$111 VBN|VSS
+ sg13_lv_nmos L=0.13u W=0.15u AS=0.1005p AD=0.1005p PS=1.34u PD=1.34u
M$798 VBN|VSS VIN|VOUT$95 VIN|VOUT$107 VBN|VSS sg13_lv_nmos L=0.13u W=0.15u
+ AS=0.1005p AD=0.1005p PS=1.34u PD=1.34u
M$799 VBN|VSS CLK|CLKIN|CLKOUT|Q|VIN|VOUT|VSN|VSP VIN|VOUT$112 VBN|VSS
+ sg13_lv_nmos L=0.13u W=0.15u AS=0.1005p AD=0.1005p PS=1.34u PD=1.34u
M$800 VIN|VOUT$97 VOUT|VSN|VSP$36 VIN|VOUT$112 VBN|VSS sg13_lv_nmos L=0.13u
+ W=0.15u AS=0.1005p AD=0.1005p PS=1.34u PD=1.34u
M$801 VBN|VSS VIN|VOUT$97 CLK|CLKIN|CLKOUT|Q|VIN|VOUT|VSN|VSP VBN|VSS
+ sg13_lv_nmos L=0.13u W=0.15u AS=0.1005p AD=0.1005p PS=1.34u PD=1.34u
M$802 VBN|VSS CLK|CLKIN|CLKOUT|Q|VIN|VOUT|VSN|VSP VOUT|VSN|VSP$37 VBN|VSS
+ sg13_lv_nmos L=0.13u W=0.15u AS=0.1005p AD=0.1005p PS=1.34u PD=1.34u
M$803 VBN|VSS VIN|VOUT$108 VIN|VOUT$113 VBN|VSS sg13_lv_nmos L=0.13u W=0.15u
+ AS=0.1005p AD=0.1005p PS=1.34u PD=1.34u
M$804 VIN|VOUT$99 CLK|CLKIN|CLKOUT|Q|VIN|VOUT|VSN|VSP VIN|VOUT$113 VBN|VSS
+ sg13_lv_nmos L=0.13u W=0.15u AS=0.1005p AD=0.1005p PS=1.34u PD=1.34u
M$805 VBN|VSS VIN|VOUT$99 VIN|VOUT$108 VBN|VSS sg13_lv_nmos L=0.13u W=0.15u
+ AS=0.1005p AD=0.1005p PS=1.34u PD=1.34u
M$806 VBN|VSS CLK|CLKIN|CLKOUT|Q|VIN|VOUT|VSN|VSP$1 VIN|VOUT$114 VBN|VSS
+ sg13_lv_nmos L=0.13u W=0.15u AS=0.1005p AD=0.1005p PS=1.34u PD=1.34u
M$807 VIN|VOUT$101 VOUT|VSN|VSP$37 VIN|VOUT$114 VBN|VSS sg13_lv_nmos L=0.13u
+ W=0.15u AS=0.1005p AD=0.1005p PS=1.34u PD=1.34u
M$808 VBN|VSS VIN|VOUT$101 CLK|CLKIN|CLKOUT|Q|VIN|VOUT|VSN|VSP$1 VBN|VSS
+ sg13_lv_nmos L=0.13u W=0.15u AS=0.1005p AD=0.1005p PS=1.34u PD=1.34u
M$809 VBN|VSS CLK|CLKIN|CLKOUT|Q|VIN|VOUT|VSN|VSP$1 VOUT|VSN|VSP$38 VBN|VSS
+ sg13_lv_nmos L=0.13u W=0.15u AS=0.1005p AD=0.1005p PS=1.34u PD=1.34u
M$810 VBN|VSS VIN|VOUT$109 VIN|VOUT$115 VBN|VSS sg13_lv_nmos L=0.13u W=0.15u
+ AS=0.1005p AD=0.1005p PS=1.34u PD=1.34u
M$811 VIN|VOUT$103 CLK|CLKIN|CLKOUT|Q|VIN|VOUT|VSN|VSP$1 VIN|VOUT$115 VBN|VSS
+ sg13_lv_nmos L=0.13u W=0.15u AS=0.1005p AD=0.1005p PS=1.34u PD=1.34u
M$812 VBN|VSS VIN|VOUT$103 VIN|VOUT$109 VBN|VSS sg13_lv_nmos L=0.13u W=0.15u
+ AS=0.1005p AD=0.1005p PS=1.34u PD=1.34u
M$813 VBN|VSS CLKOUT|Q|VIN|VOUT VIN|VOUT$116 VBN|VSS sg13_lv_nmos L=0.13u
+ W=0.15u AS=0.1005p AD=0.1005p PS=1.34u PD=1.34u
M$814 VIN|VOUT$105 VOUT|VSN|VSP$38 VIN|VOUT$116 VBN|VSS sg13_lv_nmos L=0.13u
+ W=0.15u AS=0.1005p AD=0.1005p PS=1.34u PD=1.34u
M$815 VBN|VSS VIN|VOUT$105 CLKOUT|Q|VIN|VOUT VBN|VSS sg13_lv_nmos L=0.13u
+ W=0.15u AS=0.1005p AD=0.1005p PS=1.34u PD=1.34u
M$816 VBN|VSS PH0|VIN|VOUT PH1|VIN|VOUT VBN|VSS sg13_lv_nmos L=0.13u W=0.6u
+ AS=0.312p AD=0.312p PS=4.16u PD=4.16u
M$820 VBN|VSS PH1|VIN|VOUT PH0|VIN|VOUT VBN|VSS sg13_lv_nmos L=0.13u W=0.3u
+ AS=0.156p AD=0.156p PS=2.08u PD=2.08u
M$838 VBN|VSS SQ[1]|VIN|VOUT|VS|VSN|VSP|VS[1] VOUT|VSN|VSP$41 VBN|VSS
+ sg13_lv_nmos L=0.13u W=0.15u AS=0.1005p AD=0.1005p PS=1.34u PD=1.34u
M$839 VBN|VSS PH270|VIN|VINB|VIND|VINQB|VOUT VIN|VOUT$117 VBN|VSS sg13_lv_nmos
+ L=0.13u W=0.3u AS=0.156p AD=0.156p PS=2.08u PD=2.08u
M$841 VIN|VOUT$121 VOUT|VSN|VSP$41 VIN|VOUT$122 VBN|VSS sg13_lv_nmos L=0.13u
+ W=0.3u AS=0.201p AD=0.201p PS=2.68u PD=2.68u
M$843 VBN|VSS \$3755 \$3755 VBN|VSS sg13_lv_nmos L=0.13u W=0.15u AS=0.1005p
+ AD=0.1005p PS=1.34u PD=1.34u
M$844 VIN|VOUT$121 VOUT|VSN|VSP$39 VIN|VOUT$122 VBN|VSS sg13_lv_nmos L=0.13u
+ W=0.15u AS=0.1005p AD=0.1005p PS=1.34u PD=1.34u
M$845 VIN|VOUT$122 VOUT|VSN|VSP$40 VIN|VINB|VOUT$4 VBN|VSS sg13_lv_nmos L=0.13u
+ W=0.15u AS=0.1005p AD=0.1005p PS=1.34u PD=1.34u
M$846 VIN|VOUT$123 STQ[3]|VIN|VOUT|VS|VSN|VSP|VST|VST[3] VIN|VOUT$124 VBN|VSS
+ sg13_lv_nmos L=0.13u W=0.15u AS=0.1005p AD=0.1005p PS=1.34u PD=1.34u
M$847 VIN|VOUT$123 VOUT|VSN|VSP$42 VIN|VOUT$124 VBN|VSS sg13_lv_nmos L=0.13u
+ W=0.3u AS=0.201p AD=0.201p PS=2.68u PD=2.68u
M$848 VBN|VSS \$3833 VOUT|VSN|VSP$42 VBN|VSS sg13_lv_nmos L=0.13u W=0.15u
+ AS=0.1005p AD=0.1005p PS=1.34u PD=1.34u
M$850 VIN|VOUT$124 VOUT|VSN|VSP$43 VIN|VOUT$4 VBN|VSS sg13_lv_nmos L=0.13u
+ W=0.15u AS=0.1005p AD=0.1005p PS=1.34u PD=1.34u
M$851 VBN|VSS VIN|VOUT$118 VIN|VOUT$93 VBN|VSS sg13_lv_nmos L=0.13u W=2.4u
+ AS=1.248p AD=1.248p PS=16.64u PD=16.64u
M$883 VBN|VSS CLKOUT|Q|VIN|VOUT VIN|VOUT$119 VBN|VSS sg13_lv_nmos L=0.13u
+ W=0.6u AS=0.312p AD=0.312p PS=4.16u PD=4.16u
M$887 VBN|VSS VIN|VOUT$119 VIN|VOUT$129 VBN|VSS sg13_lv_nmos L=0.13u W=1.2u
+ AS=0.624p AD=0.624p PS=8.32u PD=8.32u
M$895 VBN|VSS VIN|VOUT$120 VOUT VBN|VSS sg13_lv_nmos L=0.13u W=4.8u AS=2.496p
+ AD=2.496p PS=33.28u PD=33.28u
M$911 VBN|VSS PH0|PH1|V0|VIN|VOUT|VOUTDN VIN|VOUT$125 VBN|VSS sg13_lv_nmos
+ L=0.13u W=0.6u AS=0.312p AD=0.312p PS=4.16u PD=4.16u
M$915 VBN|VSS VIN|VOUT$125 PH0|VIN|VOUT VBN|VSS sg13_lv_nmos L=0.13u W=0.6u
+ AS=0.312p AD=0.312p PS=4.16u PD=4.16u
M$919 VBN|VSS PH0|VIN|VOUT VIN|VOUT$126 VBN|VSS sg13_lv_nmos L=0.13u W=0.6u
+ AS=0.312p AD=0.312p PS=4.16u PD=4.16u
M$923 VBN|VSS VIN|VOUT$126 VIN|VOUT$134 VBN|VSS sg13_lv_nmos L=0.13u W=1.2u
+ AS=0.624p AD=0.624p PS=8.32u PD=8.32u
M$931 VBN|VSS VIN|VOUT$127 VIN|VOUT$128 VBN|VSS sg13_lv_nmos L=0.13u W=4.8u
+ AS=2.496p AD=2.496p PS=33.28u PD=33.28u
M$947 VBN|VSS VIN|VOUT$128 VIN|VOUT$91 VBN|VSS sg13_lv_nmos L=0.13u W=4.8u
+ AS=2.496p AD=2.496p PS=33.28u PD=33.28u
M$979 VBN|VSS PH90|VIN|VINA|VINC|VINQ|VOUT VIN|VOUT$121 VBN|VSS sg13_lv_nmos
+ L=0.13u W=0.3u AS=0.156p AD=0.156p PS=2.08u PD=2.08u
M$981 VIN|VOUT$132 SQ[0]|VIN|VOUT|VS|VSN|VSP|VS[0] VIN|VOUT$130 VBN|VSS
+ sg13_lv_nmos L=0.13u W=0.15u AS=0.1005p AD=0.1005p PS=1.34u PD=1.34u
M$982 VIN|VOUT$132 VOUT|VSN|VSP$45 VIN|VOUT$130 VBN|VSS sg13_lv_nmos L=0.13u
+ W=0.3u AS=0.201p AD=0.201p PS=2.68u PD=2.68u
M$983 VBN|VSS \$3964 VOUT|VSN|VSP$45 VBN|VSS sg13_lv_nmos L=0.13u W=0.15u
+ AS=0.1005p AD=0.1005p PS=1.34u PD=1.34u
M$985 VIN|VOUT$130 VOUT|VSN|VSP$47 VIN|VINA|VOUT$4 VBN|VSS sg13_lv_nmos L=0.13u
+ W=0.15u AS=0.1005p AD=0.1005p PS=1.34u PD=1.34u
M$986 VBN|VSS STQ[3]|VIN|VOUT|VS|VSN|VSP|VST|VST[3] VOUT|VSN|VSP$44 VBN|VSS
+ sg13_lv_nmos L=0.13u W=0.15u AS=0.1005p AD=0.1005p PS=1.34u PD=1.34u
M$987 VBN|VSS VIN|VINB|VOUT$4 VIN|VOUT$123 VBN|VSS sg13_lv_nmos L=0.13u W=0.3u
+ AS=0.156p AD=0.156p PS=2.08u PD=2.08u
M$989 VIN|VOUT$133 VOUT|VSN|VSP$44 VIN|VOUT$131 VBN|VSS sg13_lv_nmos L=0.13u
+ W=0.3u AS=0.201p AD=0.201p PS=2.68u PD=2.68u
M$991 VBN|VSS \$3907 \$3907 VBN|VSS sg13_lv_nmos L=0.13u W=0.15u AS=0.1005p
+ AD=0.1005p PS=1.34u PD=1.34u
M$992 VIN|VOUT$133 VOUT|VSN|VSP$42 VIN|VOUT$131 VBN|VSS sg13_lv_nmos L=0.13u
+ W=0.15u AS=0.1005p AD=0.1005p PS=1.34u PD=1.34u
M$993 VIN|VOUT$131 VOUT|VSN|VSP$43 VIN|VOUT$4 VBN|VSS sg13_lv_nmos L=0.13u
+ W=0.15u AS=0.1005p AD=0.1005p PS=1.34u PD=1.34u
M$994 VBN|VSS VIN|VOUT$129 VIN|VOUT$120 VBN|VSS sg13_lv_nmos L=0.13u W=2.4u
+ AS=1.248p AD=1.248p PS=16.64u PD=16.64u
M$1026 VBN|VSS VIN|VOUT$134 VIN|VOUT$127 VBN|VSS sg13_lv_nmos L=0.13u W=2.4u
+ AS=1.248p AD=1.248p PS=16.64u PD=16.64u
M$1028 VBN|VSS PH0|PH1|PH5|V5|VIN|VOUT|VOUTDP VIN|VOUT$135 VBN|VSS sg13_lv_nmos
+ L=0.13u W=0.6u AS=0.312p AD=0.312p PS=4.16u PD=4.16u
M$1080 VBN|VSS VIN|VOUT$138 PH270|VIN|VINB|VIND|VINQB|VOUT VBN|VSS sg13_lv_nmos
+ L=0.13u W=9.6u AS=4.992p AD=4.992p PS=66.56u PD=66.56u
M$1110 VBN|VSS SQ[0]|VIN|VOUT|VS|VSN|VSP|VS[0] VOUT|VSN|VSP$46 VBN|VSS
+ sg13_lv_nmos L=0.13u W=0.15u AS=0.1005p AD=0.1005p PS=1.34u PD=1.34u
M$1111 VBN|VSS PH0|VIN|VINA|VINI|VOUT VIN|VOUT$136 VBN|VSS sg13_lv_nmos L=0.13u
+ W=0.3u AS=0.156p AD=0.156p PS=2.08u PD=2.08u
M$1113 VBN|VSS PH180|VIN|VINB|VINIB|VOUT VIN|VOUT$132 VBN|VSS sg13_lv_nmos
+ L=0.13u W=0.3u AS=0.156p AD=0.156p PS=2.08u PD=2.08u
M$1115 VIN|VOUT$136 VOUT|VSN|VSP$46 VIN|VOUT$137 VBN|VSS sg13_lv_nmos L=0.13u
+ W=0.3u AS=0.201p AD=0.201p PS=2.68u PD=2.68u
M$1117 VBN|VSS \$4018 \$4018 VBN|VSS sg13_lv_nmos L=0.13u W=0.15u AS=0.1005p
+ AD=0.1005p PS=1.34u PD=1.34u
M$1118 VIN|VOUT$136 VOUT|VSN|VSP$45 VIN|VOUT$137 VBN|VSS sg13_lv_nmos L=0.13u
+ W=0.15u AS=0.1005p AD=0.1005p PS=1.34u PD=1.34u
M$1119 VIN|VOUT$137 VOUT|VSN|VSP$47 VIN|VINA|VOUT$4 VBN|VSS sg13_lv_nmos
+ L=0.13u W=0.15u AS=0.1005p AD=0.1005p PS=1.34u PD=1.34u
M$1120 VBN|VSS VIN|VINA|VOUT$4 VIN|VOUT$133 VBN|VSS sg13_lv_nmos L=0.13u W=0.3u
+ AS=0.156p AD=0.156p PS=2.08u PD=2.08u
M$1122 VBN|VSS VIN|VOUT$135 PH1|PHOUT|VIN|VOUT VBN|VSS sg13_lv_nmos L=0.13u
+ W=0.6u AS=0.312p AD=0.312p PS=4.16u PD=4.16u
M$1142 VBN|VSS PH270|VIN|VINB|VIND|VINQB|VOUT VIN|VOUT$140 VBN|VSS sg13_lv_nmos
+ L=0.13u W=0.3u AS=0.156p AD=0.156p PS=2.08u PD=2.08u
M$1144 VIN|VOUT$140 SQ[1]|VIN|VOUT|VS|VSN|VSP|VS[1] VIN|VOUT$141 VBN|VSS
+ sg13_lv_nmos L=0.13u W=0.15u AS=0.1005p AD=0.1005p PS=1.34u PD=1.34u
M$1145 VIN|VOUT$140 VOUT|VSN|VSP$48 VIN|VOUT$141 VBN|VSS sg13_lv_nmos L=0.13u
+ W=0.3u AS=0.201p AD=0.201p PS=2.68u PD=2.68u
M$1146 VBN|VSS \$4086 VOUT|VSN|VSP$48 VBN|VSS sg13_lv_nmos L=0.13u W=0.15u
+ AS=0.1005p AD=0.1005p PS=1.34u PD=1.34u
M$1148 VIN|VOUT$141 VOUT|VSN|VSP$50 VIN|VINB|VOUT$5 VBN|VSS sg13_lv_nmos
+ L=0.13u W=0.15u AS=0.1005p AD=0.1005p PS=1.34u PD=1.34u
M$1149 SQ[1]|VIN|VOUT|VS|VSN|VSP|VS[1] VIN|VOUT$139 VBN|VSS VBN|VSS
+ sg13_lv_nmos L=0.13u W=0.15u AS=0.1005p AD=0.1005p PS=1.34u PD=1.34u
M$1150 VIN|VOUT$139 A|S[4]|VIN|VOUT|VS[4] VBN|VSS VBN|VSS sg13_lv_nmos L=0.13u
+ W=0.15u AS=0.1005p AD=0.1005p PS=1.34u PD=1.34u
M$1151 VBN|VSS SQ[1]|VIN|VOUT|VS|VSN|VSP|VS[1] VOUT|VSN|VSP$49 VBN|VSS
+ sg13_lv_nmos L=0.13u W=0.15u AS=0.1005p AD=0.1005p PS=1.34u PD=1.34u
M$1152 VIN|VOUT$144 VOUT|VSN|VSP$49 VIN|VOUT$142 VBN|VSS sg13_lv_nmos L=0.13u
+ W=0.3u AS=0.201p AD=0.201p PS=2.68u PD=2.68u
M$1154 VBN|VSS \$4140 \$4140 VBN|VSS sg13_lv_nmos L=0.13u W=0.15u AS=0.1005p
+ AD=0.1005p PS=1.34u PD=1.34u
M$1155 VIN|VOUT$144 VOUT|VSN|VSP$48 VIN|VOUT$142 VBN|VSS sg13_lv_nmos L=0.13u
+ W=0.15u AS=0.1005p AD=0.1005p PS=1.34u PD=1.34u
M$1156 VIN|VOUT$142 VOUT|VSN|VSP$50 VIN|VINB|VOUT$5 VBN|VSS sg13_lv_nmos
+ L=0.13u W=0.15u AS=0.1005p AD=0.1005p PS=1.34u PD=1.34u
M$1157 VIN|VOUT$145 STQ[2]|VIN|VOUT|VS|VSN|VSP|VST|VST[2] VIN|VOUT$143 VBN|VSS
+ sg13_lv_nmos L=0.13u W=0.15u AS=0.1005p AD=0.1005p PS=1.34u PD=1.34u
M$1158 VIN|VOUT$145 VOUT|VSN|VSP$51 VIN|VOUT$143 VBN|VSS sg13_lv_nmos L=0.13u
+ W=0.3u AS=0.201p AD=0.201p PS=2.68u PD=2.68u
M$1159 VBN|VSS \$4165 VOUT|VSN|VSP$51 VBN|VSS sg13_lv_nmos L=0.13u W=0.15u
+ AS=0.1005p AD=0.1005p PS=1.34u PD=1.34u
M$1161 VIN|VOUT$143 VOUT|VSN|VSP$53 VIN|VOUT$4 VBN|VSS sg13_lv_nmos L=0.13u
+ W=0.15u AS=0.1005p AD=0.1005p PS=1.34u PD=1.34u
M$1162 VOUT|VSN|VSS B|S[3]|VDD|VIN|VSP|VS[3] VBN|VSS VBN|VSS sg13_lv_nmos
+ L=0.13u W=0.15u AS=0.1005p AD=0.1005p PS=1.34u PD=1.34u
M$1163 A|S[4]|VIN|VOUT|VS[4] VOUT|VSN|VSS SQ[0]|VIN|VOUT|VS|VSN|VSP|VS[0]
+ VBN|VSS sg13_lv_nmos L=0.13u W=0.15u AS=0.1005p AD=0.1005p PS=1.34u PD=1.34u
M$1164 SQ[0]|VIN|VOUT|VS|VSN|VSP|VS[0] A|S[4]|VIN|VOUT|VS[4] VOUT|VSN|VSS
+ VBN|VSS sg13_lv_nmos L=0.13u W=0.15u AS=0.1005p AD=0.1005p PS=1.34u PD=1.34u
M$1165 VBN|VSS PH0|PH1|PH4|V4|VIN|VOUT|VOUTDP VIN|VOUT$135 VBN|VSS sg13_lv_nmos
+ L=0.13u W=0.6u AS=0.312p AD=0.312p PS=4.16u PD=4.16u
M$1169 VBN|VSS PH1|PHOUT|VIN|VOUT VIN|VOUT$146 VBN|VSS sg13_lv_nmos L=0.13u
+ W=0.6u AS=0.312p AD=0.312p PS=4.16u PD=4.16u
M$1173 VBN|VSS VIN|VOUT$146 VIN|VOUT$152 VBN|VSS sg13_lv_nmos L=0.13u W=1.2u
+ AS=0.624p AD=0.624p PS=8.32u PD=8.32u
M$1181 VBN|VSS VIN|VOUT$147 VIN|VOUT$148 VBN|VSS sg13_lv_nmos L=0.13u W=4.8u
+ AS=2.496p AD=2.496p PS=33.28u PD=33.28u
M$1197 VBN|VSS VIN|VOUT$148 VIN|VOUT$138 VBN|VSS sg13_lv_nmos L=0.13u W=4.8u
+ AS=2.496p AD=2.496p PS=33.28u PD=33.28u
M$1229 VBN|VSS PH90|VIN|VINA|VINC|VINQ|VOUT VIN|VOUT$144 VBN|VSS sg13_lv_nmos
+ L=0.13u W=0.3u AS=0.156p AD=0.156p PS=2.08u PD=2.08u
M$1231 VIN|VOUT$153 SQ[0]|VIN|VOUT|VS|VSN|VSP|VS[0] VIN|VOUT$149 VBN|VSS
+ sg13_lv_nmos L=0.13u W=0.15u AS=0.1005p AD=0.1005p PS=1.34u PD=1.34u
M$1232 VIN|VOUT$153 VOUT|VSN|VSP$54 VIN|VOUT$149 VBN|VSS sg13_lv_nmos L=0.13u
+ W=0.3u AS=0.201p AD=0.201p PS=2.68u PD=2.68u
M$1233 VBN|VSS \$4343 VOUT|VSN|VSP$54 VBN|VSS sg13_lv_nmos L=0.13u W=0.15u
+ AS=0.1005p AD=0.1005p PS=1.34u PD=1.34u
M$1235 VIN|VOUT$149 VOUT|VSN|VSP$56 VIN|VINA|VOUT$5 VBN|VSS sg13_lv_nmos
+ L=0.13u W=0.15u AS=0.1005p AD=0.1005p PS=1.34u PD=1.34u
M$1236 VBN|VSS STQ[2]|VIN|VOUT|VS|VSN|VSP|VST|VST[2] VOUT|VSN|VSP$52 VBN|VSS
+ sg13_lv_nmos L=0.13u W=0.15u AS=0.1005p AD=0.1005p PS=1.34u PD=1.34u
M$1237 VBN|VSS VIN|VINB|VOUT$5 VIN|VOUT$145 VBN|VSS sg13_lv_nmos L=0.13u W=0.3u
+ AS=0.156p AD=0.156p PS=2.08u PD=2.08u
M$1239 VIN|VOUT$154 VOUT|VSN|VSP$52 VIN|VOUT$150 VBN|VSS sg13_lv_nmos L=0.13u
+ W=0.3u AS=0.201p AD=0.201p PS=2.68u PD=2.68u
M$1241 VBN|VSS \$4275 \$4275 VBN|VSS sg13_lv_nmos L=0.13u W=0.15u AS=0.1005p
+ AD=0.1005p PS=1.34u PD=1.34u
M$1242 VIN|VOUT$154 VOUT|VSN|VSP$51 VIN|VOUT$150 VBN|VSS sg13_lv_nmos L=0.13u
+ W=0.15u AS=0.1005p AD=0.1005p PS=1.34u PD=1.34u
M$1243 VIN|VOUT$150 VOUT|VSN|VSP$53 VIN|VOUT$4 VBN|VSS sg13_lv_nmos L=0.13u
+ W=0.15u AS=0.1005p AD=0.1005p PS=1.34u PD=1.34u
M$1244 SQ[2]|VIN|VOUT|VS|VSN|VSP|VST|VST[0] VIN|VOUT$151 VBN|VSS VBN|VSS
+ sg13_lv_nmos L=0.13u W=0.15u AS=0.1005p AD=0.1005p PS=1.34u PD=1.34u
M$1245 VIN|VOUT$151 B|S[3]|VDD|VIN|VSP|VS[3] VBN|VSS VBN|VSS sg13_lv_nmos
+ L=0.13u W=0.15u AS=0.1005p AD=0.1005p PS=1.34u PD=1.34u
M$1246 VBN|VSS VIN|VOUT$152 VIN|VOUT$147 VBN|VSS sg13_lv_nmos L=0.13u W=2.4u
+ AS=1.248p AD=1.248p PS=16.64u PD=16.64u
M$1310 VBN|VSS SQ[0]|VIN|VOUT|VS|VSN|VSP|VS[0] VOUT|VSN|VSP$55 VBN|VSS
+ sg13_lv_nmos L=0.13u W=0.15u AS=0.1005p AD=0.1005p PS=1.34u PD=1.34u
M$1311 VBN|VSS PH0|VIN|VINA|VINI|VOUT VIN|VOUT$159 VBN|VSS sg13_lv_nmos L=0.13u
+ W=0.3u AS=0.156p AD=0.156p PS=2.08u PD=2.08u
M$1313 VBN|VSS PH180|VIN|VINB|VINIB|VOUT VIN|VOUT$153 VBN|VSS sg13_lv_nmos
+ L=0.13u W=0.3u AS=0.156p AD=0.156p PS=2.08u PD=2.08u
M$1315 VIN|VOUT$159 VOUT|VSN|VSP$55 VIN|VOUT$155 VBN|VSS sg13_lv_nmos L=0.13u
+ W=0.3u AS=0.201p AD=0.201p PS=2.68u PD=2.68u
M$1317 VBN|VSS \$4399 \$4399 VBN|VSS sg13_lv_nmos L=0.13u W=0.15u AS=0.1005p
+ AD=0.1005p PS=1.34u PD=1.34u
M$1318 VIN|VOUT$159 VOUT|VSN|VSP$54 VIN|VOUT$155 VBN|VSS sg13_lv_nmos L=0.13u
+ W=0.15u AS=0.1005p AD=0.1005p PS=1.34u PD=1.34u
M$1319 VIN|VOUT$155 VOUT|VSN|VSP$56 VIN|VINA|VOUT$5 VBN|VSS sg13_lv_nmos
+ L=0.13u W=0.15u AS=0.1005p AD=0.1005p PS=1.34u PD=1.34u
M$1320 VBN|VSS VIN|VINA|VOUT$5 VIN|VOUT$154 VBN|VSS sg13_lv_nmos L=0.13u W=0.3u
+ AS=0.156p AD=0.156p PS=2.08u PD=2.08u
M$1322 VOUT|VSN|VSS$1 B|OUT|ST[7]|VDD|VIN|VSP VBN|VSS VBN|VSS sg13_lv_nmos
+ L=0.13u W=0.15u AS=0.1005p AD=0.1005p PS=1.34u PD=1.34u
M$1323 A|VIN|VOUT VOUT|VSN|VSS$1 STQ[7]|VIN|VOUT|VS|VSN|VSP|VST|VST[7] VBN|VSS
+ sg13_lv_nmos L=0.13u W=0.15u AS=0.1005p AD=0.1005p PS=1.34u PD=1.34u
M$1324 STQ[7]|VIN|VOUT|VS|VSN|VSP|VST|VST[7] A|VIN|VOUT VOUT|VSN|VSS$1 VBN|VSS
+ sg13_lv_nmos L=0.13u W=0.15u AS=0.1005p AD=0.1005p PS=1.34u PD=1.34u
M$1325 A|VIN|VOUT VIN|VOUT$156 VBN|VSS VBN|VSS sg13_lv_nmos L=0.13u W=0.15u
+ AS=0.1005p AD=0.1005p PS=1.34u PD=1.34u
M$1326 VIN|VOUT$156 VIN|VOUT$157 VBN|VSS VBN|VSS sg13_lv_nmos L=0.13u W=0.15u
+ AS=0.1005p AD=0.1005p PS=1.34u PD=1.34u
M$1327 VBN|VSS PH1|PH2|V2|VIN|VOUT|VOUTDN VIN|VOUT$158 VBN|VSS sg13_lv_nmos
+ L=0.13u W=0.6u AS=0.312p AD=0.312p PS=4.16u PD=4.16u
M$1331 VBN|VSS VIN|VOUT$160 PH90|VIN|VINA|VINC|VINQ|VOUT VBN|VSS sg13_lv_nmos
+ L=0.13u W=9.6u AS=4.992p AD=4.992p PS=66.56u PD=66.56u
M$1347 VOUT|VSN|VSS$2 B|OUT|ST[6]|VDD|VIN|VSP VBN|VSS VBN|VSS sg13_lv_nmos
+ L=0.13u W=0.15u AS=0.1005p AD=0.1005p PS=1.34u PD=1.34u
M$1348 A|VIN|VOUT$1 VOUT|VSN|VSS$2 STQ[6]|VIN|VOUT|VS|VSN|VSP|VST|VST[6]
+ VBN|VSS sg13_lv_nmos L=0.13u W=0.15u AS=0.1005p AD=0.1005p PS=1.34u PD=1.34u
M$1349 STQ[6]|VIN|VOUT|VS|VSN|VSP|VST|VST[6] A|VIN|VOUT$1 VOUT|VSN|VSS$2
+ VBN|VSS sg13_lv_nmos L=0.13u W=0.15u AS=0.1005p AD=0.1005p PS=1.34u PD=1.34u
M$1350 A|VIN|VOUT$1 VIN|VOUT$161 VBN|VSS VBN|VSS sg13_lv_nmos L=0.13u W=0.15u
+ AS=0.1005p AD=0.1005p PS=1.34u PD=1.34u
M$1351 VIN|VOUT$161 VIN|VOUT$157 VBN|VSS VBN|VSS sg13_lv_nmos L=0.13u W=0.15u
+ AS=0.1005p AD=0.1005p PS=1.34u PD=1.34u
M$1352 VBN|VSS PH0|PHOUT|VIN|VOUT PH1|PHOUT|VIN|VOUT VBN|VSS sg13_lv_nmos
+ L=0.13u W=0.6u AS=0.312p AD=0.312p PS=4.16u PD=4.16u
M$1356 VBN|VSS PH1|PHOUT|VIN|VOUT PH0|PHOUT|VIN|VOUT VBN|VSS sg13_lv_nmos
+ L=0.13u W=0.3u AS=0.156p AD=0.156p PS=2.08u PD=2.08u
M$1358 VIN|VOUT$163 SQ[1]|VIN|VOUT|VS|VSN|VSP|VS[1] VIN|VOUT$162 VBN|VSS
+ sg13_lv_nmos L=0.13u W=0.15u AS=0.1005p AD=0.1005p PS=1.34u PD=1.34u
M$1359 VIN|VOUT$163 VOUT|VSN|VSP$57 VIN|VOUT$162 VBN|VSS sg13_lv_nmos L=0.13u
+ W=0.3u AS=0.201p AD=0.201p PS=2.68u PD=2.68u
M$1360 VBN|VSS \$4594 VOUT|VSN|VSP$57 VBN|VSS sg13_lv_nmos L=0.13u W=0.15u
+ AS=0.1005p AD=0.1005p PS=1.34u PD=1.34u
M$1362 VIN|VOUT$162 VOUT|VSN|VSP$58 VIN|VINB|VOUT$6 VBN|VSS sg13_lv_nmos
+ L=0.13u W=0.15u AS=0.1005p AD=0.1005p PS=1.34u PD=1.34u
M$1363 VBN|VSS VIN|VOUT$158 PH0|PHOUT|VIN|VOUT VBN|VSS sg13_lv_nmos L=0.13u
+ W=0.6u AS=0.312p AD=0.312p PS=4.16u PD=4.16u
M$1383 VBN|VSS PH270|VIN|VINB|VIND|VINQB|VOUT VIN|VOUT$163 VBN|VSS sg13_lv_nmos
+ L=0.13u W=0.3u AS=0.156p AD=0.156p PS=2.08u PD=2.08u
M$1385 VBN|VSS VIN|VOUT$164 VIN|VOUT$157 VBN|VSS sg13_lv_nmos L=0.13u W=1.2u
+ AS=0.624p AD=0.624p PS=8.32u PD=8.32u
M$1393 VBN|VSS VIN|VOUT$165 VIN|VOUT$164 VBN|VSS sg13_lv_nmos L=0.13u W=0.6u
+ AS=0.312p AD=0.312p PS=4.16u PD=4.16u
M$1397 VBN|VSS VIN|VOUT$166 VIN|VOUT$165 VBN|VSS sg13_lv_nmos L=0.13u W=0.3u
+ AS=0.156p AD=0.156p PS=2.08u PD=2.08u
M$1399 VIN|VOUT$166 B|S[3]|VDD|VIN|VSP|VS[3] VBN|VSS VBN|VSS sg13_lv_nmos
+ L=0.13u W=0.15u AS=0.1005p AD=0.1005p PS=1.34u PD=1.34u
M$1400 VOUT|VSN|VSS$3 B|OUT|ST[5]|VDD|VIN|VSP VBN|VSS VBN|VSS sg13_lv_nmos
+ L=0.13u W=0.15u AS=0.1005p AD=0.1005p PS=1.34u PD=1.34u
M$1401 A|VIN|VOUT$2 VOUT|VSN|VSS$3 STQ[5]|VIN|VOUT|VS|VSN|VSP|VST|VST[5]
+ VBN|VSS sg13_lv_nmos L=0.13u W=0.15u AS=0.1005p AD=0.1005p PS=1.34u PD=1.34u
M$1402 STQ[5]|VIN|VOUT|VS|VSN|VSP|VST|VST[5] A|VIN|VOUT$2 VOUT|VSN|VSS$3
+ VBN|VSS sg13_lv_nmos L=0.13u W=0.15u AS=0.1005p AD=0.1005p PS=1.34u PD=1.34u
M$1403 A|VIN|VOUT$2 VIN|VOUT$167 VBN|VSS VBN|VSS sg13_lv_nmos L=0.13u W=0.15u
+ AS=0.1005p AD=0.1005p PS=1.34u PD=1.34u
M$1404 VIN|VOUT$167 VIN|VOUT$157 VBN|VSS VBN|VSS sg13_lv_nmos L=0.13u W=0.15u
+ AS=0.1005p AD=0.1005p PS=1.34u PD=1.34u
M$1405 VBN|VSS SQ[1]|VIN|VOUT|VS|VSN|VSP|VS[1] VOUT|VSN|VSP$59 VBN|VSS
+ sg13_lv_nmos L=0.13u W=0.15u AS=0.1005p AD=0.1005p PS=1.34u PD=1.34u
M$1406 VIN|VOUT$168 VOUT|VSN|VSP$59 VIN|VOUT$169 VBN|VSS sg13_lv_nmos L=0.13u
+ W=0.3u AS=0.201p AD=0.201p PS=2.68u PD=2.68u
M$1408 VBN|VSS \$4856 \$4856 VBN|VSS sg13_lv_nmos L=0.13u W=0.15u AS=0.1005p
+ AD=0.1005p PS=1.34u PD=1.34u
M$1409 VIN|VOUT$168 VOUT|VSN|VSP$57 VIN|VOUT$169 VBN|VSS sg13_lv_nmos L=0.13u
+ W=0.15u AS=0.1005p AD=0.1005p PS=1.34u PD=1.34u
M$1410 VIN|VOUT$169 VOUT|VSN|VSP$58 VIN|VINB|VOUT$6 VBN|VSS sg13_lv_nmos
+ L=0.13u W=0.15u AS=0.1005p AD=0.1005p PS=1.34u PD=1.34u
M$1411 VIN|VOUT$170 STQ[1]|VIN|VOUT|VS|VSN|VSP|VST|VST[1] VIN|VOUT$171 VBN|VSS
+ sg13_lv_nmos L=0.13u W=0.15u AS=0.1005p AD=0.1005p PS=1.34u PD=1.34u
M$1412 VIN|VOUT$170 VOUT|VSN|VSP$60 VIN|VOUT$171 VBN|VSS sg13_lv_nmos L=0.13u
+ W=0.3u AS=0.201p AD=0.201p PS=2.68u PD=2.68u
M$1413 VBN|VSS \$4880 VOUT|VSN|VSP$60 VBN|VSS sg13_lv_nmos L=0.13u W=0.15u
+ AS=0.1005p AD=0.1005p PS=1.34u PD=1.34u
M$1415 VIN|VOUT$171 VOUT|VSN|VSP$62 VIN|VOUT$4 VBN|VSS sg13_lv_nmos L=0.13u
+ W=0.15u AS=0.1005p AD=0.1005p PS=1.34u PD=1.34u
M$1416 VBN|VSS PH0|PH1|V1|VIN|VOUT|VOUTDN VIN|VOUT$158 VBN|VSS sg13_lv_nmos
+ L=0.13u W=0.6u AS=0.312p AD=0.312p PS=4.16u PD=4.16u
M$1420 VBN|VSS PH0|PHOUT|VIN|VOUT VIN|VOUT$172 VBN|VSS sg13_lv_nmos L=0.13u
+ W=0.6u AS=0.312p AD=0.312p PS=4.16u PD=4.16u
M$1424 VBN|VSS VIN|VOUT$172 VIN|VOUT$180 VBN|VSS sg13_lv_nmos L=0.13u W=1.2u
+ AS=0.624p AD=0.624p PS=8.32u PD=8.32u
M$1432 VBN|VSS VIN|VOUT$173 VIN|VOUT$174 VBN|VSS sg13_lv_nmos L=0.13u W=4.8u
+ AS=2.496p AD=2.496p PS=33.28u PD=33.28u
M$1448 VBN|VSS VIN|VOUT$174 VIN|VOUT$160 VBN|VSS sg13_lv_nmos L=0.13u W=4.8u
+ AS=2.496p AD=2.496p PS=33.28u PD=33.28u
M$1480 VBN|VSS PH90|VIN|VINA|VINC|VINQ|VOUT VIN|VOUT$168 VBN|VSS sg13_lv_nmos
+ L=0.13u W=0.3u AS=0.156p AD=0.156p PS=2.08u PD=2.08u
M$1482 VIN|VOUT$178 SQ[0]|VIN|VOUT|VS|VSN|VSP|VS[0] VIN|VOUT$176 VBN|VSS
+ sg13_lv_nmos L=0.13u W=0.15u AS=0.1005p AD=0.1005p PS=1.34u PD=1.34u
M$1483 VIN|VOUT$178 VOUT|VSN|VSP$63 VIN|VOUT$176 VBN|VSS sg13_lv_nmos L=0.13u
+ W=0.3u AS=0.201p AD=0.201p PS=2.68u PD=2.68u
M$1484 VBN|VSS \$5091 VOUT|VSN|VSP$63 VBN|VSS sg13_lv_nmos L=0.13u W=0.15u
+ AS=0.1005p AD=0.1005p PS=1.34u PD=1.34u
M$1486 VIN|VOUT$176 VOUT|VSN|VSP$64 VIN|VINA|VOUT$6 VBN|VSS sg13_lv_nmos
+ L=0.13u W=0.15u AS=0.1005p AD=0.1005p PS=1.34u PD=1.34u
M$1487 VBN|VSS STQ[1]|VIN|VOUT|VS|VSN|VSP|VST|VST[1] VOUT|VSN|VSP$61 VBN|VSS
+ sg13_lv_nmos L=0.13u W=0.15u AS=0.1005p AD=0.1005p PS=1.34u PD=1.34u
M$1488 VBN|VSS VIN|VINB|VOUT$6 VIN|VOUT$170 VBN|VSS sg13_lv_nmos L=0.13u W=0.3u
+ AS=0.156p AD=0.156p PS=2.08u PD=2.08u
M$1490 VIN|VOUT$179 VOUT|VSN|VSP$61 VIN|VOUT$177 VBN|VSS sg13_lv_nmos L=0.13u
+ W=0.3u AS=0.201p AD=0.201p PS=2.68u PD=2.68u
M$1492 VBN|VSS \$5014 \$5014 VBN|VSS sg13_lv_nmos L=0.13u W=0.15u AS=0.1005p
+ AD=0.1005p PS=1.34u PD=1.34u
M$1493 VIN|VOUT$179 VOUT|VSN|VSP$60 VIN|VOUT$177 VBN|VSS sg13_lv_nmos L=0.13u
+ W=0.15u AS=0.1005p AD=0.1005p PS=1.34u PD=1.34u
M$1494 VIN|VOUT$177 VOUT|VSN|VSP$62 VIN|VOUT$4 VBN|VSS sg13_lv_nmos L=0.13u
+ W=0.15u AS=0.1005p AD=0.1005p PS=1.34u PD=1.34u
M$1495 VOUT|VSN|VSS$4 B|ST[4]|VDD|VIN|VOUT|VSP VBN|VSS VBN|VSS sg13_lv_nmos
+ L=0.13u W=0.15u AS=0.1005p AD=0.1005p PS=1.34u PD=1.34u
M$1496 A|VIN|VOUT$3 VOUT|VSN|VSS$4 STQ[4]|VIN|VOUT|VS|VSN|VSP|VST|VST[4]
+ VBN|VSS sg13_lv_nmos L=0.13u W=0.15u AS=0.1005p AD=0.1005p PS=1.34u PD=1.34u
M$1497 STQ[4]|VIN|VOUT|VS|VSN|VSP|VST|VST[4] A|VIN|VOUT$3 VOUT|VSN|VSS$4
+ VBN|VSS sg13_lv_nmos L=0.13u W=0.15u AS=0.1005p AD=0.1005p PS=1.34u PD=1.34u
M$1498 A|VIN|VOUT$3 VIN|VOUT$175 VBN|VSS VBN|VSS sg13_lv_nmos L=0.13u W=0.15u
+ AS=0.1005p AD=0.1005p PS=1.34u PD=1.34u
M$1499 VIN|VOUT$175 VIN|VOUT$157 VBN|VSS VBN|VSS sg13_lv_nmos L=0.13u W=0.15u
+ AS=0.1005p AD=0.1005p PS=1.34u PD=1.34u
M$1500 VBN|VSS VIN|VOUT$180 VIN|VOUT$173 VBN|VSS sg13_lv_nmos L=0.13u W=2.4u
+ AS=1.248p AD=1.248p PS=16.64u PD=16.64u
M$1564 VBN|VSS SQ[0]|VIN|VOUT|VS|VSN|VSP|VS[0] VOUT|VSN|VSP$65 VBN|VSS
+ sg13_lv_nmos L=0.13u W=0.15u AS=0.1005p AD=0.1005p PS=1.34u PD=1.34u
M$1565 VBN|VSS PH180|VIN|VINB|VINIB|VOUT VIN|VOUT$178 VBN|VSS sg13_lv_nmos
+ L=0.13u W=0.3u AS=0.156p AD=0.156p PS=2.08u PD=2.08u
M$1567 VBN|VSS PH0|VIN|VINA|VINI|VOUT VIN|VOUT$183 VBN|VSS sg13_lv_nmos L=0.13u
+ W=0.3u AS=0.156p AD=0.156p PS=2.08u PD=2.08u
M$1569 VIN|VOUT$183 VOUT|VSN|VSP$65 VIN|VOUT$182 VBN|VSS sg13_lv_nmos L=0.13u
+ W=0.3u AS=0.201p AD=0.201p PS=2.68u PD=2.68u
M$1571 VBN|VSS \$5167 \$5167 VBN|VSS sg13_lv_nmos L=0.13u W=0.15u AS=0.1005p
+ AD=0.1005p PS=1.34u PD=1.34u
M$1572 VIN|VOUT$183 VOUT|VSN|VSP$63 VIN|VOUT$182 VBN|VSS sg13_lv_nmos L=0.13u
+ W=0.15u AS=0.1005p AD=0.1005p PS=1.34u PD=1.34u
M$1573 VIN|VOUT$182 VOUT|VSN|VSP$64 VIN|VINA|VOUT$6 VBN|VSS sg13_lv_nmos
+ L=0.13u W=0.15u AS=0.1005p AD=0.1005p PS=1.34u PD=1.34u
M$1574 VBN|VSS VIN|VINA|VOUT$6 VIN|VOUT$179 VBN|VSS sg13_lv_nmos L=0.13u W=0.3u
+ AS=0.156p AD=0.156p PS=2.08u PD=2.08u
M$1576 VOUT|VSN|VSS$5 B|OUT|ST[3]|VDD|VIN|VSP VBN|VSS VBN|VSS sg13_lv_nmos
+ L=0.13u W=0.15u AS=0.1005p AD=0.1005p PS=1.34u PD=1.34u
M$1577 A|VIN|VOUT$4 VOUT|VSN|VSS$5 STQ[3]|VIN|VOUT|VS|VSN|VSP|VST|VST[3]
+ VBN|VSS sg13_lv_nmos L=0.13u W=0.15u AS=0.1005p AD=0.1005p PS=1.34u PD=1.34u
M$1578 STQ[3]|VIN|VOUT|VS|VSN|VSP|VST|VST[3] A|VIN|VOUT$4 VOUT|VSN|VSS$5
+ VBN|VSS sg13_lv_nmos L=0.13u W=0.15u AS=0.1005p AD=0.1005p PS=1.34u PD=1.34u
M$1579 A|VIN|VOUT$4 VIN|VOUT$181 VBN|VSS VBN|VSS sg13_lv_nmos L=0.13u W=0.15u
+ AS=0.1005p AD=0.1005p PS=1.34u PD=1.34u
M$1580 VIN|VOUT$181 VIN|VOUT$157 VBN|VSS VBN|VSS sg13_lv_nmos L=0.13u W=0.15u
+ AS=0.1005p AD=0.1005p PS=1.34u PD=1.34u
M$1581 VIN|VOUT$185 SQ[1]|VIN|VOUT|VS|VSN|VSP|VS[1] VIN|VOUT$186 VBN|VSS
+ sg13_lv_nmos L=0.13u W=0.15u AS=0.1005p AD=0.1005p PS=1.34u PD=1.34u
M$1582 VIN|VOUT$185 VOUT|VSN|VSP$66 VIN|VOUT$186 VBN|VSS sg13_lv_nmos L=0.13u
+ W=0.3u AS=0.201p AD=0.201p PS=2.68u PD=2.68u
M$1583 VBN|VSS \$5344 VOUT|VSN|VSP$66 VBN|VSS sg13_lv_nmos L=0.13u W=0.15u
+ AS=0.1005p AD=0.1005p PS=1.34u PD=1.34u
M$1585 VIN|VOUT$186 VOUT|VSN|VSP$68 VIN|VINB|VOUT$7 VBN|VSS sg13_lv_nmos
+ L=0.13u W=0.15u AS=0.1005p AD=0.1005p PS=1.34u PD=1.34u
M$1586 VOUT|VSN|VSS$6 B|OUT|ST[2]|VDD|VIN|VSP VBN|VSS VBN|VSS sg13_lv_nmos
+ L=0.13u W=0.15u AS=0.1005p AD=0.1005p PS=1.34u PD=1.34u
M$1587 A|VIN|VOUT$5 VOUT|VSN|VSS$6 STQ[2]|VIN|VOUT|VS|VSN|VSP|VST|VST[2]
+ VBN|VSS sg13_lv_nmos L=0.13u W=0.15u AS=0.1005p AD=0.1005p PS=1.34u PD=1.34u
M$1588 STQ[2]|VIN|VOUT|VS|VSN|VSP|VST|VST[2] A|VIN|VOUT$5 VOUT|VSN|VSS$6
+ VBN|VSS sg13_lv_nmos L=0.13u W=0.15u AS=0.1005p AD=0.1005p PS=1.34u PD=1.34u
M$1589 A|VIN|VOUT$5 VIN|VOUT$184 VBN|VSS VBN|VSS sg13_lv_nmos L=0.13u W=0.15u
+ AS=0.1005p AD=0.1005p PS=1.34u PD=1.34u
M$1590 VIN|VOUT$184 VIN|VOUT$157 VBN|VSS VBN|VSS sg13_lv_nmos L=0.13u W=0.15u
+ AS=0.1005p AD=0.1005p PS=1.34u PD=1.34u
M$1591 VBN|VSS A|B|VOUT B|OUT|ST[1]|VDD|VIN|VSP VBN|VSS sg13_lv_nmos L=0.13u
+ W=0.15u AS=0.1005p AD=0.0555p PS=1.34u PD=0.74u
M$1592 B|OUT|ST[1]|VDD|VIN|VSP A|B|VOUT$1 VBN|VSS VBN|VSS sg13_lv_nmos L=0.13u
+ W=0.15u AS=0.0555p AD=0.0555p PS=0.74u PD=0.74u
M$1593 VBN|VSS B|C|VIN|VOUT B|OUT|ST[1]|VDD|VIN|VSP VBN|VSS sg13_lv_nmos
+ L=0.13u W=0.15u AS=0.0555p AD=0.1005p PS=0.74u PD=1.34u
M$1594 VBN|VSS B|C|VIN|VOUT B|OUT|ST[2]|VDD|VIN|VSP VBN|VSS sg13_lv_nmos
+ L=0.13u W=0.15u AS=0.1005p AD=0.0555p PS=1.34u PD=0.74u
M$1595 B|OUT|ST[2]|VDD|VIN|VSP A|B|VOUT$1 VBN|VSS VBN|VSS sg13_lv_nmos L=0.13u
+ W=0.15u AS=0.0555p AD=0.1005p PS=0.74u PD=1.34u
M$1596 VBN|VSS B|C|VIN|VOUT B|OUT|ST[3]|VDD|VIN|VSP VBN|VSS sg13_lv_nmos
+ L=0.13u W=0.15u AS=0.1005p AD=0.0555p PS=1.34u PD=0.74u
M$1597 B|OUT|ST[3]|VDD|VIN|VSP A|OUT|VOUT VBN|VSS VBN|VSS sg13_lv_nmos L=0.13u
+ W=0.15u AS=0.0555p AD=0.1005p PS=0.74u PD=1.34u
M$1598 B|ST[4]|VDD|VIN|VOUT|VSP B|C|VIN|VOUT VBN|VSS VBN|VSS sg13_lv_nmos
+ L=0.13u W=0.15u AS=0.1005p AD=0.1005p PS=1.34u PD=1.34u
M$1599 VBN|VSS B|C|VIN|VOUT \$5217 VBN|VSS sg13_lv_nmos L=0.13u W=0.15u
+ AS=0.1005p AD=0.0555p PS=1.34u PD=0.74u
M$1600 \$5217 A|OUT|VOUT$1 B|OUT|ST[5]|VDD|VIN|VSP VBN|VSS sg13_lv_nmos L=0.13u
+ W=0.15u AS=0.0555p AD=0.1005p PS=0.74u PD=1.34u
M$1601 B|OUT|ST[6]|VDD|VIN|VSP A|B|VOUT$1 \$5218 VBN|VSS sg13_lv_nmos L=0.13u
+ W=0.15u AS=0.1005p AD=0.0555p PS=1.34u PD=0.74u
M$1602 \$5218 B|C|VIN|VOUT VBN|VSS VBN|VSS sg13_lv_nmos L=0.13u W=0.15u
+ AS=0.0555p AD=0.1005p PS=0.74u PD=1.34u
M$1603 VBN|VSS B|C|VIN|VOUT \$5219 VBN|VSS sg13_lv_nmos L=0.13u W=0.15u
+ AS=0.1005p AD=0.0555p PS=1.34u PD=0.74u
M$1604 \$5219 A|B|VOUT$1 \$5220 VBN|VSS sg13_lv_nmos L=0.13u W=0.15u AS=0.0555p
+ AD=0.0555p PS=0.74u PD=0.74u
M$1605 \$5220 A|B|VOUT B|OUT|ST[7]|VDD|VIN|VSP VBN|VSS sg13_lv_nmos L=0.13u
+ W=0.15u AS=0.0555p AD=0.1005p PS=0.74u PD=1.34u
M$1606 VBN|VSS PH270|VIN|VINB|VIND|VINQB|VOUT VIN|VOUT$185 VBN|VSS sg13_lv_nmos
+ L=0.13u W=0.3u AS=0.156p AD=0.156p PS=2.08u PD=2.08u
M$1608 VOUT|VSN|VSS$7 B|OUT|ST[1]|VDD|VIN|VSP VBN|VSS VBN|VSS sg13_lv_nmos
+ L=0.13u W=0.15u AS=0.1005p AD=0.1005p PS=1.34u PD=1.34u
M$1609 A|VIN|VOUT$6 VOUT|VSN|VSS$7 STQ[1]|VIN|VOUT|VS|VSN|VSP|VST|VST[1]
+ VBN|VSS sg13_lv_nmos L=0.13u W=0.15u AS=0.1005p AD=0.1005p PS=1.34u PD=1.34u
M$1610 STQ[1]|VIN|VOUT|VS|VSN|VSP|VST|VST[1] A|VIN|VOUT$6 VOUT|VSN|VSS$7
+ VBN|VSS sg13_lv_nmos L=0.13u W=0.15u AS=0.1005p AD=0.1005p PS=1.34u PD=1.34u
M$1611 A|VIN|VOUT$6 VIN|VOUT$187 VBN|VSS VBN|VSS sg13_lv_nmos L=0.13u W=0.15u
+ AS=0.1005p AD=0.1005p PS=1.34u PD=1.34u
M$1612 VIN|VOUT$187 VIN|VOUT$157 VBN|VSS VBN|VSS sg13_lv_nmos L=0.13u W=0.15u
+ AS=0.1005p AD=0.1005p PS=1.34u PD=1.34u
M$1613 A|OUT|VOUT OUT|VIN VBN|VSS VBN|VSS sg13_lv_nmos L=0.13u W=0.15u
+ AS=0.1005p AD=0.1005p PS=1.34u PD=1.34u
M$1614 VBN|VSS A|B|VOUT \$5471 VBN|VSS sg13_lv_nmos L=0.13u W=0.15u AS=0.1005p
+ AD=0.0555p PS=1.34u PD=0.74u
M$1615 \$5471 A|B|VOUT$1 OUT|VIN VBN|VSS sg13_lv_nmos L=0.13u W=0.15u
+ AS=0.0555p AD=0.1005p PS=0.74u PD=1.34u
M$1616 A|OUT|VOUT$1 OUT|VIN$1 VBN|VSS VBN|VSS sg13_lv_nmos L=0.13u W=0.15u
+ AS=0.1005p AD=0.1005p PS=1.34u PD=1.34u
M$1617 VBN|VSS A|B|VOUT$1 OUT|VIN$1 VBN|VSS sg13_lv_nmos L=0.13u W=0.15u
+ AS=0.1005p AD=0.0555p PS=1.34u PD=0.74u
M$1618 OUT|VIN$1 A|B|VOUT VBN|VSS VBN|VSS sg13_lv_nmos L=0.13u W=0.15u
+ AS=0.0555p AD=0.1005p PS=0.74u PD=1.34u
M$1619 VBN|VSS SQ[1]|VIN|VOUT|VS|VSN|VSP|VS[1] VOUT|VSN|VSP$67 VBN|VSS
+ sg13_lv_nmos L=0.13u W=0.15u AS=0.1005p AD=0.1005p PS=1.34u PD=1.34u
M$1620 VBN|VSS PH90|VIN|VINA|VINC|VINQ|VOUT VIN|VOUT$190 VBN|VSS sg13_lv_nmos
+ L=0.13u W=0.3u AS=0.156p AD=0.156p PS=2.08u PD=2.08u
M$1622 VIN|VOUT$190 VOUT|VSN|VSP$67 VIN|VOUT$189 VBN|VSS sg13_lv_nmos L=0.13u
+ W=0.3u AS=0.201p AD=0.201p PS=2.68u PD=2.68u
M$1624 VBN|VSS \$5534 \$5534 VBN|VSS sg13_lv_nmos L=0.13u W=0.15u AS=0.1005p
+ AD=0.1005p PS=1.34u PD=1.34u
M$1625 VIN|VOUT$190 VOUT|VSN|VSP$66 VIN|VOUT$189 VBN|VSS sg13_lv_nmos L=0.13u
+ W=0.15u AS=0.1005p AD=0.1005p PS=1.34u PD=1.34u
M$1626 VIN|VOUT$189 VOUT|VSN|VSP$68 VIN|VINB|VOUT$7 VBN|VSS sg13_lv_nmos
+ L=0.13u W=0.15u AS=0.1005p AD=0.1005p PS=1.34u PD=1.34u
M$1627 VBN|VSS VIN|VINB|VOUT$7 VIN|VOUT$191 VBN|VSS sg13_lv_nmos L=0.13u W=0.3u
+ AS=0.156p AD=0.156p PS=2.08u PD=2.08u
M$1629 VIN|VOUT$191 SQ[2]|VIN|VOUT|VS|VSN|VSP|VST|VST[0] VIN|VOUT$188 VBN|VSS
+ sg13_lv_nmos L=0.13u W=0.15u AS=0.1005p AD=0.1005p PS=1.34u PD=1.34u
M$1630 VIN|VOUT$191 VOUT|VSN|VSP$69 VIN|VOUT$188 VBN|VSS sg13_lv_nmos L=0.13u
+ W=0.3u AS=0.201p AD=0.201p PS=2.68u PD=2.68u
M$1631 VBN|VSS \$5614 VOUT|VSN|VSP$69 VBN|VSS sg13_lv_nmos L=0.13u W=0.15u
+ AS=0.1005p AD=0.1005p PS=1.34u PD=1.34u
M$1633 VIN|VOUT$188 VOUT|VSN|VSP$71 VIN|VOUT$4 VBN|VSS sg13_lv_nmos L=0.13u
+ W=0.15u AS=0.1005p AD=0.1005p PS=1.34u PD=1.34u
M$1634 VBN|VSS S[2]|VIN|VS[2] B|C|VIN|VOUT VBN|VSS sg13_lv_nmos L=0.13u W=0.15u
+ AS=0.1005p AD=0.1005p PS=1.34u PD=1.34u
M$1635 VBN|VSS S[1]|VIN|VS[1] A|B|VOUT$1 VBN|VSS sg13_lv_nmos L=0.13u W=0.15u
+ AS=0.1005p AD=0.1005p PS=1.34u PD=1.34u
M$1636 VBN|VSS S[0]|VIN|VS[0] A|B|VOUT VBN|VSS sg13_lv_nmos L=0.13u W=0.15u
+ AS=0.1005p AD=0.1005p PS=1.34u PD=1.34u
M$1637 VBN|VSS PH180|VIN|VINB|VINIB|VOUT VIN|VOUT$194 VBN|VSS sg13_lv_nmos
+ L=0.13u W=0.3u AS=0.156p AD=0.156p PS=2.08u PD=2.08u
M$1639 VIN|VOUT$194 SQ[0]|VIN|VOUT|VS|VSN|VSP|VS[0] VIN|VOUT$192 VBN|VSS
+ sg13_lv_nmos L=0.13u W=0.15u AS=0.1005p AD=0.1005p PS=1.34u PD=1.34u
M$1640 VIN|VOUT$194 VOUT|VSN|VSP$72 VIN|VOUT$192 VBN|VSS sg13_lv_nmos L=0.13u
+ W=0.3u AS=0.201p AD=0.201p PS=2.68u PD=2.68u
M$1641 VBN|VSS \$5680 VOUT|VSN|VSP$72 VBN|VSS sg13_lv_nmos L=0.13u W=0.15u
+ AS=0.1005p AD=0.1005p PS=1.34u PD=1.34u
M$1643 VIN|VOUT$192 VOUT|VSN|VSP$74 VIN|VINA|VOUT$7 VBN|VSS sg13_lv_nmos
+ L=0.13u W=0.15u AS=0.1005p AD=0.1005p PS=1.34u PD=1.34u
M$1644 VBN|VSS SQ[2]|VIN|VOUT|VS|VSN|VSP|VST|VST[0] VOUT|VSN|VSP$70 VBN|VSS
+ sg13_lv_nmos L=0.13u W=0.15u AS=0.1005p AD=0.1005p PS=1.34u PD=1.34u
M$1645 VBN|VSS VIN|VINA|VOUT$7 VIN|VOUT$195 VBN|VSS sg13_lv_nmos L=0.13u W=0.3u
+ AS=0.156p AD=0.156p PS=2.08u PD=2.08u
M$1647 VIN|VOUT$195 VOUT|VSN|VSP$70 VIN|VOUT$193 VBN|VSS sg13_lv_nmos L=0.13u
+ W=0.3u AS=0.201p AD=0.201p PS=2.68u PD=2.68u
M$1649 VBN|VSS \$5638 \$5638 VBN|VSS sg13_lv_nmos L=0.13u W=0.15u AS=0.1005p
+ AD=0.1005p PS=1.34u PD=1.34u
M$1650 VIN|VOUT$195 VOUT|VSN|VSP$69 VIN|VOUT$193 VBN|VSS sg13_lv_nmos L=0.13u
+ W=0.15u AS=0.1005p AD=0.1005p PS=1.34u PD=1.34u
M$1651 VIN|VOUT$193 VOUT|VSN|VSP$71 VIN|VOUT$4 VBN|VSS sg13_lv_nmos L=0.13u
+ W=0.15u AS=0.1005p AD=0.1005p PS=1.34u PD=1.34u
M$1652 VBN|VSS SQ[0]|VIN|VOUT|VS|VSN|VSP|VS[0] VOUT|VSN|VSP$73 VBN|VSS
+ sg13_lv_nmos L=0.13u W=0.15u AS=0.1005p AD=0.1005p PS=1.34u PD=1.34u
M$1653 VBN|VSS PH0|VIN|VINA|VINI|VOUT VIN|VOUT$196 VBN|VSS sg13_lv_nmos L=0.13u
+ W=0.3u AS=0.156p AD=0.156p PS=2.08u PD=2.08u
M$1655 VIN|VOUT$196 VOUT|VSN|VSP$73 VIN|VOUT$197 VBN|VSS sg13_lv_nmos L=0.13u
+ W=0.3u AS=0.201p AD=0.201p PS=2.68u PD=2.68u
M$1657 VBN|VSS \$5722 \$5722 VBN|VSS sg13_lv_nmos L=0.13u W=0.15u AS=0.1005p
+ AD=0.1005p PS=1.34u PD=1.34u
M$1658 VIN|VOUT$196 VOUT|VSN|VSP$72 VIN|VOUT$197 VBN|VSS sg13_lv_nmos L=0.13u
+ W=0.15u AS=0.1005p AD=0.1005p PS=1.34u PD=1.34u
M$1659 VIN|VOUT$197 VOUT|VSN|VSP$74 VIN|VINA|VOUT$7 VBN|VSS sg13_lv_nmos
+ L=0.13u W=0.15u AS=0.1005p AD=0.1005p PS=1.34u PD=1.34u
M$1660 VBP|VDD PH270|VIN|VINB|VIND|VINQB|VOUT VIN|VOUT$1 VBP|VDD sg13_lv_pmos
+ L=0.13u W=0.45u AS=0.2115p AD=0.2115p PS=2.82u PD=2.82u
M$1663 VIN|VOUT$1 VOUT|VSN|VSP$1 VIN|VOUT VBP|VDD sg13_lv_pmos L=0.13u W=0.3u
+ AS=0.156p AD=0.156p PS=2.08u PD=2.08u
M$1665 VIN|VOUT$1 VOUT|VSN|VSP$2 VIN|VOUT VBP|VDD sg13_lv_pmos L=0.13u W=0.6u
+ AS=0.312p AD=0.312p PS=4.16u PD=4.16u
M$1667 VBP|VDD \$16 \$16 VBP|VDD sg13_lv_pmos L=0.13u W=0.15u AS=0.1005p
+ AD=0.1005p PS=1.34u PD=1.34u
M$1670 VIN|VOUT VOUT|VSN|VSP VIN|VINB|VOUT VBP|VDD sg13_lv_pmos L=0.13u W=0.3u
+ AS=0.156p AD=0.156p PS=2.08u PD=2.08u
M$1672 VBP|VDD SQ[1]|VIN|VOUT|VS|VSN|VSP|VS[1] VOUT|VSN|VSP$1 VBP|VDD
+ sg13_lv_pmos L=0.13u W=0.15u AS=0.1005p AD=0.1005p PS=1.34u PD=1.34u
M$1673 VBP|VDD PH90|VIN|VINA|VINC|VINQ|VOUT VIN|VOUT$5 VBP|VDD sg13_lv_pmos
+ L=0.13u W=0.45u AS=0.2115p AD=0.2115p PS=2.82u PD=2.82u
M$1676 VIN|VOUT$5 SQ[1]|VIN|VOUT|VS|VSN|VSP|VS[1] VIN|VOUT$2 VBP|VDD
+ sg13_lv_pmos L=0.13u W=0.6u AS=0.312p AD=0.312p PS=4.16u PD=4.16u
M$1680 VBP|VDD \$24 VOUT|VSN|VSP$2 VBP|VDD sg13_lv_pmos L=0.13u W=0.15u
+ AS=0.1005p AD=0.1005p PS=1.34u PD=1.34u
M$1681 VIN|VOUT$5 VOUT|VSN|VSP$2 VIN|VOUT$2 VBP|VDD sg13_lv_pmos L=0.13u W=0.3u
+ AS=0.156p AD=0.156p PS=2.08u PD=2.08u
M$1683 VIN|VOUT$2 VOUT|VSN|VSP VIN|VINB|VOUT VBP|VDD sg13_lv_pmos L=0.13u
+ W=0.3u AS=0.156p AD=0.156p PS=2.08u PD=2.08u
M$1685 VBP|VDD VIN|VINB|VOUT VIN|VOUT$6 VBP|VDD sg13_lv_pmos L=0.13u W=0.45u
+ AS=0.2115p AD=0.2115p PS=2.82u PD=2.82u
M$1688 VIN|VOUT$6 VOUT|VSN|VSP$4 VIN|VOUT$3 VBP|VDD sg13_lv_pmos L=0.13u W=0.3u
+ AS=0.156p AD=0.156p PS=2.08u PD=2.08u
M$1690 VIN|VOUT$6 VOUT|VSN|VSP$5 VIN|VOUT$3 VBP|VDD sg13_lv_pmos L=0.13u W=0.6u
+ AS=0.312p AD=0.312p PS=4.16u PD=4.16u
M$1692 VBP|VDD \$49 \$49 VBP|VDD sg13_lv_pmos L=0.13u W=0.15u AS=0.1005p
+ AD=0.1005p PS=1.34u PD=1.34u
M$1695 VIN|VOUT$3 VOUT|VSN|VSP$3 VIN|VOUT$4 VBP|VDD sg13_lv_pmos L=0.13u W=0.3u
+ AS=0.156p AD=0.156p PS=2.08u PD=2.08u
M$1697 VBP|VDD PH180|VIN|VINB|VINIB|VOUT VIN|VOUT$7 VBP|VDD sg13_lv_pmos
+ L=0.13u W=0.45u AS=0.2115p AD=0.2115p PS=2.82u PD=2.82u
M$1700 VIN|VOUT$7 VOUT|VSN|VSP$8 VIN|VOUT$8 VBP|VDD sg13_lv_pmos L=0.13u W=0.3u
+ AS=0.156p AD=0.156p PS=2.08u PD=2.08u
M$1702 VIN|VOUT$7 VOUT|VSN|VSP$7 VIN|VOUT$8 VBP|VDD sg13_lv_pmos L=0.13u W=0.6u
+ AS=0.312p AD=0.312p PS=4.16u PD=4.16u
M$1704 VBP|VDD \$98 \$98 VBP|VDD sg13_lv_pmos L=0.13u W=0.15u AS=0.1005p
+ AD=0.1005p PS=1.34u PD=1.34u
M$1707 VIN|VOUT$8 VOUT|VSN|VSP$6 VIN|VINA|VOUT VBP|VDD sg13_lv_pmos L=0.13u
+ W=0.3u AS=0.156p AD=0.156p PS=2.08u PD=2.08u
M$1709 VBP|VDD STQ[7]|VIN|VOUT|VS|VSN|VSP|VST|VST[7] VOUT|VSN|VSP$4 VBP|VDD
+ sg13_lv_pmos L=0.13u W=0.15u AS=0.1005p AD=0.1005p PS=1.34u PD=1.34u
M$1710 VBP|VDD VIN|VINA|VOUT VIN|VOUT$10 VBP|VDD sg13_lv_pmos L=0.13u W=0.45u
+ AS=0.2115p AD=0.2115p PS=2.82u PD=2.82u
M$1713 VIN|VOUT$10 STQ[7]|VIN|VOUT|VS|VSN|VSP|VST|VST[7] VIN|VOUT$9 VBP|VDD
+ sg13_lv_pmos L=0.13u W=0.6u AS=0.312p AD=0.312p PS=4.16u PD=4.16u
M$1717 VBP|VDD \$75 VOUT|VSN|VSP$5 VBP|VDD sg13_lv_pmos L=0.13u W=0.15u
+ AS=0.1005p AD=0.1005p PS=1.34u PD=1.34u
M$1718 VIN|VOUT$10 VOUT|VSN|VSP$5 VIN|VOUT$9 VBP|VDD sg13_lv_pmos L=0.13u
+ W=0.3u AS=0.156p AD=0.156p PS=2.08u PD=2.08u
M$1720 VIN|VOUT$9 VOUT|VSN|VSP$3 VIN|VOUT$4 VBP|VDD sg13_lv_pmos L=0.13u W=0.3u
+ AS=0.156p AD=0.156p PS=2.08u PD=2.08u
M$1722 VBP|VDD CLKN|VIN|VOUT|VOUTDP VIN|VOUT$11 VBP|VDD sg13_lv_pmos L=0.13u
+ W=0.15u AS=0.1005p AD=0.1005p PS=1.34u PD=1.34u
M$1723 VBP|VDD VIN|VOUT$11 VIN|VOUT$14 VBP|VDD sg13_lv_pmos L=0.13u W=0.3u
+ AS=0.156p AD=0.156p PS=2.08u PD=2.08u
M$1725 VBP|VDD VIN|VOUT$14 VIN|VOUT$15 VBP|VDD sg13_lv_pmos L=0.13u W=0.6u
+ AS=0.312p AD=0.312p PS=4.16u PD=4.16u
M$1729 VBP|VDD VIN|VOUT$15 PH0|PH3|V3|VIN|VOUT|VOUTDP VBP|VDD sg13_lv_pmos
+ L=0.13u W=1.2u AS=0.624p AD=0.624p PS=8.32u PD=8.32u
M$1737 VBP|VDD CLKN|VIN|VOUT|VOUTDP$1 VIN|VOUT$12 VBP|VDD sg13_lv_pmos L=0.13u
+ W=0.15u AS=0.1005p AD=0.1005p PS=1.34u PD=1.34u
M$1738 VBP|VDD VIN|VOUT$12 VIN|VOUT$16 VBP|VDD sg13_lv_pmos L=0.13u W=0.3u
+ AS=0.156p AD=0.156p PS=2.08u PD=2.08u
M$1740 VBP|VDD VIN|VOUT$16 VIN|VOUT$17 VBP|VDD sg13_lv_pmos L=0.13u W=0.6u
+ AS=0.312p AD=0.312p PS=4.16u PD=4.16u
M$1744 VBP|VDD VIN|VOUT$17 PH0|PH1|V1|VIN|VOUT|VOUTDN VBP|VDD sg13_lv_pmos
+ L=0.13u W=1.2u AS=0.624p AD=0.624p PS=8.32u PD=8.32u
M$1752 VBP|VDD CLKN|VIN|VOUT|VOUTDP$2 VIN|VOUT$13 VBP|VDD sg13_lv_pmos L=0.13u
+ W=0.15u AS=0.1005p AD=0.1005p PS=1.34u PD=1.34u
M$1753 VBP|VDD VIN|VOUT$13 VIN|VOUT$18 VBP|VDD sg13_lv_pmos L=0.13u W=0.3u
+ AS=0.156p AD=0.156p PS=2.08u PD=2.08u
M$1755 VBP|VDD VIN|VOUT$18 VIN|VOUT$19 VBP|VDD sg13_lv_pmos L=0.13u W=0.6u
+ AS=0.312p AD=0.312p PS=4.16u PD=4.16u
M$1759 VBP|VDD VIN|VOUT$19 PH0|PH1|PH5|V5|VIN|VOUT|VOUTDP VBP|VDD sg13_lv_pmos
+ L=0.13u W=1.2u AS=0.624p AD=0.624p PS=8.32u PD=8.32u
M$1767 VBP|VDD SQ[0]|VIN|VOUT|VS|VSN|VSP|VS[0] VOUT|VSN|VSP$8 VBP|VDD
+ sg13_lv_pmos L=0.13u W=0.15u AS=0.1005p AD=0.1005p PS=1.34u PD=1.34u
M$1768 VBP|VDD PH0|VIN|VINA|VINI|VOUT VIN|VOUT$20 VBP|VDD sg13_lv_pmos L=0.13u
+ W=0.45u AS=0.2115p AD=0.2115p PS=2.82u PD=2.82u
M$1771 VIN|VOUT$20 SQ[0]|VIN|VOUT|VS|VSN|VSP|VS[0] VIN|VOUT$21 VBP|VDD
+ sg13_lv_pmos L=0.13u W=0.6u AS=0.312p AD=0.312p PS=4.16u PD=4.16u
M$1775 VBP|VDD \$135 VOUT|VSN|VSP$7 VBP|VDD sg13_lv_pmos L=0.13u W=0.15u
+ AS=0.1005p AD=0.1005p PS=1.34u PD=1.34u
M$1776 VIN|VOUT$20 VOUT|VSN|VSP$7 VIN|VOUT$21 VBP|VDD sg13_lv_pmos L=0.13u
+ W=0.3u AS=0.156p AD=0.156p PS=2.08u PD=2.08u
M$1778 VIN|VOUT$21 VOUT|VSN|VSP$6 VIN|VINA|VOUT VBP|VDD sg13_lv_pmos L=0.13u
+ W=0.3u AS=0.156p AD=0.156p PS=2.08u PD=2.08u
M$1780 VBP|VDD VIN|VOUT$22 CLKN|VIN|VOUT|VOUTDP VBP|VDD sg13_lv_pmos L=0.13u
+ W=1.2u AS=0.624p AD=0.624p PS=8.32u PD=8.32u
M$1788 VBP|VDD VIN|VOUT$23 VIN|VOUT$22 VBP|VDD sg13_lv_pmos L=0.13u W=0.6u
+ AS=0.312p AD=0.312p PS=4.16u PD=4.16u
M$1792 VBP|VDD VIN|VOUT$24 VIN|VOUT$23 VBP|VDD sg13_lv_pmos L=0.13u W=0.3u
+ AS=0.156p AD=0.156p PS=2.08u PD=2.08u
M$1794 VIN|VOUT$24 VIN$1 VBP|VDD VBP|VDD sg13_lv_pmos L=0.13u W=0.15u
+ AS=0.1005p AD=0.1005p PS=1.34u PD=1.34u
M$1795 VBP|VDD VIN|VOUT$25 CLKN|VIN|VOUT|VOUTDP$1 VBP|VDD sg13_lv_pmos L=0.13u
+ W=1.2u AS=0.624p AD=0.624p PS=8.32u PD=8.32u
M$1803 VBP|VDD VIN|VOUT$26 VIN|VOUT$25 VBP|VDD sg13_lv_pmos L=0.13u W=0.6u
+ AS=0.312p AD=0.312p PS=4.16u PD=4.16u
M$1807 VBP|VDD VIN|VOUT$27 VIN|VOUT$26 VBP|VDD sg13_lv_pmos L=0.13u W=0.3u
+ AS=0.156p AD=0.156p PS=2.08u PD=2.08u
M$1809 VIN|VOUT$27 VIN$3 VBP|VDD VBP|VDD sg13_lv_pmos L=0.13u W=0.15u
+ AS=0.1005p AD=0.1005p PS=1.34u PD=1.34u
M$1810 VBP|VDD VIN|VOUT$28 CLKN|VIN|VOUT|VOUTDP$2 VBP|VDD sg13_lv_pmos L=0.13u
+ W=1.2u AS=0.624p AD=0.624p PS=8.32u PD=8.32u
M$1818 VBP|VDD VIN|VOUT$29 VIN|VOUT$28 VBP|VDD sg13_lv_pmos L=0.13u W=0.6u
+ AS=0.312p AD=0.312p PS=4.16u PD=4.16u
M$1822 VBP|VDD VIN|VOUT$30 VIN|VOUT$29 VBP|VDD sg13_lv_pmos L=0.13u W=0.3u
+ AS=0.156p AD=0.156p PS=2.08u PD=2.08u
M$1824 VIN|VOUT$30 VIN$5 VBP|VDD VBP|VDD sg13_lv_pmos L=0.13u W=0.15u
+ AS=0.1005p AD=0.1005p PS=1.34u PD=1.34u
M$1825 VBP|VDD PH270|VIN|VINB|VIND|VINQB|VOUT VIN|VOUT$31 VBP|VDD sg13_lv_pmos
+ L=0.13u W=0.45u AS=0.2115p AD=0.2115p PS=2.82u PD=2.82u
M$1828 VIN|VOUT$31 VOUT|VSN|VSP$9 VIN|VOUT$32 VBP|VDD sg13_lv_pmos L=0.13u
+ W=0.3u AS=0.156p AD=0.156p PS=2.08u PD=2.08u
M$1830 VIN|VOUT$31 VOUT|VSN|VSP$11 VIN|VOUT$32 VBP|VDD sg13_lv_pmos L=0.13u
+ W=0.6u AS=0.312p AD=0.312p PS=4.16u PD=4.16u
M$1832 VBP|VDD \$991 \$991 VBP|VDD sg13_lv_pmos L=0.13u W=0.15u AS=0.1005p
+ AD=0.1005p PS=1.34u PD=1.34u
M$1835 VIN|VOUT$32 VOUT|VSN|VSP$10 VIN|VINB|VOUT$1 VBP|VDD sg13_lv_pmos L=0.13u
+ W=0.3u AS=0.156p AD=0.156p PS=2.08u PD=2.08u
M$1837 VBP|VDD SQ[1]|VIN|VOUT|VS|VSN|VSP|VS[1] VOUT|VSN|VSP$9 VBP|VDD
+ sg13_lv_pmos L=0.13u W=0.15u AS=0.1005p AD=0.1005p PS=1.34u PD=1.34u
M$1838 VBP|VDD PH90|VIN|VINA|VINC|VINQ|VOUT VIN|VOUT$34 VBP|VDD sg13_lv_pmos
+ L=0.13u W=0.45u AS=0.2115p AD=0.2115p PS=2.82u PD=2.82u
M$1841 VIN|VOUT$34 SQ[1]|VIN|VOUT|VS|VSN|VSP|VS[1] VIN|VOUT$33 VBP|VDD
+ sg13_lv_pmos L=0.13u W=0.6u AS=0.312p AD=0.312p PS=4.16u PD=4.16u
M$1845 VBP|VDD \$1283 VOUT|VSN|VSP$11 VBP|VDD sg13_lv_pmos L=0.13u W=0.15u
+ AS=0.1005p AD=0.1005p PS=1.34u PD=1.34u
M$1846 VIN|VOUT$34 VOUT|VSN|VSP$11 VIN|VOUT$33 VBP|VDD sg13_lv_pmos L=0.13u
+ W=0.3u AS=0.156p AD=0.156p PS=2.08u PD=2.08u
M$1848 VIN|VOUT$33 VOUT|VSN|VSP$10 VIN|VINB|VOUT$1 VBP|VDD sg13_lv_pmos L=0.13u
+ W=0.3u AS=0.156p AD=0.156p PS=2.08u PD=2.08u
M$1850 VBP|VDD VIN|VINB|VOUT$1 VIN|VOUT$36 VBP|VDD sg13_lv_pmos L=0.13u W=0.45u
+ AS=0.2115p AD=0.2115p PS=2.82u PD=2.82u
M$1853 VIN|VOUT$36 VOUT|VSN|VSP$13 VIN|VOUT$35 VBP|VDD sg13_lv_pmos L=0.13u
+ W=0.3u AS=0.156p AD=0.156p PS=2.08u PD=2.08u
M$1855 VIN|VOUT$36 VOUT|VSN|VSP$14 VIN|VOUT$35 VBP|VDD sg13_lv_pmos L=0.13u
+ W=0.6u AS=0.312p AD=0.312p PS=4.16u PD=4.16u
M$1857 VBP|VDD \$1313 \$1313 VBP|VDD sg13_lv_pmos L=0.13u W=0.15u AS=0.1005p
+ AD=0.1005p PS=1.34u PD=1.34u
M$1860 VIN|VOUT$35 VOUT|VSN|VSP$12 VIN|VOUT$4 VBP|VDD sg13_lv_pmos L=0.13u
+ W=0.3u AS=0.156p AD=0.156p PS=2.08u PD=2.08u
M$1862 VBP|VDD \$1320 VIN$1 VBP|VDD sg13_lv_pmos L=0.13u W=1.5u AS=0.6p
+ AD=0.555p PS=8u PD=7.4u
M$1872 VBP|VDD \$1321 VIN VBP|VDD sg13_lv_pmos L=0.13u W=1.5u AS=0.555p AD=0.6p
+ PS=7.4u PD=8u
M$1882 VBP|VDD \$1322 VIN$3 VBP|VDD sg13_lv_pmos L=0.13u W=1.5u AS=0.6p
+ AD=0.555p PS=8u PD=7.4u
M$1892 VBP|VDD \$1323 VIN$2 VBP|VDD sg13_lv_pmos L=0.13u W=1.5u AS=0.555p
+ AD=0.6p PS=7.4u PD=8u
M$1902 VBP|VDD \$1324 VIN$5 VBP|VDD sg13_lv_pmos L=0.13u W=1.5u AS=0.6p
+ AD=0.555p PS=8u PD=7.4u
M$1912 VBP|VDD \$1325 VIN$4 VBP|VDD sg13_lv_pmos L=0.13u W=1.5u AS=0.555p
+ AD=0.6p PS=7.4u PD=8u
M$1922 VBP|VDD VBN|VSS VIN$1 VBP|VDD sg13_lv_pmos L=0.13u W=3u AS=1.2p AD=1.11p
+ PS=16u PD=14.8u
M$1932 VBP|VDD VBN|VSS VIN VBP|VDD sg13_lv_pmos L=0.13u W=3u AS=1.11p AD=1.2p
+ PS=14.8u PD=16u
M$1942 VBP|VDD VBN|VSS VIN$3 VBP|VDD sg13_lv_pmos L=0.13u W=3u AS=1.2p AD=1.11p
+ PS=16u PD=14.8u
M$1952 VBP|VDD VBN|VSS VIN$2 VBP|VDD sg13_lv_pmos L=0.13u W=3u AS=1.11p AD=1.2p
+ PS=14.8u PD=16u
M$1962 VBP|VDD VBN|VSS VIN$5 VBP|VDD sg13_lv_pmos L=0.13u W=3u AS=1.2p AD=1.11p
+ PS=16u PD=14.8u
M$1972 VBP|VDD VBN|VSS VIN$4 VBP|VDD sg13_lv_pmos L=0.13u W=3u AS=1.11p AD=1.2p
+ PS=14.8u PD=16u
M$2042 VBP|VDD PH180|VIN|VINB|VINIB|VOUT VIN|VOUT$37 VBP|VDD sg13_lv_pmos
+ L=0.13u W=0.45u AS=0.2115p AD=0.2115p PS=2.82u PD=2.82u
M$2045 VIN|VOUT$37 VOUT|VSN|VSP$17 VIN|VOUT$38 VBP|VDD sg13_lv_pmos L=0.13u
+ W=0.3u AS=0.156p AD=0.156p PS=2.08u PD=2.08u
M$2047 VIN|VOUT$37 VOUT|VSN|VSP$16 VIN|VOUT$38 VBP|VDD sg13_lv_pmos L=0.13u
+ W=0.6u AS=0.312p AD=0.312p PS=4.16u PD=4.16u
M$2049 VBP|VDD \$1396 \$1396 VBP|VDD sg13_lv_pmos L=0.13u W=0.15u AS=0.1005p
+ AD=0.1005p PS=1.34u PD=1.34u
M$2052 VIN|VOUT$38 VOUT|VSN|VSP$15 VIN|VINA|VOUT$1 VBP|VDD sg13_lv_pmos L=0.13u
+ W=0.3u AS=0.156p AD=0.156p PS=2.08u PD=2.08u
M$2054 VBP|VDD STQ[6]|VIN|VOUT|VS|VSN|VSP|VST|VST[6] VOUT|VSN|VSP$13 VBP|VDD
+ sg13_lv_pmos L=0.13u W=0.15u AS=0.1005p AD=0.1005p PS=1.34u PD=1.34u
M$2055 VBP|VDD VIN|VINA|VOUT$1 VIN|VOUT$39 VBP|VDD sg13_lv_pmos L=0.13u W=0.45u
+ AS=0.2115p AD=0.2115p PS=2.82u PD=2.82u
M$2058 VIN|VOUT$39 STQ[6]|VIN|VOUT|VS|VSN|VSP|VST|VST[6] VIN|VOUT$40 VBP|VDD
+ sg13_lv_pmos L=0.13u W=0.6u AS=0.312p AD=0.312p PS=4.16u PD=4.16u
M$2062 VBP|VDD \$1370 VOUT|VSN|VSP$14 VBP|VDD sg13_lv_pmos L=0.13u W=0.15u
+ AS=0.1005p AD=0.1005p PS=1.34u PD=1.34u
M$2063 VIN|VOUT$39 VOUT|VSN|VSP$14 VIN|VOUT$40 VBP|VDD sg13_lv_pmos L=0.13u
+ W=0.3u AS=0.156p AD=0.156p PS=2.08u PD=2.08u
M$2065 VIN|VOUT$40 VOUT|VSN|VSP$12 VIN|VOUT$4 VBP|VDD sg13_lv_pmos L=0.13u
+ W=0.3u AS=0.156p AD=0.156p PS=2.08u PD=2.08u
M$2067 VBP|VDD VIN VIN|VOUT$41 VBP|VDD sg13_lv_pmos L=0.13u W=0.15u AS=0.1005p
+ AD=0.1005p PS=1.34u PD=1.34u
M$2068 VBP|VDD VIN|VOUT$41 VIN|VOUT$44 VBP|VDD sg13_lv_pmos L=0.13u W=0.3u
+ AS=0.156p AD=0.156p PS=2.08u PD=2.08u
M$2070 VBP|VDD VIN|VOUT$44 VIN|VOUT$45 VBP|VDD sg13_lv_pmos L=0.13u W=0.6u
+ AS=0.312p AD=0.312p PS=4.16u PD=4.16u
M$2074 VBP|VDD VIN|VOUT$45 CLKP|VIN|VOUT|VOUTDN VBP|VDD sg13_lv_pmos L=0.13u
+ W=1.2u AS=0.624p AD=0.624p PS=8.32u PD=8.32u
M$2082 VBP|VDD VIN$2 VIN|VOUT$42 VBP|VDD sg13_lv_pmos L=0.13u W=0.15u
+ AS=0.1005p AD=0.1005p PS=1.34u PD=1.34u
M$2083 VBP|VDD VIN|VOUT$42 VIN|VOUT$46 VBP|VDD sg13_lv_pmos L=0.13u W=0.3u
+ AS=0.156p AD=0.156p PS=2.08u PD=2.08u
M$2085 VBP|VDD VIN|VOUT$46 VIN|VOUT$47 VBP|VDD sg13_lv_pmos L=0.13u W=0.6u
+ AS=0.312p AD=0.312p PS=4.16u PD=4.16u
M$2089 VBP|VDD VIN|VOUT$47 CLKP|VIN|VOUT|VOUTDN$1 VBP|VDD sg13_lv_pmos L=0.13u
+ W=1.2u AS=0.624p AD=0.624p PS=8.32u PD=8.32u
M$2097 VBP|VDD VIN$4 VIN|VOUT$43 VBP|VDD sg13_lv_pmos L=0.13u W=0.15u
+ AS=0.1005p AD=0.1005p PS=1.34u PD=1.34u
M$2098 VBP|VDD VIN|VOUT$43 VIN|VOUT$48 VBP|VDD sg13_lv_pmos L=0.13u W=0.3u
+ AS=0.156p AD=0.156p PS=2.08u PD=2.08u
M$2100 VBP|VDD VIN|VOUT$48 VIN|VOUT$49 VBP|VDD sg13_lv_pmos L=0.13u W=0.6u
+ AS=0.312p AD=0.312p PS=4.16u PD=4.16u
M$2104 VBP|VDD VIN|VOUT$49 CLKP|VIN|VOUT|VOUTDN$2 VBP|VDD sg13_lv_pmos L=0.13u
+ W=1.2u AS=0.624p AD=0.624p PS=8.32u PD=8.32u
M$2112 VBP|VDD SQ[0]|VIN|VOUT|VS|VSN|VSP|VS[0] VOUT|VSN|VSP$17 VBP|VDD
+ sg13_lv_pmos L=0.13u W=0.15u AS=0.1005p AD=0.1005p PS=1.34u PD=1.34u
M$2113 VBP|VDD PH0|VIN|VINA|VINI|VOUT VIN|VOUT$51 VBP|VDD sg13_lv_pmos L=0.13u
+ W=0.45u AS=0.2115p AD=0.2115p PS=2.82u PD=2.82u
M$2116 VIN|VOUT$51 SQ[0]|VIN|VOUT|VS|VSN|VSP|VS[0] VIN|VOUT$50 VBP|VDD
+ sg13_lv_pmos L=0.13u W=0.6u AS=0.312p AD=0.312p PS=4.16u PD=4.16u
M$2120 VBP|VDD \$1699 VOUT|VSN|VSP$16 VBP|VDD sg13_lv_pmos L=0.13u W=0.15u
+ AS=0.1005p AD=0.1005p PS=1.34u PD=1.34u
M$2121 VIN|VOUT$51 VOUT|VSN|VSP$16 VIN|VOUT$50 VBP|VDD sg13_lv_pmos L=0.13u
+ W=0.3u AS=0.156p AD=0.156p PS=2.08u PD=2.08u
M$2123 VIN|VOUT$50 VOUT|VSN|VSP$15 VIN|VINA|VOUT$1 VBP|VDD sg13_lv_pmos L=0.13u
+ W=0.3u AS=0.156p AD=0.156p PS=2.08u PD=2.08u
M$2125 VBP|VDD VIN|VOUT$52 PH0|PH1|V0|VIN|VOUT|VOUTDN VBP|VDD sg13_lv_pmos
+ L=0.13u W=1.2u AS=0.624p AD=0.624p PS=8.32u PD=8.32u
M$2129 CTRL|VCONT PH0|PH1|V0|VIN|VOUT|VOUTDN CTRL|VCONT VBP|VDD sg13_lv_pmos
+ L=0.13u W=32u AS=6.68p AD=6.08p PS=49.36u PD=44.16u
M$2137 CTRL|VCONT PH0|PH3|V3|VIN|VOUT|VOUTDP CTRL|VCONT VBP|VDD sg13_lv_pmos
+ L=0.13u W=32u AS=6.08p AD=6.68p PS=44.16u PD=49.36u
M$2149 VBP|VDD VIN|VOUT$53 VIN|VOUT$52 VBP|VDD sg13_lv_pmos L=0.13u W=0.6u
+ AS=0.312p AD=0.312p PS=4.16u PD=4.16u
M$2153 VBP|VDD VIN|VOUT$54 VIN|VOUT$53 VBP|VDD sg13_lv_pmos L=0.13u W=0.3u
+ AS=0.156p AD=0.156p PS=2.08u PD=2.08u
M$2155 VIN|VOUT$54 CLKP|VIN|VOUT|VOUTDN VBP|VDD VBP|VDD sg13_lv_pmos L=0.13u
+ W=0.15u AS=0.1005p AD=0.1005p PS=1.34u PD=1.34u
M$2156 VBP|VDD VIN|VOUT$55 PH0|PH1|PH4|V4|VIN|VOUT|VOUTDP VBP|VDD sg13_lv_pmos
+ L=0.13u W=1.2u AS=0.624p AD=0.624p PS=8.32u PD=8.32u
M$2160 CTRL|VCONT PH0|PH1|PH4|V4|VIN|VOUT|VOUTDP CTRL|VCONT VBP|VDD
+ sg13_lv_pmos L=0.13u W=32u AS=6.68p AD=6.08p PS=49.36u PD=44.16u
M$2168 CTRL|VCONT PH0|PH1|V1|VIN|VOUT|VOUTDN CTRL|VCONT VBP|VDD sg13_lv_pmos
+ L=0.13u W=32u AS=6.08p AD=6.68p PS=44.16u PD=49.36u
M$2180 VBP|VDD VIN|VOUT$56 VIN|VOUT$55 VBP|VDD sg13_lv_pmos L=0.13u W=0.6u
+ AS=0.312p AD=0.312p PS=4.16u PD=4.16u
M$2184 VBP|VDD VIN|VOUT$57 VIN|VOUT$56 VBP|VDD sg13_lv_pmos L=0.13u W=0.3u
+ AS=0.156p AD=0.156p PS=2.08u PD=2.08u
M$2186 VIN|VOUT$57 CLKP|VIN|VOUT|VOUTDN$1 VBP|VDD VBP|VDD sg13_lv_pmos L=0.13u
+ W=0.15u AS=0.1005p AD=0.1005p PS=1.34u PD=1.34u
M$2187 VBP|VDD VIN|VOUT$58 PH1|PH2|V2|VIN|VOUT|VOUTDN VBP|VDD sg13_lv_pmos
+ L=0.13u W=1.2u AS=0.624p AD=0.624p PS=8.32u PD=8.32u
M$2191 CTRL|VCONT PH1|PH2|V2|VIN|VOUT|VOUTDN CTRL|VCONT VBP|VDD sg13_lv_pmos
+ L=0.13u W=32u AS=6.68p AD=6.08p PS=49.36u PD=44.16u
M$2199 CTRL|VCONT PH0|PH1|PH5|V5|VIN|VOUT|VOUTDP CTRL|VCONT VBP|VDD
+ sg13_lv_pmos L=0.13u W=32u AS=6.08p AD=6.68p PS=44.16u PD=49.36u
M$2211 VBP|VDD VIN|VOUT$59 VIN|VOUT$58 VBP|VDD sg13_lv_pmos L=0.13u W=0.6u
+ AS=0.312p AD=0.312p PS=4.16u PD=4.16u
M$2215 VBP|VDD VIN|VOUT$60 VIN|VOUT$59 VBP|VDD sg13_lv_pmos L=0.13u W=0.3u
+ AS=0.156p AD=0.156p PS=2.08u PD=2.08u
M$2217 VIN|VOUT$60 CLKP|VIN|VOUT|VOUTDN$2 VBP|VDD VBP|VDD sg13_lv_pmos L=0.13u
+ W=0.15u AS=0.1005p AD=0.1005p PS=1.34u PD=1.34u
M$2266 VBP|VDD PH270|VIN|VINB|VIND|VINQB|VOUT VIN|VOUT$62 VBP|VDD sg13_lv_pmos
+ L=0.13u W=0.45u AS=0.2115p AD=0.2115p PS=2.82u PD=2.82u
M$2269 VIN|VOUT$62 VOUT|VSN|VSP$19 VIN|VOUT$61 VBP|VDD sg13_lv_pmos L=0.13u
+ W=0.3u AS=0.156p AD=0.156p PS=2.08u PD=2.08u
M$2271 VIN|VOUT$62 VOUT|VSN|VSP$20 VIN|VOUT$61 VBP|VDD sg13_lv_pmos L=0.13u
+ W=0.6u AS=0.312p AD=0.312p PS=4.16u PD=4.16u
M$2273 VBP|VDD \$2559 \$2559 VBP|VDD sg13_lv_pmos L=0.13u W=0.15u AS=0.1005p
+ AD=0.1005p PS=1.34u PD=1.34u
M$2276 VIN|VOUT$61 VOUT|VSN|VSP$18 VIN|VINB|VOUT$2 VBP|VDD sg13_lv_pmos L=0.13u
+ W=0.3u AS=0.156p AD=0.156p PS=2.08u PD=2.08u
M$2374 VBP|VDD SQ[1]|VIN|VOUT|VS|VSN|VSP|VS[1] VOUT|VSN|VSP$19 VBP|VDD
+ sg13_lv_pmos L=0.13u W=0.15u AS=0.1005p AD=0.1005p PS=1.34u PD=1.34u
M$2375 VBP|VDD PH90|VIN|VINA|VINC|VINQ|VOUT VIN|VOUT$63 VBP|VDD sg13_lv_pmos
+ L=0.13u W=0.45u AS=0.2115p AD=0.2115p PS=2.82u PD=2.82u
M$2378 VIN|VOUT$63 SQ[1]|VIN|VOUT|VS|VSN|VSP|VS[1] VIN|VOUT$64 VBP|VDD
+ sg13_lv_pmos L=0.13u W=0.6u AS=0.312p AD=0.312p PS=4.16u PD=4.16u
M$2382 VBP|VDD \$2580 VOUT|VSN|VSP$20 VBP|VDD sg13_lv_pmos L=0.13u W=0.15u
+ AS=0.1005p AD=0.1005p PS=1.34u PD=1.34u
M$2383 VIN|VOUT$63 VOUT|VSN|VSP$20 VIN|VOUT$64 VBP|VDD sg13_lv_pmos L=0.13u
+ W=0.3u AS=0.156p AD=0.156p PS=2.08u PD=2.08u
M$2385 VIN|VOUT$64 VOUT|VSN|VSP$18 VIN|VINB|VOUT$2 VBP|VDD sg13_lv_pmos L=0.13u
+ W=0.3u AS=0.156p AD=0.156p PS=2.08u PD=2.08u
M$2387 VBP|VDD VIN|VINB|VOUT$2 VIN|VOUT$65 VBP|VDD sg13_lv_pmos L=0.13u W=0.45u
+ AS=0.2115p AD=0.2115p PS=2.82u PD=2.82u
M$2390 VIN|VOUT$65 VOUT|VSN|VSP$22 VIN|VOUT$66 VBP|VDD sg13_lv_pmos L=0.13u
+ W=0.3u AS=0.156p AD=0.156p PS=2.08u PD=2.08u
M$2392 VIN|VOUT$65 VOUT|VSN|VSP$23 VIN|VOUT$66 VBP|VDD sg13_lv_pmos L=0.13u
+ W=0.6u AS=0.312p AD=0.312p PS=4.16u PD=4.16u
M$2394 VBP|VDD \$2617 \$2617 VBP|VDD sg13_lv_pmos L=0.13u W=0.15u AS=0.1005p
+ AD=0.1005p PS=1.34u PD=1.34u
M$2397 VIN|VOUT$66 VOUT|VSN|VSP$21 VIN|VOUT$4 VBP|VDD sg13_lv_pmos L=0.13u
+ W=0.3u AS=0.156p AD=0.156p PS=2.08u PD=2.08u
M$2399 VBP|VDD PH0|PH1|V0|VIN|VOUT|VOUTDN PH0|PH3|V3|VIN|VOUT|VOUTDP VBP|VDD
+ sg13_lv_pmos L=0.13u W=0.3u AS=0.156p AD=0.156p PS=2.08u PD=2.08u
M$2401 VBP|VDD PH0|PH3|V3|VIN|VOUT|VOUTDP PH0|PH1|V0|VIN|VOUT|VOUTDN VBP|VDD
+ sg13_lv_pmos L=0.13u W=0.3u AS=0.156p AD=0.156p PS=2.08u PD=2.08u
M$2403 VBP|VDD PH0|PH1|PH4|V4|VIN|VOUT|VOUTDP PH0|PH1|V1|VIN|VOUT|VOUTDN
+ VBP|VDD sg13_lv_pmos L=0.13u W=0.3u AS=0.156p AD=0.156p PS=2.08u PD=2.08u
M$2405 VBP|VDD PH0|PH1|V1|VIN|VOUT|VOUTDN PH0|PH1|PH4|V4|VIN|VOUT|VOUTDP
+ VBP|VDD sg13_lv_pmos L=0.13u W=0.3u AS=0.156p AD=0.156p PS=2.08u PD=2.08u
M$2407 VBP|VDD PH1|PH2|V2|VIN|VOUT|VOUTDN PH0|PH1|PH5|V5|VIN|VOUT|VOUTDP
+ VBP|VDD sg13_lv_pmos L=0.13u W=0.3u AS=0.156p AD=0.156p PS=2.08u PD=2.08u
M$2409 VBP|VDD PH0|PH1|PH5|V5|VIN|VOUT|VOUTDP PH1|PH2|V2|VIN|VOUT|VOUTDN
+ VBP|VDD sg13_lv_pmos L=0.13u W=0.3u AS=0.156p AD=0.156p PS=2.08u PD=2.08u
M$2411 VBP|VDD PH180|VIN|VINB|VINIB|VOUT VIN|VOUT$67 VBP|VDD sg13_lv_pmos
+ L=0.13u W=0.45u AS=0.2115p AD=0.2115p PS=2.82u PD=2.82u
M$2414 VIN|VOUT$67 VOUT|VSN|VSP$26 VIN|VOUT$68 VBP|VDD sg13_lv_pmos L=0.13u
+ W=0.3u AS=0.156p AD=0.156p PS=2.08u PD=2.08u
M$2416 VIN|VOUT$67 VOUT|VSN|VSP$25 VIN|VOUT$68 VBP|VDD sg13_lv_pmos L=0.13u
+ W=0.6u AS=0.312p AD=0.312p PS=4.16u PD=4.16u
M$2418 VBP|VDD \$2685 \$2685 VBP|VDD sg13_lv_pmos L=0.13u W=0.15u AS=0.1005p
+ AD=0.1005p PS=1.34u PD=1.34u
M$2421 VIN|VOUT$68 VOUT|VSN|VSP$24 VIN|VINA|VOUT$2 VBP|VDD sg13_lv_pmos L=0.13u
+ W=0.3u AS=0.156p AD=0.156p PS=2.08u PD=2.08u
M$2423 VBP|VDD STQ[5]|VIN|VOUT|VS|VSN|VSP|VST|VST[5] VOUT|VSN|VSP$22 VBP|VDD
+ sg13_lv_pmos L=0.13u W=0.15u AS=0.1005p AD=0.1005p PS=1.34u PD=1.34u
M$2424 VBP|VDD VIN|VINA|VOUT$2 VIN|VOUT$69 VBP|VDD sg13_lv_pmos L=0.13u W=0.45u
+ AS=0.2115p AD=0.2115p PS=2.82u PD=2.82u
M$2427 VIN|VOUT$69 STQ[5]|VIN|VOUT|VS|VSN|VSP|VST|VST[5] VIN|VOUT$70 VBP|VDD
+ sg13_lv_pmos L=0.13u W=0.6u AS=0.312p AD=0.312p PS=4.16u PD=4.16u
M$2431 VBP|VDD \$2665 VOUT|VSN|VSP$23 VBP|VDD sg13_lv_pmos L=0.13u W=0.15u
+ AS=0.1005p AD=0.1005p PS=1.34u PD=1.34u
M$2432 VIN|VOUT$69 VOUT|VSN|VSP$23 VIN|VOUT$70 VBP|VDD sg13_lv_pmos L=0.13u
+ W=0.3u AS=0.156p AD=0.156p PS=2.08u PD=2.08u
M$2434 VIN|VOUT$70 VOUT|VSN|VSP$21 VIN|VOUT$4 VBP|VDD sg13_lv_pmos L=0.13u
+ W=0.3u AS=0.156p AD=0.156p PS=2.08u PD=2.08u
M$2436 VBP|VDD VIN|VOUT$73 PH180|VIN|VINB|VINIB|VOUT VBP|VDD sg13_lv_pmos
+ L=0.13u W=14.4u AS=6.768p AD=6.768p PS=90.24u PD=90.24u
M$2460 VBP|VDD SQ[0]|VIN|VOUT|VS|VSN|VSP|VS[0] VOUT|VSN|VSP$26 VBP|VDD
+ sg13_lv_pmos L=0.13u W=0.15u AS=0.1005p AD=0.1005p PS=1.34u PD=1.34u
M$2461 VBP|VDD PH0|VIN|VINA|VINI|VOUT VIN|VOUT$71 VBP|VDD sg13_lv_pmos L=0.13u
+ W=0.45u AS=0.2115p AD=0.2115p PS=2.82u PD=2.82u
M$2464 VIN|VOUT$71 SQ[0]|VIN|VOUT|VS|VSN|VSP|VS[0] VIN|VOUT$72 VBP|VDD
+ sg13_lv_pmos L=0.13u W=0.6u AS=0.312p AD=0.312p PS=4.16u PD=4.16u
M$2468 VBP|VDD \$2853 VOUT|VSN|VSP$25 VBP|VDD sg13_lv_pmos L=0.13u W=0.15u
+ AS=0.1005p AD=0.1005p PS=1.34u PD=1.34u
M$2469 VIN|VOUT$71 VOUT|VSN|VSP$25 VIN|VOUT$72 VBP|VDD sg13_lv_pmos L=0.13u
+ W=0.3u AS=0.156p AD=0.156p PS=2.08u PD=2.08u
M$2471 VIN|VOUT$72 VOUT|VSN|VSP$24 VIN|VINA|VOUT$2 VBP|VDD sg13_lv_pmos L=0.13u
+ W=0.3u AS=0.156p AD=0.156p PS=2.08u PD=2.08u
M$2497 VBP|VDD PH270|VIN|VINB|VIND|VINQB|VOUT VIN|VOUT$75 VBP|VDD sg13_lv_pmos
+ L=0.13u W=0.45u AS=0.2115p AD=0.2115p PS=2.82u PD=2.82u
M$2500 VIN|VOUT$75 VOUT|VSN|VSP$28 VIN|VOUT$74 VBP|VDD sg13_lv_pmos L=0.13u
+ W=0.3u AS=0.156p AD=0.156p PS=2.08u PD=2.08u
M$2502 VIN|VOUT$75 VOUT|VSN|VSP$29 VIN|VOUT$74 VBP|VDD sg13_lv_pmos L=0.13u
+ W=0.6u AS=0.312p AD=0.312p PS=4.16u PD=4.16u
M$2504 VBP|VDD \$2914 \$2914 VBP|VDD sg13_lv_pmos L=0.13u W=0.15u AS=0.1005p
+ AD=0.1005p PS=1.34u PD=1.34u
M$2507 VIN|VOUT$74 VOUT|VSN|VSP$27 VIN|VINB|VOUT$3 VBP|VDD sg13_lv_pmos L=0.13u
+ W=0.3u AS=0.156p AD=0.156p PS=2.08u PD=2.08u
M$2509 VBP|VDD PH0|PH3|V3|VIN|VOUT|VOUTDP VIN|VOUT$81 VBP|VDD sg13_lv_pmos
+ L=0.13u W=0.9u AS=0.423p AD=0.423p PS=5.64u PD=5.64u
M$2515 VBP|VDD VIN|VOUT$81 PH1|VIN|VOUT VBP|VDD sg13_lv_pmos L=0.13u W=0.9u
+ AS=0.423p AD=0.423p PS=5.64u PD=5.64u
M$2521 VBP|VDD PH1|VIN|VOUT VIN|VOUT$82 VBP|VDD sg13_lv_pmos L=0.13u W=0.9u
+ AS=0.423p AD=0.423p PS=5.64u PD=5.64u
M$2527 VBP|VDD VIN|VOUT$82 VIN|VOUT$76 VBP|VDD sg13_lv_pmos L=0.13u W=1.8u
+ AS=0.846p AD=0.846p PS=11.28u PD=11.28u
M$2539 VBP|VDD VIN|VOUT$83 VIN|VOUT$84 VBP|VDD sg13_lv_pmos L=0.13u W=7.2u
+ AS=3.384p AD=3.384p PS=45.12u PD=45.12u
M$2563 VBP|VDD VIN|VOUT$84 VIN|VOUT$73 VBP|VDD sg13_lv_pmos L=0.13u W=7.2u
+ AS=3.384p AD=3.384p PS=45.12u PD=45.12u
M$2611 VBP|VDD SQ[1]|VIN|VOUT|VS|VSN|VSP|VS[1] VOUT|VSN|VSP$28 VBP|VDD
+ sg13_lv_pmos L=0.13u W=0.15u AS=0.1005p AD=0.1005p PS=1.34u PD=1.34u
M$2612 VBP|VDD PH90|VIN|VINA|VINC|VINQ|VOUT VIN|VOUT$77 VBP|VDD sg13_lv_pmos
+ L=0.13u W=0.45u AS=0.2115p AD=0.2115p PS=2.82u PD=2.82u
M$2615 VIN|VOUT$77 SQ[1]|VIN|VOUT|VS|VSN|VSP|VS[1] VIN|VOUT$78 VBP|VDD
+ sg13_lv_pmos L=0.13u W=0.6u AS=0.312p AD=0.312p PS=4.16u PD=4.16u
M$2619 VBP|VDD \$2933 VOUT|VSN|VSP$29 VBP|VDD sg13_lv_pmos L=0.13u W=0.15u
+ AS=0.1005p AD=0.1005p PS=1.34u PD=1.34u
M$2620 VIN|VOUT$77 VOUT|VSN|VSP$29 VIN|VOUT$78 VBP|VDD sg13_lv_pmos L=0.13u
+ W=0.3u AS=0.156p AD=0.156p PS=2.08u PD=2.08u
M$2622 VIN|VOUT$78 VOUT|VSN|VSP$27 VIN|VINB|VOUT$3 VBP|VDD sg13_lv_pmos L=0.13u
+ W=0.3u AS=0.156p AD=0.156p PS=2.08u PD=2.08u
M$2624 VBP|VDD VIN|VINB|VOUT$3 VIN|VOUT$79 VBP|VDD sg13_lv_pmos L=0.13u W=0.45u
+ AS=0.2115p AD=0.2115p PS=2.82u PD=2.82u
M$2627 VIN|VOUT$79 VOUT|VSN|VSP$31 VIN|VOUT$80 VBP|VDD sg13_lv_pmos L=0.13u
+ W=0.3u AS=0.156p AD=0.156p PS=2.08u PD=2.08u
M$2629 VIN|VOUT$79 VOUT|VSN|VSP$32 VIN|VOUT$80 VBP|VDD sg13_lv_pmos L=0.13u
+ W=0.6u AS=0.312p AD=0.312p PS=4.16u PD=4.16u
M$2631 VBP|VDD \$2994 \$2994 VBP|VDD sg13_lv_pmos L=0.13u W=0.15u AS=0.1005p
+ AD=0.1005p PS=1.34u PD=1.34u
M$2634 VIN|VOUT$80 VOUT|VSN|VSP$30 VIN|VOUT$4 VBP|VDD sg13_lv_pmos L=0.13u
+ W=0.3u AS=0.156p AD=0.156p PS=2.08u PD=2.08u
M$2636 VBP|VDD VIN|VOUT$76 VIN|VOUT$83 VBP|VDD sg13_lv_pmos L=0.13u W=3.6u
+ AS=1.692p AD=1.692p PS=22.56u PD=22.56u
M$2732 VBP|VDD PH180|VIN|VINB|VINIB|VOUT VIN|VOUT$85 VBP|VDD sg13_lv_pmos
+ L=0.13u W=0.45u AS=0.2115p AD=0.2115p PS=2.82u PD=2.82u
M$2735 VIN|VOUT$85 VOUT|VSN|VSP$34 VIN|VOUT$86 VBP|VDD sg13_lv_pmos L=0.13u
+ W=0.3u AS=0.156p AD=0.156p PS=2.08u PD=2.08u
M$2737 VIN|VOUT$85 VOUT|VSN|VSP$35 VIN|VOUT$86 VBP|VDD sg13_lv_pmos L=0.13u
+ W=0.6u AS=0.312p AD=0.312p PS=4.16u PD=4.16u
M$2739 VBP|VDD \$3072 \$3072 VBP|VDD sg13_lv_pmos L=0.13u W=0.15u AS=0.1005p
+ AD=0.1005p PS=1.34u PD=1.34u
M$2742 VIN|VOUT$86 VOUT|VSN|VSP$33 VIN|VINA|VOUT$3 VBP|VDD sg13_lv_pmos L=0.13u
+ W=0.3u AS=0.156p AD=0.156p PS=2.08u PD=2.08u
M$2744 VBP|VDD STQ[4]|VIN|VOUT|VS|VSN|VSP|VST|VST[4] VOUT|VSN|VSP$31 VBP|VDD
+ sg13_lv_pmos L=0.13u W=0.15u AS=0.1005p AD=0.1005p PS=1.34u PD=1.34u
M$2745 VBP|VDD VIN|VINA|VOUT$3 VIN|VOUT$87 VBP|VDD sg13_lv_pmos L=0.13u W=0.45u
+ AS=0.2115p AD=0.2115p PS=2.82u PD=2.82u
M$2748 VIN|VOUT$87 STQ[4]|VIN|VOUT|VS|VSN|VSP|VST|VST[4] VIN|VOUT$88 VBP|VDD
+ sg13_lv_pmos L=0.13u W=0.6u AS=0.312p AD=0.312p PS=4.16u PD=4.16u
M$2752 VBP|VDD \$3054 VOUT|VSN|VSP$32 VBP|VDD sg13_lv_pmos L=0.13u W=0.15u
+ AS=0.1005p AD=0.1005p PS=1.34u PD=1.34u
M$2753 VIN|VOUT$87 VOUT|VSN|VSP$32 VIN|VOUT$88 VBP|VDD sg13_lv_pmos L=0.13u
+ W=0.3u AS=0.156p AD=0.156p PS=2.08u PD=2.08u
M$2755 VIN|VOUT$88 VOUT|VSN|VSP$30 VIN|VOUT$4 VBP|VDD sg13_lv_pmos L=0.13u
+ W=0.3u AS=0.156p AD=0.156p PS=2.08u PD=2.08u
M$2757 VBP|VDD D|VIN|VOUT VIN|VOUT$94 VBP|VDD sg13_lv_pmos L=0.13u W=0.15u
+ AS=0.1005p AD=0.1005p PS=1.34u PD=1.34u
M$2758 VIN|VOUT$94 CLK|CLKIN|VIN|VINPI|VOUT|VSN|VSP VIN|VOUT$95 VBP|VDD
+ sg13_lv_pmos L=0.13u W=0.3u AS=0.156p AD=0.156p PS=2.08u PD=2.08u
M$2760 VBP|VDD VIN|VOUT$107 VIN|VOUT$96 VBP|VDD sg13_lv_pmos L=0.13u W=0.15u
+ AS=0.1005p AD=0.1005p PS=1.34u PD=1.34u
M$2761 VIN|VOUT$96 VOUT|VSN|VSP$36 VIN|VOUT$97 VBP|VDD sg13_lv_pmos L=0.13u
+ W=0.3u AS=0.156p AD=0.156p PS=2.08u PD=2.08u
M$2763 VBP|VDD CLK|CLKIN|CLKOUT|Q|VIN|VOUT|VSN|VSP D|VIN|VOUT VBP|VDD
+ sg13_lv_pmos L=0.13u W=0.15u AS=0.1005p AD=0.1005p PS=1.34u PD=1.34u
M$2764 VBP|VDD D|VIN|VOUT$1 VIN|VOUT$98 VBP|VDD sg13_lv_pmos L=0.13u W=0.15u
+ AS=0.1005p AD=0.1005p PS=1.34u PD=1.34u
M$2765 VIN|VOUT$98 CLK|CLKIN|CLKOUT|Q|VIN|VOUT|VSN|VSP VIN|VOUT$99 VBP|VDD
+ sg13_lv_pmos L=0.13u W=0.3u AS=0.156p AD=0.156p PS=2.08u PD=2.08u
M$2767 VBP|VDD VIN|VOUT$108 VIN|VOUT$100 VBP|VDD sg13_lv_pmos L=0.13u W=0.15u
+ AS=0.1005p AD=0.1005p PS=1.34u PD=1.34u
M$2768 VIN|VOUT$100 VOUT|VSN|VSP$37 VIN|VOUT$101 VBP|VDD sg13_lv_pmos L=0.13u
+ W=0.3u AS=0.156p AD=0.156p PS=2.08u PD=2.08u
M$2770 VBP|VDD CLK|CLKIN|CLKOUT|Q|VIN|VOUT|VSN|VSP$1 D|VIN|VOUT$1 VBP|VDD
+ sg13_lv_pmos L=0.13u W=0.15u AS=0.1005p AD=0.1005p PS=1.34u PD=1.34u
M$2771 VBP|VDD D|VIN|VOUT$2 VIN|VOUT$102 VBP|VDD sg13_lv_pmos L=0.13u W=0.15u
+ AS=0.1005p AD=0.1005p PS=1.34u PD=1.34u
M$2772 VIN|VOUT$102 CLK|CLKIN|CLKOUT|Q|VIN|VOUT|VSN|VSP$1 VIN|VOUT$103 VBP|VDD
+ sg13_lv_pmos L=0.13u W=0.3u AS=0.156p AD=0.156p PS=2.08u PD=2.08u
M$2774 VBP|VDD VIN|VOUT$109 VIN|VOUT$104 VBP|VDD sg13_lv_pmos L=0.13u W=0.15u
+ AS=0.1005p AD=0.1005p PS=1.34u PD=1.34u
M$2775 VIN|VOUT$104 VOUT|VSN|VSP$38 VIN|VOUT$105 VBP|VDD sg13_lv_pmos L=0.13u
+ W=0.3u AS=0.156p AD=0.156p PS=2.08u PD=2.08u
M$2777 VBP|VDD CLKOUT|Q|VIN|VOUT D|VIN|VOUT$2 VBP|VDD sg13_lv_pmos L=0.13u
+ W=0.15u AS=0.1005p AD=0.1005p PS=1.34u PD=1.34u
M$2778 VBP|VDD SQ[0]|VIN|VOUT|VS|VSN|VSP|VS[0] VOUT|VSN|VSP$34 VBP|VDD
+ sg13_lv_pmos L=0.13u W=0.15u AS=0.1005p AD=0.1005p PS=1.34u PD=1.34u
M$2779 VBP|VDD PH0|VIN|VINA|VINI|VOUT VIN|VOUT$106 VBP|VDD sg13_lv_pmos L=0.13u
+ W=0.45u AS=0.2115p AD=0.2115p PS=2.82u PD=2.82u
M$2782 VIN|VOUT$106 SQ[0]|VIN|VOUT|VS|VSN|VSP|VS[0] VIN|VOUT$89 VBP|VDD
+ sg13_lv_pmos L=0.13u W=0.6u AS=0.312p AD=0.312p PS=4.16u PD=4.16u
M$2786 VBP|VDD \$3160 VOUT|VSN|VSP$35 VBP|VDD sg13_lv_pmos L=0.13u W=0.15u
+ AS=0.1005p AD=0.1005p PS=1.34u PD=1.34u
M$2787 VIN|VOUT$106 VOUT|VSN|VSP$35 VIN|VOUT$89 VBP|VDD sg13_lv_pmos L=0.13u
+ W=0.3u AS=0.156p AD=0.156p PS=2.08u PD=2.08u
M$2789 VIN|VOUT$89 VOUT|VSN|VSP$33 VIN|VINA|VOUT$3 VBP|VDD sg13_lv_pmos L=0.13u
+ W=0.3u AS=0.156p AD=0.156p PS=2.08u PD=2.08u
M$2791 VBP|VDD VIN|VOUT$4 VIN|VOUT$90 VBP|VDD sg13_lv_pmos L=0.13u W=0.45u
+ AS=0.2115p AD=0.2115p PS=2.82u PD=2.82u
M$2794 VBP|VDD VIN|VOUT$90 VIN|VOUT$92 VBP|VDD sg13_lv_pmos L=0.13u W=0.9u
+ AS=0.423p AD=0.423p PS=5.64u PD=5.64u
M$2800 VBP|VDD VIN|VOUT$92 VIN|VOUT$118 VBP|VDD sg13_lv_pmos L=0.13u W=1.8u
+ AS=0.846p AD=0.846p PS=11.28u PD=11.28u
M$2812 VBP|VDD VIN|VOUT$93 CLK|CLKIN|VIN|VINPI|VOUT|VSN|VSP VBP|VDD
+ sg13_lv_pmos L=0.13u W=7.2u AS=3.384p AD=3.384p PS=45.12u PD=45.12u
M$2836 VBP|VDD VIN|VOUT$91 PH0|VIN|VINA|VINI|VOUT VBP|VDD sg13_lv_pmos L=0.13u
+ W=14.4u AS=6.768p AD=6.768p PS=90.24u PD=90.24u
M$2860 VBP|VDD PH0|VIN|VOUT PH1|VIN|VOUT VBP|VDD sg13_lv_pmos L=0.13u W=0.6u
+ AS=0.312p AD=0.312p PS=4.16u PD=4.16u
M$2864 VBP|VDD PH1|VIN|VOUT PH0|VIN|VOUT VBP|VDD sg13_lv_pmos L=0.13u W=0.3u
+ AS=0.156p AD=0.156p PS=2.08u PD=2.08u
M$2890 VBP|VDD PH270|VIN|VINB|VIND|VINQB|VOUT VIN|VOUT$117 VBP|VDD sg13_lv_pmos
+ L=0.13u W=0.45u AS=0.2115p AD=0.2115p PS=2.82u PD=2.82u
M$2893 VIN|VOUT$117 VOUT|VSN|VSP$41 VIN|VOUT$110 VBP|VDD sg13_lv_pmos L=0.13u
+ W=0.3u AS=0.156p AD=0.156p PS=2.08u PD=2.08u
M$2895 VIN|VOUT$117 VOUT|VSN|VSP$40 VIN|VOUT$110 VBP|VDD sg13_lv_pmos L=0.13u
+ W=0.6u AS=0.312p AD=0.312p PS=4.16u PD=4.16u
M$2897 VBP|VDD \$3573 \$3573 VBP|VDD sg13_lv_pmos L=0.13u W=0.15u AS=0.1005p
+ AD=0.1005p PS=1.34u PD=1.34u
M$2900 VIN|VOUT$110 VOUT|VSN|VSP$39 VIN|VINB|VOUT$4 VBP|VDD sg13_lv_pmos
+ L=0.13u W=0.3u AS=0.156p AD=0.156p PS=2.08u PD=2.08u
M$2902 VBP|VDD VIN|VOUT$118 VIN|VOUT$93 VBP|VDD sg13_lv_pmos L=0.13u W=3.6u
+ AS=1.692p AD=1.692p PS=22.56u PD=22.56u
M$2950 VBP|VDD CLK|CLKIN|VIN|VINPI|VOUT|VSN|VSP VOUT|VSN|VSP$36 VBP|VDD
+ sg13_lv_pmos L=0.13u W=0.15u AS=0.1005p AD=0.1005p PS=1.34u PD=1.34u
M$2951 VBP|VDD VIN|VOUT$107 VIN|VOUT$111 VBP|VDD sg13_lv_pmos L=0.13u W=0.15u
+ AS=0.1005p AD=0.1005p PS=1.34u PD=1.34u
M$2952 VIN|VOUT$111 VOUT|VSN|VSP$36 VIN|VOUT$95 VBP|VDD sg13_lv_pmos L=0.13u
+ W=0.3u AS=0.156p AD=0.156p PS=2.08u PD=2.08u
M$2954 VBP|VDD VIN|VOUT$95 VIN|VOUT$107 VBP|VDD sg13_lv_pmos L=0.13u W=0.15u
+ AS=0.1005p AD=0.1005p PS=1.34u PD=1.34u
M$2955 VBP|VDD CLK|CLKIN|CLKOUT|Q|VIN|VOUT|VSN|VSP VIN|VOUT$112 VBP|VDD
+ sg13_lv_pmos L=0.13u W=0.15u AS=0.1005p AD=0.1005p PS=1.34u PD=1.34u
M$2956 VIN|VOUT$112 CLK|CLKIN|VIN|VINPI|VOUT|VSN|VSP VIN|VOUT$97 VBP|VDD
+ sg13_lv_pmos L=0.13u W=0.3u AS=0.156p AD=0.156p PS=2.08u PD=2.08u
M$2958 VBP|VDD VIN|VOUT$97 CLK|CLKIN|CLKOUT|Q|VIN|VOUT|VSN|VSP VBP|VDD
+ sg13_lv_pmos L=0.13u W=0.15u AS=0.1005p AD=0.1005p PS=1.34u PD=1.34u
M$2959 VBP|VDD CLK|CLKIN|CLKOUT|Q|VIN|VOUT|VSN|VSP VOUT|VSN|VSP$37 VBP|VDD
+ sg13_lv_pmos L=0.13u W=0.15u AS=0.1005p AD=0.1005p PS=1.34u PD=1.34u
M$2960 VBP|VDD VIN|VOUT$108 VIN|VOUT$113 VBP|VDD sg13_lv_pmos L=0.13u W=0.15u
+ AS=0.1005p AD=0.1005p PS=1.34u PD=1.34u
M$2961 VIN|VOUT$113 VOUT|VSN|VSP$37 VIN|VOUT$99 VBP|VDD sg13_lv_pmos L=0.13u
+ W=0.3u AS=0.156p AD=0.156p PS=2.08u PD=2.08u
M$2963 VBP|VDD VIN|VOUT$99 VIN|VOUT$108 VBP|VDD sg13_lv_pmos L=0.13u W=0.15u
+ AS=0.1005p AD=0.1005p PS=1.34u PD=1.34u
M$2964 VBP|VDD CLK|CLKIN|CLKOUT|Q|VIN|VOUT|VSN|VSP$1 VIN|VOUT$114 VBP|VDD
+ sg13_lv_pmos L=0.13u W=0.15u AS=0.1005p AD=0.1005p PS=1.34u PD=1.34u
M$2965 VIN|VOUT$114 CLK|CLKIN|CLKOUT|Q|VIN|VOUT|VSN|VSP VIN|VOUT$101 VBP|VDD
+ sg13_lv_pmos L=0.13u W=0.3u AS=0.156p AD=0.156p PS=2.08u PD=2.08u
M$2967 VBP|VDD VIN|VOUT$101 CLK|CLKIN|CLKOUT|Q|VIN|VOUT|VSN|VSP$1 VBP|VDD
+ sg13_lv_pmos L=0.13u W=0.15u AS=0.1005p AD=0.1005p PS=1.34u PD=1.34u
M$2968 VBP|VDD CLK|CLKIN|CLKOUT|Q|VIN|VOUT|VSN|VSP$1 VOUT|VSN|VSP$38 VBP|VDD
+ sg13_lv_pmos L=0.13u W=0.15u AS=0.1005p AD=0.1005p PS=1.34u PD=1.34u
M$2969 VBP|VDD VIN|VOUT$109 VIN|VOUT$115 VBP|VDD sg13_lv_pmos L=0.13u W=0.15u
+ AS=0.1005p AD=0.1005p PS=1.34u PD=1.34u
M$2970 VIN|VOUT$115 VOUT|VSN|VSP$38 VIN|VOUT$103 VBP|VDD sg13_lv_pmos L=0.13u
+ W=0.3u AS=0.156p AD=0.156p PS=2.08u PD=2.08u
M$2972 VBP|VDD VIN|VOUT$103 VIN|VOUT$109 VBP|VDD sg13_lv_pmos L=0.13u W=0.15u
+ AS=0.1005p AD=0.1005p PS=1.34u PD=1.34u
M$2973 VBP|VDD CLKOUT|Q|VIN|VOUT VIN|VOUT$116 VBP|VDD sg13_lv_pmos L=0.13u
+ W=0.15u AS=0.1005p AD=0.1005p PS=1.34u PD=1.34u
M$2974 VIN|VOUT$116 CLK|CLKIN|CLKOUT|Q|VIN|VOUT|VSN|VSP$1 VIN|VOUT$105 VBP|VDD
+ sg13_lv_pmos L=0.13u W=0.3u AS=0.156p AD=0.156p PS=2.08u PD=2.08u
M$2976 VBP|VDD VIN|VOUT$105 CLKOUT|Q|VIN|VOUT VBP|VDD sg13_lv_pmos L=0.13u
+ W=0.15u AS=0.1005p AD=0.1005p PS=1.34u PD=1.34u
M$2977 VBP|VDD CLKOUT|Q|VIN|VOUT VIN|VOUT$119 VBP|VDD sg13_lv_pmos L=0.13u
+ W=0.9u AS=0.423p AD=0.423p PS=5.64u PD=5.64u
M$2983 VBP|VDD VIN|VOUT$119 VIN|VOUT$129 VBP|VDD sg13_lv_pmos L=0.13u W=1.8u
+ AS=0.846p AD=0.846p PS=11.28u PD=11.28u
M$2995 VBP|VDD VIN|VOUT$120 VOUT VBP|VDD sg13_lv_pmos L=0.13u W=7.2u AS=3.384p
+ AD=3.384p PS=45.12u PD=45.12u
M$3019 VBP|VDD PH0|PH1|V0|VIN|VOUT|VOUTDN VIN|VOUT$125 VBP|VDD sg13_lv_pmos
+ L=0.13u W=0.9u AS=0.423p AD=0.423p PS=5.64u PD=5.64u
M$3025 VBP|VDD VIN|VOUT$125 PH0|VIN|VOUT VBP|VDD sg13_lv_pmos L=0.13u W=0.9u
+ AS=0.423p AD=0.423p PS=5.64u PD=5.64u
M$3031 VBP|VDD PH0|VIN|VOUT VIN|VOUT$126 VBP|VDD sg13_lv_pmos L=0.13u W=0.9u
+ AS=0.423p AD=0.423p PS=5.64u PD=5.64u
M$3037 VBP|VDD VIN|VOUT$126 VIN|VOUT$134 VBP|VDD sg13_lv_pmos L=0.13u W=1.8u
+ AS=0.846p AD=0.846p PS=11.28u PD=11.28u
M$3049 VBP|VDD VIN|VOUT$127 VIN|VOUT$128 VBP|VDD sg13_lv_pmos L=0.13u W=7.2u
+ AS=3.384p AD=3.384p PS=45.12u PD=45.12u
M$3073 VBP|VDD VIN|VOUT$128 VIN|VOUT$91 VBP|VDD sg13_lv_pmos L=0.13u W=7.2u
+ AS=3.384p AD=3.384p PS=45.12u PD=45.12u
M$3121 VBP|VDD SQ[1]|VIN|VOUT|VS|VSN|VSP|VS[1] VOUT|VSN|VSP$41 VBP|VDD
+ sg13_lv_pmos L=0.13u W=0.15u AS=0.1005p AD=0.1005p PS=1.34u PD=1.34u
M$3122 VBP|VDD PH90|VIN|VINA|VINC|VINQ|VOUT VIN|VOUT$121 VBP|VDD sg13_lv_pmos
+ L=0.13u W=0.45u AS=0.2115p AD=0.2115p PS=2.82u PD=2.82u
M$3125 VIN|VOUT$121 SQ[1]|VIN|VOUT|VS|VSN|VSP|VS[1] VIN|VOUT$122 VBP|VDD
+ sg13_lv_pmos L=0.13u W=0.6u AS=0.312p AD=0.312p PS=4.16u PD=4.16u
M$3129 VBP|VDD \$3755 VOUT|VSN|VSP$40 VBP|VDD sg13_lv_pmos L=0.13u W=0.15u
+ AS=0.1005p AD=0.1005p PS=1.34u PD=1.34u
M$3130 VIN|VOUT$121 VOUT|VSN|VSP$40 VIN|VOUT$122 VBP|VDD sg13_lv_pmos L=0.13u
+ W=0.3u AS=0.156p AD=0.156p PS=2.08u PD=2.08u
M$3132 VIN|VOUT$122 VOUT|VSN|VSP$39 VIN|VINB|VOUT$4 VBP|VDD sg13_lv_pmos
+ L=0.13u W=0.3u AS=0.156p AD=0.156p PS=2.08u PD=2.08u
M$3134 VBP|VDD VIN|VINB|VOUT$4 VIN|VOUT$123 VBP|VDD sg13_lv_pmos L=0.13u
+ W=0.45u AS=0.2115p AD=0.2115p PS=2.82u PD=2.82u
M$3137 VIN|VOUT$123 VOUT|VSN|VSP$44 VIN|VOUT$124 VBP|VDD sg13_lv_pmos L=0.13u
+ W=0.3u AS=0.156p AD=0.156p PS=2.08u PD=2.08u
M$3139 VIN|VOUT$123 VOUT|VSN|VSP$43 VIN|VOUT$124 VBP|VDD sg13_lv_pmos L=0.13u
+ W=0.6u AS=0.312p AD=0.312p PS=4.16u PD=4.16u
M$3141 VBP|VDD \$3833 \$3833 VBP|VDD sg13_lv_pmos L=0.13u W=0.15u AS=0.1005p
+ AD=0.1005p PS=1.34u PD=1.34u
M$3144 VIN|VOUT$124 VOUT|VSN|VSP$42 VIN|VOUT$4 VBP|VDD sg13_lv_pmos L=0.13u
+ W=0.3u AS=0.156p AD=0.156p PS=2.08u PD=2.08u
M$3146 VBP|VDD VIN|VOUT$129 VIN|VOUT$120 VBP|VDD sg13_lv_pmos L=0.13u W=3.6u
+ AS=1.692p AD=1.692p PS=22.56u PD=22.56u
M$3194 VBP|VDD VIN|VOUT$134 VIN|VOUT$127 VBP|VDD sg13_lv_pmos L=0.13u W=3.6u
+ AS=1.692p AD=1.692p PS=22.56u PD=22.56u
M$3197 VBP|VDD PH0|PH1|PH5|V5|VIN|VOUT|VOUTDP VIN|VOUT$135 VBP|VDD sg13_lv_pmos
+ L=0.13u W=0.9u AS=0.423p AD=0.423p PS=5.64u PD=5.64u
M$3272 VBP|VDD VIN|VOUT$138 PH270|VIN|VINB|VIND|VINQB|VOUT VBP|VDD sg13_lv_pmos
+ L=0.13u W=14.4u AS=6.768p AD=6.768p PS=90.24u PD=90.24u
M$3320 VBP|VDD SQ[0]|VIN|VOUT|VS|VSN|VSP|VS[0] VOUT|VSN|VSP$46 VBP|VDD
+ sg13_lv_pmos L=0.13u W=0.15u AS=0.1005p AD=0.1005p PS=1.34u PD=1.34u
M$3321 VBP|VDD PH180|VIN|VINB|VINIB|VOUT VIN|VOUT$132 VBP|VDD sg13_lv_pmos
+ L=0.13u W=0.45u AS=0.2115p AD=0.2115p PS=2.82u PD=2.82u
M$3324 VBP|VDD PH0|VIN|VINA|VINI|VOUT VIN|VOUT$136 VBP|VDD sg13_lv_pmos L=0.13u
+ W=0.45u AS=0.2115p AD=0.2115p PS=2.82u PD=2.82u
M$3327 VIN|VOUT$132 VOUT|VSN|VSP$46 VIN|VOUT$130 VBP|VDD sg13_lv_pmos L=0.13u
+ W=0.3u AS=0.156p AD=0.156p PS=2.08u PD=2.08u
M$3329 VIN|VOUT$136 SQ[0]|VIN|VOUT|VS|VSN|VSP|VS[0] VIN|VOUT$137 VBP|VDD
+ sg13_lv_pmos L=0.13u W=0.6u AS=0.312p AD=0.312p PS=4.16u PD=4.16u
M$3333 VIN|VOUT$132 VOUT|VSN|VSP$47 VIN|VOUT$130 VBP|VDD sg13_lv_pmos L=0.13u
+ W=0.6u AS=0.312p AD=0.312p PS=4.16u PD=4.16u
M$3335 VBP|VDD \$4018 VOUT|VSN|VSP$47 VBP|VDD sg13_lv_pmos L=0.13u W=0.15u
+ AS=0.1005p AD=0.1005p PS=1.34u PD=1.34u
M$3336 VBP|VDD \$3964 \$3964 VBP|VDD sg13_lv_pmos L=0.13u W=0.15u AS=0.1005p
+ AD=0.1005p PS=1.34u PD=1.34u
M$3337 VIN|VOUT$136 VOUT|VSN|VSP$47 VIN|VOUT$137 VBP|VDD sg13_lv_pmos L=0.13u
+ W=0.3u AS=0.156p AD=0.156p PS=2.08u PD=2.08u
M$3341 VIN|VOUT$137 VOUT|VSN|VSP$45 VIN|VINA|VOUT$4 VBP|VDD sg13_lv_pmos
+ L=0.13u W=0.3u AS=0.156p AD=0.156p PS=2.08u PD=2.08u
M$3343 VIN|VOUT$130 VOUT|VSN|VSP$45 VIN|VINA|VOUT$4 VBP|VDD sg13_lv_pmos
+ L=0.13u W=0.3u AS=0.156p AD=0.156p PS=2.08u PD=2.08u
M$3345 VBP|VDD STQ[3]|VIN|VOUT|VS|VSN|VSP|VST|VST[3] VOUT|VSN|VSP$44 VBP|VDD
+ sg13_lv_pmos L=0.13u W=0.15u AS=0.1005p AD=0.1005p PS=1.34u PD=1.34u
M$3346 VBP|VDD VIN|VINA|VOUT$4 VIN|VOUT$133 VBP|VDD sg13_lv_pmos L=0.13u
+ W=0.45u AS=0.2115p AD=0.2115p PS=2.82u PD=2.82u
M$3349 VIN|VOUT$133 STQ[3]|VIN|VOUT|VS|VSN|VSP|VST|VST[3] VIN|VOUT$131 VBP|VDD
+ sg13_lv_pmos L=0.13u W=0.6u AS=0.312p AD=0.312p PS=4.16u PD=4.16u
M$3353 VBP|VDD \$3907 VOUT|VSN|VSP$43 VBP|VDD sg13_lv_pmos L=0.13u W=0.15u
+ AS=0.1005p AD=0.1005p PS=1.34u PD=1.34u
M$3354 VIN|VOUT$133 VOUT|VSN|VSP$43 VIN|VOUT$131 VBP|VDD sg13_lv_pmos L=0.13u
+ W=0.3u AS=0.156p AD=0.156p PS=2.08u PD=2.08u
M$3356 VIN|VOUT$131 VOUT|VSN|VSP$42 VIN|VOUT$4 VBP|VDD sg13_lv_pmos L=0.13u
+ W=0.3u AS=0.156p AD=0.156p PS=2.08u PD=2.08u
M$3358 SQ[1]|VIN|VOUT|VS|VSN|VSP|VS[1] VIN|VOUT$139 VBP|VDD VBP|VDD
+ sg13_lv_pmos L=0.13u W=0.15u AS=0.1005p AD=0.1005p PS=1.34u PD=1.34u
M$3359 VIN|VOUT$139 A|S[4]|VIN|VOUT|VS[4] VBP|VDD VBP|VDD sg13_lv_pmos L=0.13u
+ W=0.15u AS=0.1005p AD=0.1005p PS=1.34u PD=1.34u
M$3360 VBP|VDD VIN|VOUT$135 PH1|PHOUT|VIN|VOUT VBP|VDD sg13_lv_pmos L=0.13u
+ W=0.9u AS=0.423p AD=0.423p PS=5.64u PD=5.64u
M$3390 VBP|VDD PH270|VIN|VINB|VIND|VINQB|VOUT VIN|VOUT$140 VBP|VDD sg13_lv_pmos
+ L=0.13u W=0.45u AS=0.2115p AD=0.2115p PS=2.82u PD=2.82u
M$3393 VIN|VOUT$140 VOUT|VSN|VSP$49 VIN|VOUT$141 VBP|VDD sg13_lv_pmos L=0.13u
+ W=0.3u AS=0.156p AD=0.156p PS=2.08u PD=2.08u
M$3395 VIN|VOUT$140 VOUT|VSN|VSP$50 VIN|VOUT$141 VBP|VDD sg13_lv_pmos L=0.13u
+ W=0.6u AS=0.312p AD=0.312p PS=4.16u PD=4.16u
M$3397 VBP|VDD \$4086 \$4086 VBP|VDD sg13_lv_pmos L=0.13u W=0.15u AS=0.1005p
+ AD=0.1005p PS=1.34u PD=1.34u
M$3400 VIN|VOUT$141 VOUT|VSN|VSP$48 VIN|VINB|VOUT$5 VBP|VDD sg13_lv_pmos
+ L=0.13u W=0.3u AS=0.156p AD=0.156p PS=2.08u PD=2.08u
M$3402 VOUT|VSN|VSS B|S[3]|VDD|VIN|VSP|VS[3] VBP|VDD VBP|VDD sg13_lv_pmos
+ L=0.13u W=0.15u AS=0.1005p AD=0.1005p PS=1.34u PD=1.34u
M$3403 SQ[0]|VIN|VOUT|VS|VSN|VSP|VS[0] B|S[3]|VDD|VIN|VSP|VS[3]
+ A|S[4]|VIN|VOUT|VS[4] VBP|VDD sg13_lv_pmos L=0.13u W=0.3u AS=0.156p AD=0.156p
+ PS=2.08u PD=2.08u
M$3405 SQ[0]|VIN|VOUT|VS|VSN|VSP|VS[0] A|S[4]|VIN|VOUT|VS[4]
+ B|S[3]|VDD|VIN|VSP|VS[3] VBP|VDD sg13_lv_pmos L=0.13u W=0.15u AS=0.1005p
+ AD=0.1005p PS=1.34u PD=1.34u
M$3406 VBP|VDD PH0|PH1|PH4|V4|VIN|VOUT|VOUTDP VIN|VOUT$135 VBP|VDD sg13_lv_pmos
+ L=0.13u W=0.9u AS=0.423p AD=0.423p PS=5.64u PD=5.64u
M$3412 VBP|VDD PH1|PHOUT|VIN|VOUT VIN|VOUT$146 VBP|VDD sg13_lv_pmos L=0.13u
+ W=0.9u AS=0.423p AD=0.423p PS=5.64u PD=5.64u
M$3418 VBP|VDD VIN|VOUT$146 VIN|VOUT$152 VBP|VDD sg13_lv_pmos L=0.13u W=1.8u
+ AS=0.846p AD=0.846p PS=11.28u PD=11.28u
M$3430 VBP|VDD VIN|VOUT$147 VIN|VOUT$148 VBP|VDD sg13_lv_pmos L=0.13u W=7.2u
+ AS=3.384p AD=3.384p PS=45.12u PD=45.12u
M$3454 VBP|VDD VIN|VOUT$148 VIN|VOUT$138 VBP|VDD sg13_lv_pmos L=0.13u W=7.2u
+ AS=3.384p AD=3.384p PS=45.12u PD=45.12u
M$3502 VBP|VDD SQ[1]|VIN|VOUT|VS|VSN|VSP|VS[1] VOUT|VSN|VSP$49 VBP|VDD
+ sg13_lv_pmos L=0.13u W=0.15u AS=0.1005p AD=0.1005p PS=1.34u PD=1.34u
M$3503 VBP|VDD PH90|VIN|VINA|VINC|VINQ|VOUT VIN|VOUT$144 VBP|VDD sg13_lv_pmos
+ L=0.13u W=0.45u AS=0.2115p AD=0.2115p PS=2.82u PD=2.82u
M$3506 VIN|VOUT$144 SQ[1]|VIN|VOUT|VS|VSN|VSP|VS[1] VIN|VOUT$142 VBP|VDD
+ sg13_lv_pmos L=0.13u W=0.6u AS=0.312p AD=0.312p PS=4.16u PD=4.16u
M$3510 VBP|VDD \$4140 VOUT|VSN|VSP$50 VBP|VDD sg13_lv_pmos L=0.13u W=0.15u
+ AS=0.1005p AD=0.1005p PS=1.34u PD=1.34u
M$3511 VIN|VOUT$144 VOUT|VSN|VSP$50 VIN|VOUT$142 VBP|VDD sg13_lv_pmos L=0.13u
+ W=0.3u AS=0.156p AD=0.156p PS=2.08u PD=2.08u
M$3513 VIN|VOUT$142 VOUT|VSN|VSP$48 VIN|VINB|VOUT$5 VBP|VDD sg13_lv_pmos
+ L=0.13u W=0.3u AS=0.156p AD=0.156p PS=2.08u PD=2.08u
M$3515 VBP|VDD VIN|VINB|VOUT$5 VIN|VOUT$145 VBP|VDD sg13_lv_pmos L=0.13u
+ W=0.45u AS=0.2115p AD=0.2115p PS=2.82u PD=2.82u
M$3518 VIN|VOUT$145 VOUT|VSN|VSP$52 VIN|VOUT$143 VBP|VDD sg13_lv_pmos L=0.13u
+ W=0.3u AS=0.156p AD=0.156p PS=2.08u PD=2.08u
M$3520 VIN|VOUT$145 VOUT|VSN|VSP$53 VIN|VOUT$143 VBP|VDD sg13_lv_pmos L=0.13u
+ W=0.6u AS=0.312p AD=0.312p PS=4.16u PD=4.16u
M$3522 VBP|VDD \$4165 \$4165 VBP|VDD sg13_lv_pmos L=0.13u W=0.15u AS=0.1005p
+ AD=0.1005p PS=1.34u PD=1.34u
M$3525 VIN|VOUT$143 VOUT|VSN|VSP$51 VIN|VOUT$4 VBP|VDD sg13_lv_pmos L=0.13u
+ W=0.3u AS=0.156p AD=0.156p PS=2.08u PD=2.08u
M$3527 SQ[2]|VIN|VOUT|VS|VSN|VSP|VST|VST[0] VIN|VOUT$151 VBP|VDD VBP|VDD
+ sg13_lv_pmos L=0.13u W=0.15u AS=0.1005p AD=0.1005p PS=1.34u PD=1.34u
M$3528 VIN|VOUT$151 B|S[3]|VDD|VIN|VSP|VS[3] VBP|VDD VBP|VDD sg13_lv_pmos
+ L=0.13u W=0.15u AS=0.1005p AD=0.1005p PS=1.34u PD=1.34u
M$3529 VBP|VDD VIN|VOUT$152 VIN|VOUT$147 VBP|VDD sg13_lv_pmos L=0.13u W=3.6u
+ AS=1.692p AD=1.692p PS=22.56u PD=22.56u
M$3625 VBP|VDD PH180|VIN|VINB|VINIB|VOUT VIN|VOUT$153 VBP|VDD sg13_lv_pmos
+ L=0.13u W=0.45u AS=0.2115p AD=0.2115p PS=2.82u PD=2.82u
M$3628 VIN|VOUT$153 VOUT|VSN|VSP$55 VIN|VOUT$149 VBP|VDD sg13_lv_pmos L=0.13u
+ W=0.3u AS=0.156p AD=0.156p PS=2.08u PD=2.08u
M$3630 VIN|VOUT$153 VOUT|VSN|VSP$56 VIN|VOUT$149 VBP|VDD sg13_lv_pmos L=0.13u
+ W=0.6u AS=0.312p AD=0.312p PS=4.16u PD=4.16u
M$3632 VBP|VDD \$4343 \$4343 VBP|VDD sg13_lv_pmos L=0.13u W=0.15u AS=0.1005p
+ AD=0.1005p PS=1.34u PD=1.34u
M$3635 VIN|VOUT$149 VOUT|VSN|VSP$54 VIN|VINA|VOUT$5 VBP|VDD sg13_lv_pmos
+ L=0.13u W=0.3u AS=0.156p AD=0.156p PS=2.08u PD=2.08u
M$3637 VBP|VDD STQ[2]|VIN|VOUT|VS|VSN|VSP|VST|VST[2] VOUT|VSN|VSP$52 VBP|VDD
+ sg13_lv_pmos L=0.13u W=0.15u AS=0.1005p AD=0.1005p PS=1.34u PD=1.34u
M$3638 VBP|VDD VIN|VINA|VOUT$5 VIN|VOUT$154 VBP|VDD sg13_lv_pmos L=0.13u
+ W=0.45u AS=0.2115p AD=0.2115p PS=2.82u PD=2.82u
M$3641 VIN|VOUT$154 STQ[2]|VIN|VOUT|VS|VSN|VSP|VST|VST[2] VIN|VOUT$150 VBP|VDD
+ sg13_lv_pmos L=0.13u W=0.6u AS=0.312p AD=0.312p PS=4.16u PD=4.16u
M$3645 VBP|VDD \$4275 VOUT|VSN|VSP$53 VBP|VDD sg13_lv_pmos L=0.13u W=0.15u
+ AS=0.1005p AD=0.1005p PS=1.34u PD=1.34u
M$3646 VIN|VOUT$154 VOUT|VSN|VSP$53 VIN|VOUT$150 VBP|VDD sg13_lv_pmos L=0.13u
+ W=0.3u AS=0.156p AD=0.156p PS=2.08u PD=2.08u
M$3648 VIN|VOUT$150 VOUT|VSN|VSP$51 VIN|VOUT$4 VBP|VDD sg13_lv_pmos L=0.13u
+ W=0.3u AS=0.156p AD=0.156p PS=2.08u PD=2.08u
M$3650 VOUT|VSN|VSS$1 B|OUT|ST[7]|VDD|VIN|VSP VBP|VDD VBP|VDD sg13_lv_pmos
+ L=0.13u W=0.15u AS=0.1005p AD=0.1005p PS=1.34u PD=1.34u
M$3651 STQ[7]|VIN|VOUT|VS|VSN|VSP|VST|VST[7] B|OUT|ST[7]|VDD|VIN|VSP A|VIN|VOUT
+ VBP|VDD sg13_lv_pmos L=0.13u W=0.3u AS=0.156p AD=0.156p PS=2.08u PD=2.08u
M$3653 STQ[7]|VIN|VOUT|VS|VSN|VSP|VST|VST[7] A|VIN|VOUT B|OUT|ST[7]|VDD|VIN|VSP
+ VBP|VDD sg13_lv_pmos L=0.13u W=0.15u AS=0.1005p AD=0.1005p PS=1.34u PD=1.34u
M$3654 A|VIN|VOUT VIN|VOUT$156 VBP|VDD VBP|VDD sg13_lv_pmos L=0.13u W=0.15u
+ AS=0.1005p AD=0.1005p PS=1.34u PD=1.34u
M$3655 VIN|VOUT$156 VIN|VOUT$157 VBP|VDD VBP|VDD sg13_lv_pmos L=0.13u W=0.15u
+ AS=0.1005p AD=0.1005p PS=1.34u PD=1.34u
M$3656 VBP|VDD PH1|PH2|V2|VIN|VOUT|VOUTDN VIN|VOUT$158 VBP|VDD sg13_lv_pmos
+ L=0.13u W=0.9u AS=0.423p AD=0.423p PS=5.64u PD=5.64u
M$3662 VBP|VDD VIN|VOUT$160 PH90|VIN|VINA|VINC|VINQ|VOUT VBP|VDD sg13_lv_pmos
+ L=0.13u W=14.4u AS=6.768p AD=6.768p PS=90.24u PD=90.24u
M$3686 VBP|VDD SQ[0]|VIN|VOUT|VS|VSN|VSP|VS[0] VOUT|VSN|VSP$55 VBP|VDD
+ sg13_lv_pmos L=0.13u W=0.15u AS=0.1005p AD=0.1005p PS=1.34u PD=1.34u
M$3687 VBP|VDD PH0|VIN|VINA|VINI|VOUT VIN|VOUT$159 VBP|VDD sg13_lv_pmos L=0.13u
+ W=0.45u AS=0.2115p AD=0.2115p PS=2.82u PD=2.82u
M$3690 VIN|VOUT$159 SQ[0]|VIN|VOUT|VS|VSN|VSP|VS[0] VIN|VOUT$155 VBP|VDD
+ sg13_lv_pmos L=0.13u W=0.6u AS=0.312p AD=0.312p PS=4.16u PD=4.16u
M$3694 VBP|VDD \$4399 VOUT|VSN|VSP$56 VBP|VDD sg13_lv_pmos L=0.13u W=0.15u
+ AS=0.1005p AD=0.1005p PS=1.34u PD=1.34u
M$3695 VIN|VOUT$159 VOUT|VSN|VSP$56 VIN|VOUT$155 VBP|VDD sg13_lv_pmos L=0.13u
+ W=0.3u AS=0.156p AD=0.156p PS=2.08u PD=2.08u
M$3697 VIN|VOUT$155 VOUT|VSN|VSP$54 VIN|VINA|VOUT$5 VBP|VDD sg13_lv_pmos
+ L=0.13u W=0.3u AS=0.156p AD=0.156p PS=2.08u PD=2.08u
M$3699 VOUT|VSN|VSS$2 B|OUT|ST[6]|VDD|VIN|VSP VBP|VDD VBP|VDD sg13_lv_pmos
+ L=0.13u W=0.15u AS=0.1005p AD=0.1005p PS=1.34u PD=1.34u
M$3700 STQ[6]|VIN|VOUT|VS|VSN|VSP|VST|VST[6] B|OUT|ST[6]|VDD|VIN|VSP
+ A|VIN|VOUT$1 VBP|VDD sg13_lv_pmos L=0.13u W=0.3u AS=0.156p AD=0.156p PS=2.08u
+ PD=2.08u
M$3702 STQ[6]|VIN|VOUT|VS|VSN|VSP|VST|VST[6] A|VIN|VOUT$1
+ B|OUT|ST[6]|VDD|VIN|VSP VBP|VDD sg13_lv_pmos L=0.13u W=0.15u AS=0.1005p
+ AD=0.1005p PS=1.34u PD=1.34u
M$3703 A|VIN|VOUT$1 VIN|VOUT$161 VBP|VDD VBP|VDD sg13_lv_pmos L=0.13u W=0.15u
+ AS=0.1005p AD=0.1005p PS=1.34u PD=1.34u
M$3704 VIN|VOUT$161 VIN|VOUT$157 VBP|VDD VBP|VDD sg13_lv_pmos L=0.13u W=0.15u
+ AS=0.1005p AD=0.1005p PS=1.34u PD=1.34u
M$3705 VBP|VDD VIN|VOUT$158 PH0|PHOUT|VIN|VOUT VBP|VDD sg13_lv_pmos L=0.13u
+ W=0.9u AS=0.423p AD=0.423p PS=5.64u PD=5.64u
M$3711 VBP|VDD PH0|PHOUT|VIN|VOUT PH1|PHOUT|VIN|VOUT VBP|VDD sg13_lv_pmos
+ L=0.13u W=0.6u AS=0.312p AD=0.312p PS=4.16u PD=4.16u
M$3715 VBP|VDD PH1|PHOUT|VIN|VOUT PH0|PHOUT|VIN|VOUT VBP|VDD sg13_lv_pmos
+ L=0.13u W=0.3u AS=0.156p AD=0.156p PS=2.08u PD=2.08u
M$3741 VBP|VDD PH270|VIN|VINB|VIND|VINQB|VOUT VIN|VOUT$163 VBP|VDD sg13_lv_pmos
+ L=0.13u W=0.45u AS=0.2115p AD=0.2115p PS=2.82u PD=2.82u
M$3744 VIN|VOUT$163 VOUT|VSN|VSP$59 VIN|VOUT$162 VBP|VDD sg13_lv_pmos L=0.13u
+ W=0.3u AS=0.156p AD=0.156p PS=2.08u PD=2.08u
M$3746 VIN|VOUT$163 VOUT|VSN|VSP$58 VIN|VOUT$162 VBP|VDD sg13_lv_pmos L=0.13u
+ W=0.6u AS=0.312p AD=0.312p PS=4.16u PD=4.16u
M$3748 VBP|VDD \$4594 \$4594 VBP|VDD sg13_lv_pmos L=0.13u W=0.15u AS=0.1005p
+ AD=0.1005p PS=1.34u PD=1.34u
M$3751 VIN|VOUT$162 VOUT|VSN|VSP$57 VIN|VINB|VOUT$6 VBP|VDD sg13_lv_pmos
+ L=0.13u W=0.3u AS=0.156p AD=0.156p PS=2.08u PD=2.08u
M$3753 VBP|VDD VIN|VOUT$164 VIN|VOUT$157 VBP|VDD sg13_lv_pmos L=0.13u W=1.2u
+ AS=0.624p AD=0.624p PS=8.32u PD=8.32u
M$3761 VBP|VDD VIN|VOUT$165 VIN|VOUT$164 VBP|VDD sg13_lv_pmos L=0.13u W=0.6u
+ AS=0.312p AD=0.312p PS=4.16u PD=4.16u
M$3765 VBP|VDD VIN|VOUT$166 VIN|VOUT$165 VBP|VDD sg13_lv_pmos L=0.13u W=0.3u
+ AS=0.156p AD=0.156p PS=2.08u PD=2.08u
M$3767 VIN|VOUT$166 B|S[3]|VDD|VIN|VSP|VS[3] VBP|VDD VBP|VDD sg13_lv_pmos
+ L=0.13u W=0.15u AS=0.1005p AD=0.1005p PS=1.34u PD=1.34u
M$3768 VOUT|VSN|VSS$3 B|OUT|ST[5]|VDD|VIN|VSP VBP|VDD VBP|VDD sg13_lv_pmos
+ L=0.13u W=0.15u AS=0.1005p AD=0.1005p PS=1.34u PD=1.34u
M$3769 STQ[5]|VIN|VOUT|VS|VSN|VSP|VST|VST[5] B|OUT|ST[5]|VDD|VIN|VSP
+ A|VIN|VOUT$2 VBP|VDD sg13_lv_pmos L=0.13u W=0.3u AS=0.156p AD=0.156p PS=2.08u
+ PD=2.08u
M$3771 STQ[5]|VIN|VOUT|VS|VSN|VSP|VST|VST[5] A|VIN|VOUT$2
+ B|OUT|ST[5]|VDD|VIN|VSP VBP|VDD sg13_lv_pmos L=0.13u W=0.15u AS=0.1005p
+ AD=0.1005p PS=1.34u PD=1.34u
M$3772 A|VIN|VOUT$2 VIN|VOUT$167 VBP|VDD VBP|VDD sg13_lv_pmos L=0.13u W=0.15u
+ AS=0.1005p AD=0.1005p PS=1.34u PD=1.34u
M$3773 VIN|VOUT$167 VIN|VOUT$157 VBP|VDD VBP|VDD sg13_lv_pmos L=0.13u W=0.15u
+ AS=0.1005p AD=0.1005p PS=1.34u PD=1.34u
M$3774 VBP|VDD PH0|PH1|V1|VIN|VOUT|VOUTDN VIN|VOUT$158 VBP|VDD sg13_lv_pmos
+ L=0.13u W=0.9u AS=0.423p AD=0.423p PS=5.64u PD=5.64u
M$3780 VBP|VDD PH0|PHOUT|VIN|VOUT VIN|VOUT$172 VBP|VDD sg13_lv_pmos L=0.13u
+ W=0.9u AS=0.423p AD=0.423p PS=5.64u PD=5.64u
M$3786 VBP|VDD VIN|VOUT$172 VIN|VOUT$180 VBP|VDD sg13_lv_pmos L=0.13u W=1.8u
+ AS=0.846p AD=0.846p PS=11.28u PD=11.28u
M$3798 VBP|VDD VIN|VOUT$173 VIN|VOUT$174 VBP|VDD sg13_lv_pmos L=0.13u W=7.2u
+ AS=3.384p AD=3.384p PS=45.12u PD=45.12u
M$3822 VBP|VDD VIN|VOUT$174 VIN|VOUT$160 VBP|VDD sg13_lv_pmos L=0.13u W=7.2u
+ AS=3.384p AD=3.384p PS=45.12u PD=45.12u
M$3870 VBP|VDD SQ[1]|VIN|VOUT|VS|VSN|VSP|VS[1] VOUT|VSN|VSP$59 VBP|VDD
+ sg13_lv_pmos L=0.13u W=0.15u AS=0.1005p AD=0.1005p PS=1.34u PD=1.34u
M$3871 VBP|VDD PH90|VIN|VINA|VINC|VINQ|VOUT VIN|VOUT$168 VBP|VDD sg13_lv_pmos
+ L=0.13u W=0.45u AS=0.2115p AD=0.2115p PS=2.82u PD=2.82u
M$3874 VIN|VOUT$168 SQ[1]|VIN|VOUT|VS|VSN|VSP|VS[1] VIN|VOUT$169 VBP|VDD
+ sg13_lv_pmos L=0.13u W=0.6u AS=0.312p AD=0.312p PS=4.16u PD=4.16u
M$3878 VBP|VDD \$4856 VOUT|VSN|VSP$58 VBP|VDD sg13_lv_pmos L=0.13u W=0.15u
+ AS=0.1005p AD=0.1005p PS=1.34u PD=1.34u
M$3879 VIN|VOUT$168 VOUT|VSN|VSP$58 VIN|VOUT$169 VBP|VDD sg13_lv_pmos L=0.13u
+ W=0.3u AS=0.156p AD=0.156p PS=2.08u PD=2.08u
M$3881 VIN|VOUT$169 VOUT|VSN|VSP$57 VIN|VINB|VOUT$6 VBP|VDD sg13_lv_pmos
+ L=0.13u W=0.3u AS=0.156p AD=0.156p PS=2.08u PD=2.08u
M$3883 VBP|VDD VIN|VINB|VOUT$6 VIN|VOUT$170 VBP|VDD sg13_lv_pmos L=0.13u
+ W=0.45u AS=0.2115p AD=0.2115p PS=2.82u PD=2.82u
M$3886 VIN|VOUT$170 VOUT|VSN|VSP$61 VIN|VOUT$171 VBP|VDD sg13_lv_pmos L=0.13u
+ W=0.3u AS=0.156p AD=0.156p PS=2.08u PD=2.08u
M$3888 VIN|VOUT$170 VOUT|VSN|VSP$62 VIN|VOUT$171 VBP|VDD sg13_lv_pmos L=0.13u
+ W=0.6u AS=0.312p AD=0.312p PS=4.16u PD=4.16u
M$3890 VBP|VDD \$4880 \$4880 VBP|VDD sg13_lv_pmos L=0.13u W=0.15u AS=0.1005p
+ AD=0.1005p PS=1.34u PD=1.34u
M$3893 VIN|VOUT$171 VOUT|VSN|VSP$60 VIN|VOUT$4 VBP|VDD sg13_lv_pmos L=0.13u
+ W=0.3u AS=0.156p AD=0.156p PS=2.08u PD=2.08u
M$3895 VOUT|VSN|VSS$4 B|ST[4]|VDD|VIN|VOUT|VSP VBP|VDD VBP|VDD sg13_lv_pmos
+ L=0.13u W=0.15u AS=0.1005p AD=0.1005p PS=1.34u PD=1.34u
M$3896 STQ[4]|VIN|VOUT|VS|VSN|VSP|VST|VST[4] B|ST[4]|VDD|VIN|VOUT|VSP
+ A|VIN|VOUT$3 VBP|VDD sg13_lv_pmos L=0.13u W=0.3u AS=0.156p AD=0.156p PS=2.08u
+ PD=2.08u
M$3898 STQ[4]|VIN|VOUT|VS|VSN|VSP|VST|VST[4] A|VIN|VOUT$3
+ B|ST[4]|VDD|VIN|VOUT|VSP VBP|VDD sg13_lv_pmos L=0.13u W=0.15u AS=0.1005p
+ AD=0.1005p PS=1.34u PD=1.34u
M$3899 A|VIN|VOUT$3 VIN|VOUT$175 VBP|VDD VBP|VDD sg13_lv_pmos L=0.13u W=0.15u
+ AS=0.1005p AD=0.1005p PS=1.34u PD=1.34u
M$3900 VIN|VOUT$175 VIN|VOUT$157 VBP|VDD VBP|VDD sg13_lv_pmos L=0.13u W=0.15u
+ AS=0.1005p AD=0.1005p PS=1.34u PD=1.34u
M$3901 VBP|VDD VIN|VOUT$180 VIN|VOUT$173 VBP|VDD sg13_lv_pmos L=0.13u W=3.6u
+ AS=1.692p AD=1.692p PS=22.56u PD=22.56u
M$3997 VBP|VDD SQ[0]|VIN|VOUT|VS|VSN|VSP|VS[0] VOUT|VSN|VSP$65 VBP|VDD
+ sg13_lv_pmos L=0.13u W=0.15u AS=0.1005p AD=0.1005p PS=1.34u PD=1.34u
M$3998 VBP|VDD PH0|VIN|VINA|VINI|VOUT VIN|VOUT$183 VBP|VDD sg13_lv_pmos L=0.13u
+ W=0.45u AS=0.2115p AD=0.2115p PS=2.82u PD=2.82u
M$4001 VBP|VDD PH180|VIN|VINB|VINIB|VOUT VIN|VOUT$178 VBP|VDD sg13_lv_pmos
+ L=0.13u W=0.45u AS=0.2115p AD=0.2115p PS=2.82u PD=2.82u
M$4004 VIN|VOUT$183 SQ[0]|VIN|VOUT|VS|VSN|VSP|VS[0] VIN|VOUT$182 VBP|VDD
+ sg13_lv_pmos L=0.13u W=0.6u AS=0.312p AD=0.312p PS=4.16u PD=4.16u
M$4006 VIN|VOUT$178 VOUT|VSN|VSP$65 VIN|VOUT$176 VBP|VDD sg13_lv_pmos L=0.13u
+ W=0.3u AS=0.156p AD=0.156p PS=2.08u PD=2.08u
M$4008 VIN|VOUT$178 VOUT|VSN|VSP$64 VIN|VOUT$176 VBP|VDD sg13_lv_pmos L=0.13u
+ W=0.6u AS=0.312p AD=0.312p PS=4.16u PD=4.16u
M$4012 VBP|VDD \$5167 VOUT|VSN|VSP$64 VBP|VDD sg13_lv_pmos L=0.13u W=0.15u
+ AS=0.1005p AD=0.1005p PS=1.34u PD=1.34u
M$4013 VBP|VDD \$5091 \$5091 VBP|VDD sg13_lv_pmos L=0.13u W=0.15u AS=0.1005p
+ AD=0.1005p PS=1.34u PD=1.34u
M$4016 VIN|VOUT$183 VOUT|VSN|VSP$64 VIN|VOUT$182 VBP|VDD sg13_lv_pmos L=0.13u
+ W=0.3u AS=0.156p AD=0.156p PS=2.08u PD=2.08u
M$4018 VIN|VOUT$176 VOUT|VSN|VSP$63 VIN|VINA|VOUT$6 VBP|VDD sg13_lv_pmos
+ L=0.13u W=0.3u AS=0.156p AD=0.156p PS=2.08u PD=2.08u
M$4020 VIN|VOUT$182 VOUT|VSN|VSP$63 VIN|VINA|VOUT$6 VBP|VDD sg13_lv_pmos
+ L=0.13u W=0.3u AS=0.156p AD=0.156p PS=2.08u PD=2.08u
M$4022 VBP|VDD STQ[1]|VIN|VOUT|VS|VSN|VSP|VST|VST[1] VOUT|VSN|VSP$61 VBP|VDD
+ sg13_lv_pmos L=0.13u W=0.15u AS=0.1005p AD=0.1005p PS=1.34u PD=1.34u
M$4023 VBP|VDD VIN|VINA|VOUT$6 VIN|VOUT$179 VBP|VDD sg13_lv_pmos L=0.13u
+ W=0.45u AS=0.2115p AD=0.2115p PS=2.82u PD=2.82u
M$4026 VIN|VOUT$179 STQ[1]|VIN|VOUT|VS|VSN|VSP|VST|VST[1] VIN|VOUT$177 VBP|VDD
+ sg13_lv_pmos L=0.13u W=0.6u AS=0.312p AD=0.312p PS=4.16u PD=4.16u
M$4030 VBP|VDD \$5014 VOUT|VSN|VSP$62 VBP|VDD sg13_lv_pmos L=0.13u W=0.15u
+ AS=0.1005p AD=0.1005p PS=1.34u PD=1.34u
M$4031 VIN|VOUT$179 VOUT|VSN|VSP$62 VIN|VOUT$177 VBP|VDD sg13_lv_pmos L=0.13u
+ W=0.3u AS=0.156p AD=0.156p PS=2.08u PD=2.08u
M$4033 VIN|VOUT$177 VOUT|VSN|VSP$60 VIN|VOUT$4 VBP|VDD sg13_lv_pmos L=0.13u
+ W=0.3u AS=0.156p AD=0.156p PS=2.08u PD=2.08u
M$4035 VOUT|VSN|VSS$5 B|OUT|ST[3]|VDD|VIN|VSP VBP|VDD VBP|VDD sg13_lv_pmos
+ L=0.13u W=0.15u AS=0.1005p AD=0.1005p PS=1.34u PD=1.34u
M$4036 STQ[3]|VIN|VOUT|VS|VSN|VSP|VST|VST[3] B|OUT|ST[3]|VDD|VIN|VSP
+ A|VIN|VOUT$4 VBP|VDD sg13_lv_pmos L=0.13u W=0.3u AS=0.156p AD=0.156p PS=2.08u
+ PD=2.08u
M$4038 STQ[3]|VIN|VOUT|VS|VSN|VSP|VST|VST[3] A|VIN|VOUT$4
+ B|OUT|ST[3]|VDD|VIN|VSP VBP|VDD sg13_lv_pmos L=0.13u W=0.15u AS=0.1005p
+ AD=0.1005p PS=1.34u PD=1.34u
M$4039 A|VIN|VOUT$4 VIN|VOUT$181 VBP|VDD VBP|VDD sg13_lv_pmos L=0.13u W=0.15u
+ AS=0.1005p AD=0.1005p PS=1.34u PD=1.34u
M$4040 VIN|VOUT$181 VIN|VOUT$157 VBP|VDD VBP|VDD sg13_lv_pmos L=0.13u W=0.15u
+ AS=0.1005p AD=0.1005p PS=1.34u PD=1.34u
M$4041 VOUT|VSN|VSS$6 B|OUT|ST[2]|VDD|VIN|VSP VBP|VDD VBP|VDD sg13_lv_pmos
+ L=0.13u W=0.15u AS=0.1005p AD=0.1005p PS=1.34u PD=1.34u
M$4042 STQ[2]|VIN|VOUT|VS|VSN|VSP|VST|VST[2] B|OUT|ST[2]|VDD|VIN|VSP
+ A|VIN|VOUT$5 VBP|VDD sg13_lv_pmos L=0.13u W=0.3u AS=0.156p AD=0.156p PS=2.08u
+ PD=2.08u
M$4044 STQ[2]|VIN|VOUT|VS|VSN|VSP|VST|VST[2] A|VIN|VOUT$5
+ B|OUT|ST[2]|VDD|VIN|VSP VBP|VDD sg13_lv_pmos L=0.13u W=0.15u AS=0.1005p
+ AD=0.1005p PS=1.34u PD=1.34u
M$4045 A|VIN|VOUT$5 VIN|VOUT$184 VBP|VDD VBP|VDD sg13_lv_pmos L=0.13u W=0.15u
+ AS=0.1005p AD=0.1005p PS=1.34u PD=1.34u
M$4046 VIN|VOUT$184 VIN|VOUT$157 VBP|VDD VBP|VDD sg13_lv_pmos L=0.13u W=0.15u
+ AS=0.1005p AD=0.1005p PS=1.34u PD=1.34u
M$4047 VBP|VDD A|B|VOUT \$5336 VBP|VDD sg13_lv_pmos L=0.13u W=0.15u AS=0.1005p
+ AD=0.0555p PS=1.34u PD=0.74u
M$4048 \$5336 A|B|VOUT$1 \$5337 VBP|VDD sg13_lv_pmos L=0.13u W=0.15u AS=0.0555p
+ AD=0.0555p PS=0.74u PD=0.74u
M$4049 \$5337 B|C|VIN|VOUT B|OUT|ST[1]|VDD|VIN|VSP VBP|VDD sg13_lv_pmos L=0.13u
+ W=0.15u AS=0.0555p AD=0.1005p PS=0.74u PD=1.34u
M$4050 B|OUT|ST[2]|VDD|VIN|VSP B|C|VIN|VOUT \$5338 VBP|VDD sg13_lv_pmos L=0.13u
+ W=0.15u AS=0.1005p AD=0.0555p PS=1.34u PD=0.74u
M$4051 \$5338 A|B|VOUT$1 VBP|VDD VBP|VDD sg13_lv_pmos L=0.13u W=0.15u
+ AS=0.0555p AD=0.1005p PS=0.74u PD=1.34u
M$4052 B|OUT|ST[3]|VDD|VIN|VSP B|C|VIN|VOUT \$5339 VBP|VDD sg13_lv_pmos L=0.13u
+ W=0.15u AS=0.1005p AD=0.0555p PS=1.34u PD=0.74u
M$4053 \$5339 A|OUT|VOUT VBP|VDD VBP|VDD sg13_lv_pmos L=0.13u W=0.15u
+ AS=0.0555p AD=0.1005p PS=0.74u PD=1.34u
M$4054 B|ST[4]|VDD|VIN|VOUT|VSP B|C|VIN|VOUT VBP|VDD VBP|VDD sg13_lv_pmos
+ L=0.13u W=0.15u AS=0.1005p AD=0.1005p PS=1.34u PD=1.34u
M$4055 VBP|VDD B|C|VIN|VOUT B|OUT|ST[5]|VDD|VIN|VSP VBP|VDD sg13_lv_pmos
+ L=0.13u W=0.15u AS=0.1005p AD=0.0555p PS=1.34u PD=0.74u
M$4056 B|OUT|ST[5]|VDD|VIN|VSP A|OUT|VOUT$1 VBP|VDD VBP|VDD sg13_lv_pmos
+ L=0.13u W=0.15u AS=0.0555p AD=0.1005p PS=0.74u PD=1.34u
M$4057 VBP|VDD A|B|VOUT$1 B|OUT|ST[6]|VDD|VIN|VSP VBP|VDD sg13_lv_pmos L=0.13u
+ W=0.15u AS=0.1005p AD=0.0555p PS=1.34u PD=0.74u
M$4058 B|OUT|ST[6]|VDD|VIN|VSP B|C|VIN|VOUT VBP|VDD VBP|VDD sg13_lv_pmos
+ L=0.13u W=0.15u AS=0.0555p AD=0.1005p PS=0.74u PD=1.34u
M$4059 B|OUT|ST[7]|VDD|VIN|VSP B|C|VIN|VOUT VBP|VDD VBP|VDD sg13_lv_pmos
+ L=0.13u W=0.15u AS=0.1005p AD=0.0555p PS=1.34u PD=0.74u
M$4060 VBP|VDD A|B|VOUT$1 B|OUT|ST[7]|VDD|VIN|VSP VBP|VDD sg13_lv_pmos L=0.13u
+ W=0.15u AS=0.0555p AD=0.0555p PS=0.74u PD=0.74u
M$4061 B|OUT|ST[7]|VDD|VIN|VSP A|B|VOUT VBP|VDD VBP|VDD sg13_lv_pmos L=0.13u
+ W=0.15u AS=0.0555p AD=0.1005p PS=0.74u PD=1.34u
M$4062 VBP|VDD PH270|VIN|VINB|VIND|VINQB|VOUT VIN|VOUT$185 VBP|VDD sg13_lv_pmos
+ L=0.13u W=0.45u AS=0.2115p AD=0.2115p PS=2.82u PD=2.82u
M$4065 VIN|VOUT$185 VOUT|VSN|VSP$67 VIN|VOUT$186 VBP|VDD sg13_lv_pmos L=0.13u
+ W=0.3u AS=0.156p AD=0.156p PS=2.08u PD=2.08u
M$4067 VIN|VOUT$185 VOUT|VSN|VSP$68 VIN|VOUT$186 VBP|VDD sg13_lv_pmos L=0.13u
+ W=0.6u AS=0.312p AD=0.312p PS=4.16u PD=4.16u
M$4069 VBP|VDD \$5344 \$5344 VBP|VDD sg13_lv_pmos L=0.13u W=0.15u AS=0.1005p
+ AD=0.1005p PS=1.34u PD=1.34u
M$4072 VIN|VOUT$186 VOUT|VSN|VSP$66 VIN|VINB|VOUT$7 VBP|VDD sg13_lv_pmos
+ L=0.13u W=0.3u AS=0.156p AD=0.156p PS=2.08u PD=2.08u
M$4074 VOUT|VSN|VSS$7 B|OUT|ST[1]|VDD|VIN|VSP VBP|VDD VBP|VDD sg13_lv_pmos
+ L=0.13u W=0.15u AS=0.1005p AD=0.1005p PS=1.34u PD=1.34u
M$4075 STQ[1]|VIN|VOUT|VS|VSN|VSP|VST|VST[1] B|OUT|ST[1]|VDD|VIN|VSP
+ A|VIN|VOUT$6 VBP|VDD sg13_lv_pmos L=0.13u W=0.3u AS=0.156p AD=0.156p PS=2.08u
+ PD=2.08u
M$4077 STQ[1]|VIN|VOUT|VS|VSN|VSP|VST|VST[1] A|VIN|VOUT$6
+ B|OUT|ST[1]|VDD|VIN|VSP VBP|VDD sg13_lv_pmos L=0.13u W=0.15u AS=0.1005p
+ AD=0.1005p PS=1.34u PD=1.34u
M$4078 A|VIN|VOUT$6 VIN|VOUT$187 VBP|VDD VBP|VDD sg13_lv_pmos L=0.13u W=0.15u
+ AS=0.1005p AD=0.1005p PS=1.34u PD=1.34u
M$4079 VIN|VOUT$187 VIN|VOUT$157 VBP|VDD VBP|VDD sg13_lv_pmos L=0.13u W=0.15u
+ AS=0.1005p AD=0.1005p PS=1.34u PD=1.34u
M$4080 A|OUT|VOUT OUT|VIN VBP|VDD VBP|VDD sg13_lv_pmos L=0.13u W=0.15u
+ AS=0.1005p AD=0.1005p PS=1.34u PD=1.34u
M$4081 VBP|VDD A|B|VOUT OUT|VIN VBP|VDD sg13_lv_pmos L=0.13u W=0.15u AS=0.1005p
+ AD=0.0555p PS=1.34u PD=0.74u
M$4082 OUT|VIN A|B|VOUT$1 VBP|VDD VBP|VDD sg13_lv_pmos L=0.13u W=0.15u
+ AS=0.0555p AD=0.1005p PS=0.74u PD=1.34u
M$4083 A|OUT|VOUT$1 OUT|VIN$1 VBP|VDD VBP|VDD sg13_lv_pmos L=0.13u W=0.15u
+ AS=0.1005p AD=0.1005p PS=1.34u PD=1.34u
M$4084 OUT|VIN$1 A|B|VOUT$1 \$5535 VBP|VDD sg13_lv_pmos L=0.13u W=0.15u
+ AS=0.1005p AD=0.0555p PS=1.34u PD=0.74u
M$4085 \$5535 A|B|VOUT VBP|VDD VBP|VDD sg13_lv_pmos L=0.13u W=0.15u AS=0.0555p
+ AD=0.1005p PS=0.74u PD=1.34u
M$4086 VBP|VDD SQ[1]|VIN|VOUT|VS|VSN|VSP|VS[1] VOUT|VSN|VSP$67 VBP|VDD
+ sg13_lv_pmos L=0.13u W=0.15u AS=0.1005p AD=0.1005p PS=1.34u PD=1.34u
M$4087 VBP|VDD PH90|VIN|VINA|VINC|VINQ|VOUT VIN|VOUT$190 VBP|VDD sg13_lv_pmos
+ L=0.13u W=0.45u AS=0.2115p AD=0.2115p PS=2.82u PD=2.82u
M$4090 VIN|VOUT$190 SQ[1]|VIN|VOUT|VS|VSN|VSP|VS[1] VIN|VOUT$189 VBP|VDD
+ sg13_lv_pmos L=0.13u W=0.6u AS=0.312p AD=0.312p PS=4.16u PD=4.16u
M$4094 VBP|VDD \$5534 VOUT|VSN|VSP$68 VBP|VDD sg13_lv_pmos L=0.13u W=0.15u
+ AS=0.1005p AD=0.1005p PS=1.34u PD=1.34u
M$4095 VIN|VOUT$190 VOUT|VSN|VSP$68 VIN|VOUT$189 VBP|VDD sg13_lv_pmos L=0.13u
+ W=0.3u AS=0.156p AD=0.156p PS=2.08u PD=2.08u
M$4097 VIN|VOUT$189 VOUT|VSN|VSP$66 VIN|VINB|VOUT$7 VBP|VDD sg13_lv_pmos
+ L=0.13u W=0.3u AS=0.156p AD=0.156p PS=2.08u PD=2.08u
M$4099 VBP|VDD VIN|VINB|VOUT$7 VIN|VOUT$191 VBP|VDD sg13_lv_pmos L=0.13u
+ W=0.45u AS=0.2115p AD=0.2115p PS=2.82u PD=2.82u
M$4102 VIN|VOUT$191 VOUT|VSN|VSP$70 VIN|VOUT$188 VBP|VDD sg13_lv_pmos L=0.13u
+ W=0.3u AS=0.156p AD=0.156p PS=2.08u PD=2.08u
M$4104 VIN|VOUT$191 VOUT|VSN|VSP$71 VIN|VOUT$188 VBP|VDD sg13_lv_pmos L=0.13u
+ W=0.6u AS=0.312p AD=0.312p PS=4.16u PD=4.16u
M$4106 VBP|VDD \$5614 \$5614 VBP|VDD sg13_lv_pmos L=0.13u W=0.15u AS=0.1005p
+ AD=0.1005p PS=1.34u PD=1.34u
M$4109 VIN|VOUT$188 VOUT|VSN|VSP$69 VIN|VOUT$4 VBP|VDD sg13_lv_pmos L=0.13u
+ W=0.3u AS=0.156p AD=0.156p PS=2.08u PD=2.08u
M$4111 VBP|VDD S[2]|VIN|VS[2] B|C|VIN|VOUT VBP|VDD sg13_lv_pmos L=0.13u W=0.15u
+ AS=0.1005p AD=0.1005p PS=1.34u PD=1.34u
M$4112 VBP|VDD S[1]|VIN|VS[1] A|B|VOUT$1 VBP|VDD sg13_lv_pmos L=0.13u W=0.15u
+ AS=0.1005p AD=0.1005p PS=1.34u PD=1.34u
M$4113 VBP|VDD S[0]|VIN|VS[0] A|B|VOUT VBP|VDD sg13_lv_pmos L=0.13u W=0.15u
+ AS=0.1005p AD=0.1005p PS=1.34u PD=1.34u
M$4114 VBP|VDD SQ[0]|VIN|VOUT|VS|VSN|VSP|VS[0] VOUT|VSN|VSP$73 VBP|VDD
+ sg13_lv_pmos L=0.13u W=0.15u AS=0.1005p AD=0.1005p PS=1.34u PD=1.34u
M$4115 VBP|VDD PH0|VIN|VINA|VINI|VOUT VIN|VOUT$196 VBP|VDD sg13_lv_pmos L=0.13u
+ W=0.45u AS=0.2115p AD=0.2115p PS=2.82u PD=2.82u
M$4118 VBP|VDD PH180|VIN|VINB|VINIB|VOUT VIN|VOUT$194 VBP|VDD sg13_lv_pmos
+ L=0.13u W=0.45u AS=0.2115p AD=0.2115p PS=2.82u PD=2.82u
M$4121 VIN|VOUT$194 VOUT|VSN|VSP$73 VIN|VOUT$192 VBP|VDD sg13_lv_pmos L=0.13u
+ W=0.3u AS=0.156p AD=0.156p PS=2.08u PD=2.08u
M$4123 VIN|VOUT$196 SQ[0]|VIN|VOUT|VS|VSN|VSP|VS[0] VIN|VOUT$197 VBP|VDD
+ sg13_lv_pmos L=0.13u W=0.6u AS=0.312p AD=0.312p PS=4.16u PD=4.16u
M$4127 VIN|VOUT$194 VOUT|VSN|VSP$74 VIN|VOUT$192 VBP|VDD sg13_lv_pmos L=0.13u
+ W=0.6u AS=0.312p AD=0.312p PS=4.16u PD=4.16u
M$4129 VBP|VDD \$5722 VOUT|VSN|VSP$74 VBP|VDD sg13_lv_pmos L=0.13u W=0.15u
+ AS=0.1005p AD=0.1005p PS=1.34u PD=1.34u
M$4130 VBP|VDD \$5680 \$5680 VBP|VDD sg13_lv_pmos L=0.13u W=0.15u AS=0.1005p
+ AD=0.1005p PS=1.34u PD=1.34u
M$4131 VIN|VOUT$196 VOUT|VSN|VSP$74 VIN|VOUT$197 VBP|VDD sg13_lv_pmos L=0.13u
+ W=0.3u AS=0.156p AD=0.156p PS=2.08u PD=2.08u
M$4135 VIN|VOUT$197 VOUT|VSN|VSP$72 VIN|VINA|VOUT$7 VBP|VDD sg13_lv_pmos
+ L=0.13u W=0.3u AS=0.156p AD=0.156p PS=2.08u PD=2.08u
M$4137 VIN|VOUT$192 VOUT|VSN|VSP$72 VIN|VINA|VOUT$7 VBP|VDD sg13_lv_pmos
+ L=0.13u W=0.3u AS=0.156p AD=0.156p PS=2.08u PD=2.08u
M$4139 VBP|VDD SQ[2]|VIN|VOUT|VS|VSN|VSP|VST|VST[0] VOUT|VSN|VSP$70 VBP|VDD
+ sg13_lv_pmos L=0.13u W=0.15u AS=0.1005p AD=0.1005p PS=1.34u PD=1.34u
M$4140 VBP|VDD VIN|VINA|VOUT$7 VIN|VOUT$195 VBP|VDD sg13_lv_pmos L=0.13u
+ W=0.45u AS=0.2115p AD=0.2115p PS=2.82u PD=2.82u
M$4143 VIN|VOUT$195 SQ[2]|VIN|VOUT|VS|VSN|VSP|VST|VST[0] VIN|VOUT$193 VBP|VDD
+ sg13_lv_pmos L=0.13u W=0.6u AS=0.312p AD=0.312p PS=4.16u PD=4.16u
M$4147 VBP|VDD \$5638 VOUT|VSN|VSP$71 VBP|VDD sg13_lv_pmos L=0.13u W=0.15u
+ AS=0.1005p AD=0.1005p PS=1.34u PD=1.34u
M$4148 VIN|VOUT$195 VOUT|VSN|VSP$71 VIN|VOUT$193 VBP|VDD sg13_lv_pmos L=0.13u
+ W=0.3u AS=0.156p AD=0.156p PS=2.08u PD=2.08u
M$4150 VIN|VOUT$193 VOUT|VSN|VSP$69 VIN|VOUT$4 VBP|VDD sg13_lv_pmos L=0.13u
+ W=0.3u AS=0.156p AD=0.156p PS=2.08u PD=2.08u
.ENDS CDR4176

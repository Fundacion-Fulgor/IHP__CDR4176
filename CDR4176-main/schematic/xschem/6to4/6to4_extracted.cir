* Extracted by KLayout with SG13G2 LVS runset on : 25/03/2026 00:22

.SUBCKT 6to4 VSS VIN|VOUT PH180|VOUT VIN|VOUT$1 VIN|VOUT$2 VIN|VOUT$3 V3|VIN
+ VIN|VOUT$4 VDD VIN|VOUT$5 PH0|VOUT VIN|VOUT$6 PH0|VIN|VOUT PH1|VIN|VOUT
+ VIN|VOUT$7 V0|VIN VIN|VOUT$8 VIN|VOUT$9 VIN|VOUT$10 VIN|VOUT$11 PH1|V5|VIN
+ VIN|VOUT$12 VIN|VOUT$13 PH270|VOUT PH0|V4|VIN VIN|VOUT$14 VIN|VOUT$15
+ VIN|VOUT$16 VIN|VOUT$17 PH1|V2|VIN VIN|VOUT$18 VIN|VOUT$19 PH90|VOUT
+ PH0|PHOUT|VIN|VOUT PH1|PHOUT|VIN|VOUT VIN|VOUT$20 PH0|V1|VIN VIN|VOUT$21
+ VIN|VOUT$22 VIN|VOUT$23
M$1 VSS VIN|VOUT PH180|VOUT VSS sg13_lv_nmos L=0.13u W=9.6u AS=4.992p AD=4.992p
+ PS=66.56u PD=66.56u
M$33 VSS V3|VIN VIN|VOUT$1 VSS sg13_lv_nmos L=0.13u W=0.6u AS=0.312p AD=0.312p
+ PS=4.16u PD=4.16u
M$37 VSS VIN|VOUT$1 PH1|VIN|VOUT VSS sg13_lv_nmos L=0.13u W=0.6u AS=0.312p
+ AD=0.312p PS=4.16u PD=4.16u
M$41 VSS PH1|VIN|VOUT VIN|VOUT$2 VSS sg13_lv_nmos L=0.13u W=0.6u AS=0.312p
+ AD=0.312p PS=4.16u PD=4.16u
M$45 VSS VIN|VOUT$2 VIN|VOUT$5 VSS sg13_lv_nmos L=0.13u W=1.2u AS=0.624p
+ AD=0.624p PS=8.32u PD=8.32u
M$53 VSS VIN|VOUT$4 VIN|VOUT$3 VSS sg13_lv_nmos L=0.13u W=4.8u AS=2.496p
+ AD=2.496p PS=33.28u PD=33.28u
M$69 VSS VIN|VOUT$3 VIN|VOUT VSS sg13_lv_nmos L=0.13u W=4.8u AS=2.496p
+ AD=2.496p PS=33.28u PD=33.28u
M$101 VSS VIN|VOUT$5 VIN|VOUT$4 VSS sg13_lv_nmos L=0.13u W=2.4u AS=1.248p
+ AD=1.248p PS=16.64u PD=16.64u
M$149 VSS VIN|VOUT$6 PH0|VOUT VSS sg13_lv_nmos L=0.13u W=9.6u AS=4.992p
+ AD=4.992p PS=66.56u PD=66.56u
M$181 VSS PH0|VIN|VOUT PH1|VIN|VOUT VSS sg13_lv_nmos L=0.13u W=0.6u AS=0.312p
+ AD=0.312p PS=4.16u PD=4.16u
M$185 VSS PH1|VIN|VOUT PH0|VIN|VOUT VSS sg13_lv_nmos L=0.13u W=0.3u AS=0.156p
+ AD=0.156p PS=2.08u PD=2.08u
M$203 VSS V0|VIN VIN|VOUT$8 VSS sg13_lv_nmos L=0.13u W=0.6u AS=0.312p AD=0.312p
+ PS=4.16u PD=4.16u
M$207 VSS VIN|VOUT$8 PH0|VIN|VOUT VSS sg13_lv_nmos L=0.13u W=0.6u AS=0.312p
+ AD=0.312p PS=4.16u PD=4.16u
M$211 VSS PH0|VIN|VOUT VIN|VOUT$9 VSS sg13_lv_nmos L=0.13u W=0.6u AS=0.312p
+ AD=0.312p PS=4.16u PD=4.16u
M$215 VSS VIN|VOUT$9 VIN|VOUT$11 VSS sg13_lv_nmos L=0.13u W=1.2u AS=0.624p
+ AD=0.624p PS=8.32u PD=8.32u
M$223 VSS VIN|VOUT$10 VIN|VOUT$7 VSS sg13_lv_nmos L=0.13u W=4.8u AS=2.496p
+ AD=2.496p PS=33.28u PD=33.28u
M$239 VSS VIN|VOUT$7 VIN|VOUT$6 VSS sg13_lv_nmos L=0.13u W=4.8u AS=2.496p
+ AD=2.496p PS=33.28u PD=33.28u
M$271 VSS VIN|VOUT$11 VIN|VOUT$10 VSS sg13_lv_nmos L=0.13u W=2.4u AS=1.248p
+ AD=1.248p PS=16.64u PD=16.64u
M$273 VSS PH1|V5|VIN VIN|VOUT$12 VSS sg13_lv_nmos L=0.13u W=0.6u AS=0.312p
+ AD=0.312p PS=4.16u PD=4.16u
M$323 VSS VIN|VOUT$13 PH270|VOUT VSS sg13_lv_nmos L=0.13u W=9.6u AS=4.992p
+ AD=4.992p PS=66.56u PD=66.56u
M$355 VSS VIN|VOUT$12 PH1|PHOUT|VIN|VOUT VSS sg13_lv_nmos L=0.13u W=0.6u
+ AS=0.312p AD=0.312p PS=4.16u PD=4.16u
M$375 VSS PH0|V4|VIN VIN|VOUT$12 VSS sg13_lv_nmos L=0.13u W=0.6u AS=0.312p
+ AD=0.312p PS=4.16u PD=4.16u
M$379 VSS PH1|PHOUT|VIN|VOUT VIN|VOUT$14 VSS sg13_lv_nmos L=0.13u W=0.6u
+ AS=0.312p AD=0.312p PS=4.16u PD=4.16u
M$383 VSS VIN|VOUT$14 VIN|VOUT$17 VSS sg13_lv_nmos L=0.13u W=1.2u AS=0.624p
+ AD=0.624p PS=8.32u PD=8.32u
M$391 VSS VIN|VOUT$16 VIN|VOUT$15 VSS sg13_lv_nmos L=0.13u W=4.8u AS=2.496p
+ AD=2.496p PS=33.28u PD=33.28u
M$407 VSS VIN|VOUT$15 VIN|VOUT$13 VSS sg13_lv_nmos L=0.13u W=4.8u AS=2.496p
+ AD=2.496p PS=33.28u PD=33.28u
M$439 VSS VIN|VOUT$17 VIN|VOUT$16 VSS sg13_lv_nmos L=0.13u W=2.4u AS=1.248p
+ AD=1.248p PS=16.64u PD=16.64u
M$441 VSS PH1|V2|VIN VIN|VOUT$18 VSS sg13_lv_nmos L=0.13u W=0.6u AS=0.312p
+ AD=0.312p PS=4.16u PD=4.16u
M$493 VSS VIN|VOUT$19 PH90|VOUT VSS sg13_lv_nmos L=0.13u W=9.6u AS=4.992p
+ AD=4.992p PS=66.56u PD=66.56u
M$523 VSS VIN|VOUT$18 PH0|PHOUT|VIN|VOUT VSS sg13_lv_nmos L=0.13u W=0.6u
+ AS=0.312p AD=0.312p PS=4.16u PD=4.16u
M$527 VSS PH0|PHOUT|VIN|VOUT PH1|PHOUT|VIN|VOUT VSS sg13_lv_nmos L=0.13u W=0.6u
+ AS=0.312p AD=0.312p PS=4.16u PD=4.16u
M$531 VSS PH1|PHOUT|VIN|VOUT PH0|PHOUT|VIN|VOUT VSS sg13_lv_nmos L=0.13u W=0.3u
+ AS=0.156p AD=0.156p PS=2.08u PD=2.08u
M$549 VSS PH0|V1|VIN VIN|VOUT$18 VSS sg13_lv_nmos L=0.13u W=0.6u AS=0.312p
+ AD=0.312p PS=4.16u PD=4.16u
M$553 VSS PH0|PHOUT|VIN|VOUT VIN|VOUT$21 VSS sg13_lv_nmos L=0.13u W=0.6u
+ AS=0.312p AD=0.312p PS=4.16u PD=4.16u
M$557 VSS VIN|VOUT$21 VIN|VOUT$23 VSS sg13_lv_nmos L=0.13u W=1.2u AS=0.624p
+ AD=0.624p PS=8.32u PD=8.32u
M$565 VSS VIN|VOUT$22 VIN|VOUT$20 VSS sg13_lv_nmos L=0.13u W=4.8u AS=2.496p
+ AD=2.496p PS=33.28u PD=33.28u
M$581 VSS VIN|VOUT$20 VIN|VOUT$19 VSS sg13_lv_nmos L=0.13u W=4.8u AS=2.496p
+ AD=2.496p PS=33.28u PD=33.28u
M$613 VSS VIN|VOUT$23 VIN|VOUT$22 VSS sg13_lv_nmos L=0.13u W=2.4u AS=1.248p
+ AD=1.248p PS=16.64u PD=16.64u
M$677 VDD VIN|VOUT PH180|VOUT VDD sg13_lv_pmos L=0.13u W=14.4u AS=6.768p
+ AD=6.768p PS=90.24u PD=90.24u
M$725 VDD V3|VIN VIN|VOUT$1 VDD sg13_lv_pmos L=0.13u W=0.9u AS=0.423p AD=0.423p
+ PS=5.64u PD=5.64u
M$731 VDD VIN|VOUT$1 PH1|VIN|VOUT VDD sg13_lv_pmos L=0.13u W=0.9u AS=0.423p
+ AD=0.423p PS=5.64u PD=5.64u
M$737 VDD PH1|VIN|VOUT VIN|VOUT$2 VDD sg13_lv_pmos L=0.13u W=0.9u AS=0.423p
+ AD=0.423p PS=5.64u PD=5.64u
M$743 VDD VIN|VOUT$2 VIN|VOUT$5 VDD sg13_lv_pmos L=0.13u W=1.8u AS=0.846p
+ AD=0.846p PS=11.28u PD=11.28u
M$755 VDD VIN|VOUT$4 VIN|VOUT$3 VDD sg13_lv_pmos L=0.13u W=7.2u AS=3.384p
+ AD=3.384p PS=45.12u PD=45.12u
M$779 VDD VIN|VOUT$3 VIN|VOUT VDD sg13_lv_pmos L=0.13u W=7.2u AS=3.384p
+ AD=3.384p PS=45.12u PD=45.12u
M$827 VDD VIN|VOUT$5 VIN|VOUT$4 VDD sg13_lv_pmos L=0.13u W=3.6u AS=1.692p
+ AD=1.692p PS=22.56u PD=22.56u
M$923 VDD VIN|VOUT$6 PH0|VOUT VDD sg13_lv_pmos L=0.13u W=14.4u AS=6.768p
+ AD=6.768p PS=90.24u PD=90.24u
M$947 VDD PH0|VIN|VOUT PH1|VIN|VOUT VDD sg13_lv_pmos L=0.13u W=0.6u AS=0.312p
+ AD=0.312p PS=4.16u PD=4.16u
M$951 VDD PH1|VIN|VOUT PH0|VIN|VOUT VDD sg13_lv_pmos L=0.13u W=0.3u AS=0.156p
+ AD=0.156p PS=2.08u PD=2.08u
M$977 VDD V0|VIN VIN|VOUT$8 VDD sg13_lv_pmos L=0.13u W=0.9u AS=0.423p AD=0.423p
+ PS=5.64u PD=5.64u
M$983 VDD VIN|VOUT$8 PH0|VIN|VOUT VDD sg13_lv_pmos L=0.13u W=0.9u AS=0.423p
+ AD=0.423p PS=5.64u PD=5.64u
M$989 VDD PH0|VIN|VOUT VIN|VOUT$9 VDD sg13_lv_pmos L=0.13u W=0.9u AS=0.423p
+ AD=0.423p PS=5.64u PD=5.64u
M$995 VDD VIN|VOUT$9 VIN|VOUT$11 VDD sg13_lv_pmos L=0.13u W=1.8u AS=0.846p
+ AD=0.846p PS=11.28u PD=11.28u
M$1007 VDD VIN|VOUT$10 VIN|VOUT$7 VDD sg13_lv_pmos L=0.13u W=7.2u AS=3.384p
+ AD=3.384p PS=45.12u PD=45.12u
M$1031 VDD VIN|VOUT$7 VIN|VOUT$6 VDD sg13_lv_pmos L=0.13u W=7.2u AS=3.384p
+ AD=3.384p PS=45.12u PD=45.12u
M$1079 VDD VIN|VOUT$11 VIN|VOUT$10 VDD sg13_lv_pmos L=0.13u W=3.6u AS=1.692p
+ AD=1.692p PS=22.56u PD=22.56u
M$1175 VDD PH1|V5|VIN VIN|VOUT$12 VDD sg13_lv_pmos L=0.13u W=0.9u AS=0.423p
+ AD=0.423p PS=5.64u PD=5.64u
M$1181 VDD VIN|VOUT$13 PH270|VOUT VDD sg13_lv_pmos L=0.13u W=14.4u AS=6.768p
+ AD=6.768p PS=90.24u PD=90.24u
M$1205 VDD VIN|VOUT$12 PH1|PHOUT|VIN|VOUT VDD sg13_lv_pmos L=0.13u W=0.9u
+ AS=0.423p AD=0.423p PS=5.64u PD=5.64u
M$1235 VDD PH0|V4|VIN VIN|VOUT$12 VDD sg13_lv_pmos L=0.13u W=0.9u AS=0.423p
+ AD=0.423p PS=5.64u PD=5.64u
M$1241 VDD PH1|PHOUT|VIN|VOUT VIN|VOUT$14 VDD sg13_lv_pmos L=0.13u W=0.9u
+ AS=0.423p AD=0.423p PS=5.64u PD=5.64u
M$1247 VDD VIN|VOUT$14 VIN|VOUT$17 VDD sg13_lv_pmos L=0.13u W=1.8u AS=0.846p
+ AD=0.846p PS=11.28u PD=11.28u
M$1259 VDD VIN|VOUT$16 VIN|VOUT$15 VDD sg13_lv_pmos L=0.13u W=7.2u AS=3.384p
+ AD=3.384p PS=45.12u PD=45.12u
M$1283 VDD VIN|VOUT$15 VIN|VOUT$13 VDD sg13_lv_pmos L=0.13u W=7.2u AS=3.384p
+ AD=3.384p PS=45.12u PD=45.12u
M$1331 VDD VIN|VOUT$17 VIN|VOUT$16 VDD sg13_lv_pmos L=0.13u W=3.6u AS=1.692p
+ AD=1.692p PS=22.56u PD=22.56u
M$1427 VDD PH1|V2|VIN VIN|VOUT$18 VDD sg13_lv_pmos L=0.13u W=0.9u AS=0.423p
+ AD=0.423p PS=5.64u PD=5.64u
M$1433 VDD VIN|VOUT$19 PH90|VOUT VDD sg13_lv_pmos L=0.13u W=14.4u AS=6.768p
+ AD=6.768p PS=90.24u PD=90.24u
M$1457 VDD VIN|VOUT$18 PH0|PHOUT|VIN|VOUT VDD sg13_lv_pmos L=0.13u W=0.9u
+ AS=0.423p AD=0.423p PS=5.64u PD=5.64u
M$1463 VDD PH0|PHOUT|VIN|VOUT PH1|PHOUT|VIN|VOUT VDD sg13_lv_pmos L=0.13u
+ W=0.6u AS=0.312p AD=0.312p PS=4.16u PD=4.16u
M$1467 VDD PH1|PHOUT|VIN|VOUT PH0|PHOUT|VIN|VOUT VDD sg13_lv_pmos L=0.13u
+ W=0.3u AS=0.156p AD=0.156p PS=2.08u PD=2.08u
M$1493 VDD PH0|V1|VIN VIN|VOUT$18 VDD sg13_lv_pmos L=0.13u W=0.9u AS=0.423p
+ AD=0.423p PS=5.64u PD=5.64u
M$1499 VDD PH0|PHOUT|VIN|VOUT VIN|VOUT$21 VDD sg13_lv_pmos L=0.13u W=0.9u
+ AS=0.423p AD=0.423p PS=5.64u PD=5.64u
M$1505 VDD VIN|VOUT$21 VIN|VOUT$23 VDD sg13_lv_pmos L=0.13u W=1.8u AS=0.846p
+ AD=0.846p PS=11.28u PD=11.28u
M$1517 VDD VIN|VOUT$22 VIN|VOUT$20 VDD sg13_lv_pmos L=0.13u W=7.2u AS=3.384p
+ AD=3.384p PS=45.12u PD=45.12u
M$1541 VDD VIN|VOUT$20 VIN|VOUT$19 VDD sg13_lv_pmos L=0.13u W=7.2u AS=3.384p
+ AD=3.384p PS=45.12u PD=45.12u
M$1589 VDD VIN|VOUT$23 VIN|VOUT$22 VDD sg13_lv_pmos L=0.13u W=3.6u AS=1.692p
+ AD=1.692p PS=22.56u PD=22.56u
.ENDS 6to4

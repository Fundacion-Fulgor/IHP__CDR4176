** sch_path: CDR4176-main/testbenches/tran/xschem/tb_8xPI.sch
**.subckt tb_8xPI
x1 VoutI[0] VoutIB[0] VoutQ[0] VoutQB[0] v0 v0 v0 v0 v0 v0 v0 v0 v0 v0 Vout8I VDD VSS 8xPI
Vin3 vinI GND dc 0 ac 0 pulse(0, 1.2, 0, 25p, 25p, 225p, 500p)
Vin4 vinQ GND dc 0 ac 0 pulse(0, 1.2, 125p, 25p, 25p, 225p, 500p )
Vin5 vinIB GND dc 0 ac 0 pulse(0, 1.2, 250p, 25p, 25p, 225p, 500p )
Vin6 vinQB GND dc 0 ac 0 pulse(0, 1.2, 375p, 25p, 25p, 225p, 500p )
x2[4] VDD vinI VoutI[4] VoutQ[4] vinQ vinIB VoutIB[4] vinQB VoutQB[4] VSS 4to4
x2[3] VDD vinI VoutI[3] VoutQ[3] vinQ vinIB VoutIB[3] vinQB VoutQB[3] VSS 4to4
x2[2] VDD vinI VoutI[2] VoutQ[2] vinQ vinIB VoutIB[2] vinQB VoutQB[2] VSS 4to4
x2[1] VDD vinI VoutI[1] VoutQ[1] vinQ vinIB VoutIB[1] vinQB VoutQB[1] VSS 4to4
x2[0] VDD vinI VoutI[0] VoutQ[0] vinQ vinIB VoutIB[0] vinQB VoutQB[0] VSS 4to4
Vdd4 VDD VSS 1.2
Vdd1 v1 VSS 1.2
Vdd2 v0 VSS 0
Vdd3 VSS GND 0
x3 VoutI[1] VoutIB[1] VoutQ[1] VoutQB[1] v0 v0 v1 v1 v1 v1 v0 v0 v0 v0 Vout4I4Q VDD VSS 8xPI
x4 VoutI[2] VoutIB[2] VoutQ[2] VoutQB[2] v0 v0 v1 v1 v1 v1 v1 v1 v1 v1 Vout8Q VDD VSS 8xPI
x5 VoutI[3] VoutIB[3] VoutQ[3] VoutQB[3] v0 v0 v1 v1 v1 v0 v0 v0 v0 v0 Vout5I3Q VDD VSS 8xPI
x6 VoutI[4] VoutIB[4] VoutQ[4] VoutQB[4] v0 v0 v1 v1 v1 v1 v1 v0 v0 v0 Vout3I5Q VDD VSS 8xPI
C1 Vout8I VSS 25f m=1
C2 Vout8Q VSS 25f m=1
C3 Vout4I4Q VSS 25f m=1
C4 Vout5I3Q VSS 25f m=1
C5 Vout3I5Q VSS 25f m=1
**** begin user architecture code

.param temp=27
.control
save all
tran 5p 1.5n

*meas tran tPWI TRIG v(Vout_I) VAl=0.6 RISE=1 TARG v(Vout_I) VAl=0.6 FALL=1
*meas tran tPWIQ TRIG v(Vout_IQ) VAl=0.6 RISE=1 TARG v(Vout_IQ) VAl=0.6 FALL=1
*meas tran tPWQ TRIG v(Vout_Q) VAl=0.6 RISE=1 TARG v(Vout_Q) VAl=0.6 FALL=1
*meas tran tPWQIB TRIG v(Vout_QIB) VAl=0.6 RISE=1 TARG v(Vout_QIB) VAl=0.6 FALL=1
*meas tran tPWIB TRIG v(Vout_IB) VAl=0.6 RISE=1 TARG v(Vout_IB) VAl=0.6 FALL=1
*meas tran tPWIBQB TRIG v(Vout_IBQB) VAl=0.6 RISE=1 TARG v(Vout_IBQB) VAl=0.6 FALL=1
*meas tran tPWQB TRIG v(Vout_QB) VAl=0.6 RISE=1 TARG v(Vout_QB) VAl=0.6 FALL=1
*meas tran tPWQBI TRIG v(Vout_QBI) VAl=0.6 RISE=1 TARG v(Vout_QBI) VAl=0.6 FALL=1

*meas tran tskewI_IQ TRIG v(Vout_I) VAl=0.6 RISE=1 TARG v(Vout_IQ) VAl=0.6 RISE=1
*meas tran tskewIQ_Q TRIG v(Vout_IQ) VAl=0.6 RISE=1 TARG v(Vout_Q) VAl=0.6 RISE=1
*meas tran tskewQ_QIB TRIG v(Vout_Q) VAl=0.6 RISE=1 TARG v(Vout_QIB) VAl=0.6 RISE=1
*meas tran tskewQIB_IB TRIG v(Vout_QIB) VAl=0.6 RISE=1 TARG v(Vout_IB) VAl=0.6 RISE=1
*meas tran tskewIB_IBQB TRIG v(Vout_IB) VAl=0.6 RISE=1 TARG v(Vout_IBQB) VAl=0.6 RISE=1
*meas tran tskewIBQB_QB TRIG v(Vout_IBQB) VAl=0.6 RISE=1 TARG v(Vout_QB) VAl=0.6 RISE=1
*meas tran tskewQB_QBI TRIG v(Vout_QB) VAl=0.6 RISE=1 TARG v(Vout_QBI) VAl=0.6 RISE=1
*meas tran tskewQBI_I TRIG v(Vout_QBI) VAl=0.6 RISE=1 TARG v(Vout_I) VAl=0.6 RISE=2

write tran_8XPI.raw
.endc

.lib cornerMOSlv.lib mos_tt

**** end user architecture code
**.ends

* expanding   symbol:  CDR4176-main/schematic/xschem/8xPI/8xPI.sym # of pins=9
** sym_path: CDR4176-main/schematic/xschem/8xPI/8xPI.sym
** sch_path: CDR4176-main/schematic/xschem/8xPI/8xPI.sch
.subckt 8xPI VINI VINIB VINQ VINQB VS[1] VS[0] VST[7] VST[6] VST[5] VST[4] VST[3] VST[2] VST[1] VST[0] VOUT VDD VSS
*.ipin VINI
*.ipin VINQ
*.ipin VINIB
*.ipin VINQB
*.iopin VDD
*.iopin VSS
*.opin VOUT
*.ipin VS[1],VS[0]
*.ipin VST[7],VST[6],VST[5],VST[4],VST[3],VST[2],VST[1],VST[0]
x1[7] VINI VINIB VDD net1 VS[1] VS[0] VINQ VSS VINQB VST[7] MUX_4_1
x1[6] VINI VINIB VDD net1 VS[1] VS[0] VINQ VSS VINQB VST[6] MUX_4_1
x1[5] VINI VINIB VDD net1 VS[1] VS[0] VINQ VSS VINQB VST[5] MUX_4_1
x1[4] VINI VINIB VDD net1 VS[1] VS[0] VINQ VSS VINQB VST[4] MUX_4_1
x1[3] VINI VINIB VDD net1 VS[1] VS[0] VINQ VSS VINQB VST[3] MUX_4_1
x1[2] VINI VINIB VDD net1 VS[1] VS[0] VINQ VSS VINQB VST[2] MUX_4_1
x1[1] VINI VINIB VDD net1 VS[1] VS[0] VINQ VSS VINQB VST[1] MUX_4_1
x1[0] VINI VINIB VDD net1 VS[1] VS[0] VINQ VSS VINQB VST[0] MUX_4_1
x2 VDD net2 net1 VSS inv_PI
x3[1] VDD net3_1 net2 VSS inv_PI
x3[0] VDD net3_0 net2 VSS inv_PI
x4[3] VDD net4_3 net3_1 VSS inv_PI
x4[2] VDD net4_2 net3_0 VSS inv_PI
x4[1] VDD net4_1 net3_1 VSS inv_PI
x4[0] VDD net4_0 net3_0 VSS inv_PI
x5[7] VDD VOUT net4_3 VSS inv_PI
x5[6] VDD VOUT net4_2 VSS inv_PI
x5[5] VDD VOUT net4_1 VSS inv_PI
x5[4] VDD VOUT net4_0 VSS inv_PI
x5[3] VDD VOUT net4_3 VSS inv_PI
x5[2] VDD VOUT net4_2 VSS inv_PI
x5[1] VDD VOUT net4_1 VSS inv_PI
x5[0] VDD VOUT net4_0 VSS inv_PI
.ends

* expanding   symbol:  CDR4176-main/schematic/xschem/4to4/4to4.sym # of pins=10
** sym_path: CDR4176-main/schematic/xschem/4to4/4to4.sym
** sch_path: CDR4176-main/schematic/xschem/4to4/4to4.sch
.subckt 4to4 VDD VINI VOUTI VOUTQ VINQ VINIB VOUTIB VINQB VOUTQB VSS
*.iopin VDD
*.iopin VSS
*.ipin VINI
*.ipin VINQ
*.ipin VINIB
*.ipin VINQB
*.opin VOUTI
*.opin VOUTQ
*.opin VOUTIB
*.opin VOUTQB
x0[7] VDD net4_7 VINI VSS inv
x0[6] VDD net4_6 VINI VSS inv
x0[5] VDD net4_5 VINI VSS inv
x0[4] VDD net4_4 VINI VSS inv
x0[3] VDD net4_3 VINI VSS inv
x0[2] VDD net4_2 VINI VSS inv
x0[1] VDD net4_1 VINI VSS inv
x0[0] VDD net4_0 VINI VSS inv
x1[7] VDD net3_7 VINQ VSS inv
x1[6] VDD net3_6 VINQ VSS inv
x1[5] VDD net3_5 VINQ VSS inv
x1[4] VDD net3_4 VINQ VSS inv
x1[3] VDD net3_3 VINQ VSS inv
x1[2] VDD net3_2 VINQ VSS inv
x1[1] VDD net3_1 VINQ VSS inv
x1[0] VDD net3_0 VINQ VSS inv
x2[7] VDD net1_7 VINIB VSS inv
x2[6] VDD net1_6 VINIB VSS inv
x2[5] VDD net1_5 VINIB VSS inv
x2[4] VDD net1_4 VINIB VSS inv
x2[3] VDD net1_3 VINIB VSS inv
x2[2] VDD net1_2 VINIB VSS inv
x2[1] VDD net1_1 VINIB VSS inv
x2[0] VDD net1_0 VINIB VSS inv
x3[7] VDD net2_7 VINQB VSS inv
x3[6] VDD net2_6 VINQB VSS inv
x3[5] VDD net2_5 VINQB VSS inv
x3[4] VDD net2_4 VINQB VSS inv
x3[3] VDD net2_3 VINQB VSS inv
x3[2] VDD net2_2 VINQB VSS inv
x3[1] VDD net2_1 VINQB VSS inv
x3[0] VDD net2_0 VINQB VSS inv
x4[15] VDD VOUTI net4_7 VSS inv
x4[14] VDD VOUTI net4_6 VSS inv
x4[13] VDD VOUTI net4_5 VSS inv
x4[12] VDD VOUTI net4_4 VSS inv
x4[11] VDD VOUTI net4_3 VSS inv
x4[10] VDD VOUTI net4_2 VSS inv
x4[9] VDD VOUTI net4_1 VSS inv
x4[8] VDD VOUTI net4_0 VSS inv
x4[7] VDD VOUTI net4_7 VSS inv
x4[6] VDD VOUTI net4_6 VSS inv
x4[5] VDD VOUTI net4_5 VSS inv
x4[4] VDD VOUTI net4_4 VSS inv
x4[3] VDD VOUTI net4_3 VSS inv
x4[2] VDD VOUTI net4_2 VSS inv
x4[1] VDD VOUTI net4_1 VSS inv
x4[0] VDD VOUTI net4_0 VSS inv
x5[15] VDD VOUTQ net3_7 VSS inv
x5[14] VDD VOUTQ net3_6 VSS inv
x5[13] VDD VOUTQ net3_5 VSS inv
x5[12] VDD VOUTQ net3_4 VSS inv
x5[11] VDD VOUTQ net3_3 VSS inv
x5[10] VDD VOUTQ net3_2 VSS inv
x5[9] VDD VOUTQ net3_1 VSS inv
x5[8] VDD VOUTQ net3_0 VSS inv
x5[7] VDD VOUTQ net3_7 VSS inv
x5[6] VDD VOUTQ net3_6 VSS inv
x5[5] VDD VOUTQ net3_5 VSS inv
x5[4] VDD VOUTQ net3_4 VSS inv
x5[3] VDD VOUTQ net3_3 VSS inv
x5[2] VDD VOUTQ net3_2 VSS inv
x5[1] VDD VOUTQ net3_1 VSS inv
x5[0] VDD VOUTQ net3_0 VSS inv
x6[15] VDD VOUTIB net1_7 VSS inv
x6[14] VDD VOUTIB net1_6 VSS inv
x6[13] VDD VOUTIB net1_5 VSS inv
x6[12] VDD VOUTIB net1_4 VSS inv
x6[11] VDD VOUTIB net1_3 VSS inv
x6[10] VDD VOUTIB net1_2 VSS inv
x6[9] VDD VOUTIB net1_1 VSS inv
x6[8] VDD VOUTIB net1_0 VSS inv
x6[7] VDD VOUTIB net1_7 VSS inv
x6[6] VDD VOUTIB net1_6 VSS inv
x6[5] VDD VOUTIB net1_5 VSS inv
x6[4] VDD VOUTIB net1_4 VSS inv
x6[3] VDD VOUTIB net1_3 VSS inv
x6[2] VDD VOUTIB net1_2 VSS inv
x6[1] VDD VOUTIB net1_1 VSS inv
x6[0] VDD VOUTIB net1_0 VSS inv
x7[15] VDD VOUTQB net2_7 VSS inv
x7[14] VDD VOUTQB net2_6 VSS inv
x7[13] VDD VOUTQB net2_5 VSS inv
x7[12] VDD VOUTQB net2_4 VSS inv
x7[11] VDD VOUTQB net2_3 VSS inv
x7[10] VDD VOUTQB net2_2 VSS inv
x7[9] VDD VOUTQB net2_1 VSS inv
x7[8] VDD VOUTQB net2_0 VSS inv
x7[7] VDD VOUTQB net2_7 VSS inv
x7[6] VDD VOUTQB net2_6 VSS inv
x7[5] VDD VOUTQB net2_5 VSS inv
x7[4] VDD VOUTQB net2_4 VSS inv
x7[3] VDD VOUTQB net2_3 VSS inv
x7[2] VDD VOUTQB net2_2 VSS inv
x7[1] VDD VOUTQB net2_1 VSS inv
x7[0] VDD VOUTQB net2_0 VSS inv
.ends

* expanding   symbol:  CDR4176-main/schematic/xschem/MUX_4_1/MUX_4_1.sym # of pins=9
** sym_path: CDR4176-main/schematic/xschem/MUX_4_1/MUX_4_1.sym
** sch_path: CDR4176-main/schematic/xschem/MUX_4_1/MUX_4_1.sch
.subckt MUX_4_1 VINA VINB VDD VOUT VS[1] VS[0] VINC VSS VIND VST
*.opin VOUT
*.iopin VDD
*.iopin VSS
*.ipin VINA
*.ipin VINB
*.ipin VINC
*.ipin VIND
*.ipin VS[1],VS[0]
*.ipin VST
x3 VDD VINC net2 VS[1] VIND VSS MUX_2_1
x4 VDD VINA net1 VS[0] VINB VSS MUX_2_1
x5 VDD net1 VOUT VST net2 VSS MUX_2_1
.ends

* expanding   symbol:  CDR4176-main/schematic/xschem/inv_PI/inv_PI.sym # of pins=4
** sym_path: CDR4176-main/schematic/xschem/inv_PI/inv_PI.sym
** sch_path: CDR4176-main/schematic/xschem/inv_PI/inv_PI.sch
.subckt inv_PI VDD VOUT VIN VSS
*.iopin VDD
*.iopin VSS
*.opin VOUT
*.ipin VIN
XM2 VOUT VIN VDD VDD sg13_lv_pmos w=0.45u l=0.13u ng=3 m=1
XM1 VOUT VIN VSS VSS sg13_lv_nmos w=0.3u l=0.13u ng=2 m=1
.ends

* expanding   symbol:  CDR4176-main/schematic/xschem/inv/inv.sym # of pins=4
** sym_path: CDR4176-main/schematic/xschem/inv/inv.sym
** sch_path: CDR4176-main/schematic/xschem/inv/inv.sch
.subckt inv VDD VOUT VIN VSS
*.iopin VDD
*.iopin VSS
*.opin VOUT
*.ipin VIN
XM2 VOUT VIN VDD VDD sg13_lv_pmos w=0.15u l=0.13u ng=1 m=1
XM1 VOUT VIN VSS VSS sg13_lv_nmos w=0.15u l=0.13u ng=1 m=1
.ends

* expanding   symbol:  CDR4176-main/schematic/xschem/MUX_2_1/MUX_2_1.sym # of pins=6
** sym_path: CDR4176-main/schematic/xschem/MUX_2_1/MUX_2_1.sym
** sch_path: CDR4176-main/schematic/xschem/MUX_2_1/MUX_2_1.sch
.subckt MUX_2_1 VDD VINA VOUT VS VINB VSS
*.opin VOUT
*.ipin VINA
*.ipin VINB
*.ipin VS
*.iopin VDD
*.iopin VSS
x1 VOUT net1 VS net2 VDD VSS tg_custom
x2 VOUT VS net1 net3 VDD VSS tg_custom
x3 VDD net1 VS VSS inv
x4 VDD net2 VINA VSS inv_PI
x5 VDD net3 VINB VSS inv_PI
x6[3] VOUT VSS VDD net2 VDD VSS tg_custom
x6[2] VOUT VSS VDD net2 VDD VSS tg_custom
x6[1] VOUT VSS VDD net2 VDD VSS tg_custom
x6[0] VOUT VSS VDD net2 VDD VSS tg_custom
x7[3] VOUT VSS VDD net3 VDD VSS tg_custom
x7[2] VOUT VSS VDD net3 VDD VSS tg_custom
x7[1] VOUT VSS VDD net3 VDD VSS tg_custom
x7[0] VOUT VSS VDD net3 VDD VSS tg_custom
.ends

* expanding   symbol:  CDR4176-main/schematic/xschem/tg_custom/tg_custom.sym # of pins=6
** sym_path: CDR4176-main/schematic/xschem/tg_custom/tg_custom.sym
** sch_path: CDR4176-main/schematic/xschem/tg_custom/tg_custom.sch
.subckt tg_custom VOUT VSN VSP VIN VBP VBN
*.iopin VIN
*.iopin VSN
*.iopin VOUT
*.iopin VSP
*.iopin VBN
*.iopin VBP
XM1 VOUT VSN VIN VBN sg13_lv_nmos w=0.15u l=0.13u ng=1 m=1
XM2 VOUT VSP VIN VBP sg13_lv_pmos w=0.3u l=0.13u ng=2 m=1
.ends

.GLOBAL GND
.end

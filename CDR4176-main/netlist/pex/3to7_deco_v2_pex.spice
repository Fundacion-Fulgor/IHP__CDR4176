* NGSPICE file created from 3to7_deco_v2.ext - technology: ihp-sg13g2

.subckt 3to7_deco_v2_pex ST[7] ST[6] ST[5] ST[4] ST[3] ST[2] ST[1] S[2] S[1] S[0] VDD VSS
X0 VDD.t20 nor_x3_custom_0.A ST[7] VDD.t3 sg13_lv_pmos ad=0.1005p pd=1.34u as=55.5f ps=0.74u w=0.15u l=0.13u
X1 VSS.t11 or_custom_0.inv$1_0.VIN or_custom_0.OUT VSS.t10 sg13_lv_nmos ad=0.1005p pd=1.34u as=0.1005p ps=1.34u w=0.15u l=0.13u
X2 VDD.t24 nor_x3_custom_0.C.t2 ST[6] VDD.t15 sg13_lv_pmos ad=0.1005p pd=1.34u as=55.5f ps=0.74u w=0.15u l=0.13u
X3 VDD.t14 and_custom_0.inv$1_0.VIN nor_custom_0.A VDD.t13 sg13_lv_pmos ad=0.1005p pd=1.34u as=0.1005p ps=1.34u w=0.15u l=0.13u
X4 VDD.t4 nor_x3_custom_0.C.t3 ST[7] VDD.t3 sg13_lv_pmos ad=55.5f pd=0.74u as=0.1005p ps=1.34u w=0.15u l=0.13u
X5 and_custom_0.inv$1_0.VIN nor_x3_custom_0.B.t2 a_2893_2758# VSS.t37 sg13_lv_nmos ad=0.1005p pd=1.34u as=55.5f ps=0.74u w=0.15u l=0.13u
X6 a_4391_2063# nor_x3_custom_0.B.t3 a_4277_2063# VSS.t5 sg13_lv_nmos ad=55.5f pd=0.74u as=55.5f ps=0.74u w=0.15u l=0.13u
X7 ST[5] or_custom_0.OUT a_3333_2063# VSS.t2 sg13_lv_nmos ad=0.1005p pd=1.34u as=55.5f ps=0.74u w=0.15u l=0.13u
X8 VSS.t26 nor_x3_custom_0.A or_custom_0.inv$1_0.VIN VSS.t25 sg13_lv_nmos ad=0.1005p pd=1.34u as=55.5f ps=0.74u w=0.15u l=0.13u
X9 a_3900_3048# nor_x3_custom_0.B.t4 or_custom_0.inv$1_0.VIN VDD.t8 sg13_lv_pmos ad=55.5f pd=0.74u as=0.1005p ps=1.34u w=0.15u l=0.13u
X10 a_1506_2353# nor_x3_custom_0.A VDD.t19 VDD.t0 sg13_lv_pmos ad=55.5f pd=0.74u as=0.1005p ps=1.34u w=0.15u l=0.13u
X11 a_2031_2353# nor_x3_custom_0.C.t4 ST[2] VDD.t0 sg13_lv_pmos ad=55.5f pd=0.74u as=0.1005p ps=1.34u w=0.15u l=0.13u
X12 VSS.t13 nor_x3_custom_0.B.t5 ST[2] VSS.t12 sg13_lv_nmos ad=0.1005p pd=1.34u as=55.5f ps=0.74u w=0.15u l=0.13u
X13 ST[3] nor_x3_custom_0.C.t5 VSS.t7 VSS.t6 sg13_lv_nmos ad=55.5f pd=0.74u as=0.1005p ps=1.34u w=0.15u l=0.13u
X14 nor_x3_custom_0.A S[0] VSS.t30 VSS.t29 sg13_lv_nmos ad=0.1005p pd=1.34u as=0.1005p ps=1.34u w=0.15u l=0.13u
X15 VSS.t4 nor_x3_custom_0.B.t6 ST[1] VSS.t3 sg13_lv_nmos ad=55.5f pd=0.74u as=55.5f ps=0.74u w=0.15u l=0.13u
X16 ST[6] nor_x3_custom_0.B.t7 VDD.t16 VDD.t15 sg13_lv_pmos ad=55.5f pd=0.74u as=0.1005p ps=1.34u w=0.15u l=0.13u
X17 VDD.t12 nor_custom_0.A a_2503_2353# VDD.t5 sg13_lv_pmos ad=0.1005p pd=1.34u as=55.5f ps=0.74u w=0.15u l=0.13u
X18 nor_x3_custom_0.C.t0 S[2] VSS.t9 VSS.t8 sg13_lv_nmos ad=0.1005p pd=1.34u as=0.1005p ps=1.34u w=0.15u l=0.13u
X19 a_2893_2758# nor_x3_custom_0.A VSS.t24 VSS.t23 sg13_lv_nmos ad=55.5f pd=0.74u as=0.1005p ps=1.34u w=0.15u l=0.13u
X20 VSS.t41 nor_x3_custom_0.C.t6 ST[4] VSS.t40 sg13_lv_nmos ad=0.1005p pd=1.34u as=0.1005p ps=1.34u w=0.15u l=0.13u
X21 ST[1] nor_x3_custom_0.C.t7 VSS.t4 VSS.t18 sg13_lv_nmos ad=0.1005p pd=1.34u as=55.5f ps=0.74u w=0.15u l=0.13u
X22 VDD.t9 or_custom_0.inv$1_0.VIN or_custom_0.OUT VDD.t8 sg13_lv_pmos ad=0.1005p pd=1.34u as=0.1005p ps=1.34u w=0.15u l=0.13u
X23 nor_x3_custom_0.B.t0 S[1] VSS.t28 VSS.t27 sg13_lv_nmos ad=0.1005p pd=1.34u as=0.1005p ps=1.34u w=0.15u l=0.13u
X24 a_3333_2063# nor_x3_custom_0.C.t8 VSS.t39 VSS.t38 sg13_lv_nmos ad=55.5f pd=0.74u as=0.1005p ps=1.34u w=0.15u l=0.13u
X25 ST[7] nor_x3_custom_0.B.t3 VDD.t4 VDD.t3 sg13_lv_pmos ad=55.5f pd=0.74u as=55.5f ps=0.74u w=0.15u l=0.13u
X26 VDD.t25 nor_x3_custom_0.B.t2 and_custom_0.inv$1_0.VIN VDD.t13 sg13_lv_pmos ad=0.1005p pd=1.34u as=55.5f ps=0.74u w=0.15u l=0.13u
X27 ST[7] nor_x3_custom_0.A a_4391_2063# VSS.t22 sg13_lv_nmos ad=0.1005p pd=1.34u as=55.5f ps=0.74u w=0.15u l=0.13u
X28 VDD.t2 or_custom_0.OUT ST[5] VDD.t1 sg13_lv_pmos ad=0.1005p pd=1.34u as=55.5f ps=0.74u w=0.15u l=0.13u
X29 VSS.t17 and_custom_0.inv$1_0.VIN nor_custom_0.A VSS.t16 sg13_lv_nmos ad=0.1005p pd=1.34u as=0.1005p ps=1.34u w=0.15u l=0.13u
X30 VSS.t36 nor_x3_custom_0.C.t2 a_3805_2063# VSS.t35 sg13_lv_nmos ad=0.1005p pd=1.34u as=55.5f ps=0.74u w=0.15u l=0.13u
X31 VDD.t11 nor_x3_custom_0.B.t5 a_2031_2353# VDD.t10 sg13_lv_pmos ad=0.1005p pd=1.34u as=55.5f ps=0.74u w=0.15u l=0.13u
X32 a_2503_2353# nor_x3_custom_0.C.t5 ST[3] VDD.t5 sg13_lv_pmos ad=55.5f pd=0.74u as=0.1005p ps=1.34u w=0.15u l=0.13u
X33 VDD.t18 nor_x3_custom_0.A a_3900_3048# VDD.t8 sg13_lv_pmos ad=0.1005p pd=1.34u as=55.5f ps=0.74u w=0.15u l=0.13u
X34 a_1620_2353# nor_x3_custom_0.B.t6 a_1506_2353# VDD.t0 sg13_lv_pmos ad=55.5f pd=0.74u as=55.5f ps=0.74u w=0.15u l=0.13u
X35 a_4277_2063# nor_x3_custom_0.C.t3 VSS.t32 VSS.t31 sg13_lv_nmos ad=55.5f pd=0.74u as=0.1005p ps=1.34u w=0.15u l=0.13u
X36 nor_x3_custom_0.A S[0] VDD.t22 VDD.t6 sg13_lv_pmos ad=0.1005p pd=1.34u as=0.1005p ps=1.34u w=0.15u l=0.13u
X37 nor_x3_custom_0.C.t1 S[2] VDD.t7 VDD.t6 sg13_lv_pmos ad=0.1005p pd=1.34u as=0.1005p ps=1.34u w=0.15u l=0.13u
X38 or_custom_0.inv$1_0.VIN nor_x3_custom_0.B.t4 VSS.t34 VSS.t33 sg13_lv_nmos ad=55.5f pd=0.74u as=0.1005p ps=1.34u w=0.15u l=0.13u
X39 ST[2] nor_x3_custom_0.C.t4 VSS.t1 VSS.t0 sg13_lv_nmos ad=55.5f pd=0.74u as=0.1005p ps=1.34u w=0.15u l=0.13u
X40 ST[1] nor_x3_custom_0.C.t7 a_1620_2353# VDD.t0 sg13_lv_pmos ad=0.1005p pd=1.34u as=55.5f ps=0.74u w=0.15u l=0.13u
X41 ST[1] nor_x3_custom_0.A VSS.t21 VSS.t20 sg13_lv_nmos ad=55.5f pd=0.74u as=0.1005p ps=1.34u w=0.15u l=0.13u
X42 VDD.t28 nor_x3_custom_0.C.t6 ST[4] VDD.t27 sg13_lv_pmos ad=0.1005p pd=1.34u as=0.1005p ps=1.34u w=0.15u l=0.13u
X43 and_custom_0.inv$1_0.VIN nor_x3_custom_0.A VDD.t17 VDD.t13 sg13_lv_pmos ad=55.5f pd=0.74u as=0.1005p ps=1.34u w=0.15u l=0.13u
X44 ST[5] nor_x3_custom_0.C.t8 VDD.t26 VDD.t1 sg13_lv_pmos ad=55.5f pd=0.74u as=0.1005p ps=1.34u w=0.15u l=0.13u
X45 a_3805_2063# nor_x3_custom_0.B.t7 ST[6] VSS.t19 sg13_lv_nmos ad=55.5f pd=0.74u as=0.1005p ps=1.34u w=0.15u l=0.13u
X46 nor_x3_custom_0.B.t1 S[1] VDD.t21 VDD.t6 sg13_lv_pmos ad=0.1005p pd=1.34u as=0.1005p ps=1.34u w=0.15u l=0.13u
X47 VSS.t15 nor_custom_0.A ST[3] VSS.t14 sg13_lv_nmos ad=0.1005p pd=1.34u as=55.5f ps=0.74u w=0.15u l=0.13u
R0 VDD.n38 VDD.t7 17.3167
R1 VDD.n35 VDD.t21 17.3167
R2 VDD.n36 VDD.t22 17.3167
R3 VDD.n2 VDD.t19 17.3167
R4 VDD.n6 VDD.t11 17.3167
R5 VDD.n9 VDD.t12 17.3167
R6 VDD.n11 VDD.t28 17.3167
R7 VDD.n14 VDD.t2 17.3167
R8 VDD.n12 VDD.t26 17.3167
R9 VDD.n17 VDD.t24 17.3167
R10 VDD.n15 VDD.t16 17.3167
R11 VDD.n21 VDD.t20 17.3167
R12 VDD.n0 VDD.t4 17.3167
R13 VDD.n28 VDD.t25 17.3167
R14 VDD.n23 VDD.t17 17.3167
R15 VDD.n24 VDD.t14 17.3167
R16 VDD.n32 VDD.t18 17.3167
R17 VDD.n29 VDD.t9 17.3167
R18 VDD.n9 VDD.n8 17.0005
R19 VDD.n6 VDD.n5 17.0005
R20 VDD.n32 VDD.n31 17.0005
R21 VDD.t6 VDD.n34 16.9731
R22 VDD.n10 VDD.t27 16.9721
R23 VDD.t6 VDD.n37 16.9721
R24 VDD.n39 VDD.t6 16.9721
R25 VDD.n16 VDD.t15 11.2832
R26 VDD.n13 VDD.t1 11.2832
R27 VDD.n19 VDD.n18 8.47207
R28 VDD.n20 VDD.n19 8.47207
R29 VDD.n8 VDD.n7 8.47207
R30 VDD.n5 VDD.n1 8.47207
R31 VDD.n31 VDD.n30 8.47207
R32 VDD.n31 VDD.n22 8.47207
R33 VDD.n26 VDD.n25 8.47207
R34 VDD.t0 VDD.n3 8.42955
R35 VDD.n5 VDD.n4 5.66767
R36 VDD.n8 VDD.t5 5.66717
R37 VDD.n27 VDD.n26 5.61655
R38 VDD.n19 VDD.t3 4.2505
R39 VDD.n34 VDD.n33 3.56857
R40 VDD.n31 VDD.t8 3.4005
R41 VDD.n26 VDD.t13 3.4005
R42 VDD.n33 VDD.n21 1.99527
R43 VDD.n33 VDD.n32 1.71395
R44 VDD.n3 VDD 0.266496
R45 VDD.n20 VDD.n0 0.174969
R46 VDD.n3 VDD.n2 0.174579
R47 VDD VDD.n17 0.155315
R48 VDD VDD.n9 0.155315
R49 VDD VDD.n6 0.155315
R50 VDD.n18 VDD 0.152562
R51 VDD.n10 VDD 0.152562
R52 VDD.n7 VDD 0.152562
R53 VDD VDD.n1 0.152562
R54 VDD VDD.n22 0.152562
R55 VDD.n30 VDD 0.152562
R56 VDD.n25 VDD 0.152562
R57 VDD.n37 VDD 0.152562
R58 VDD VDD.n39 0.152562
R59 VDD.n16 VDD.n15 0.11699
R60 VDD.n13 VDD.n12 0.11699
R61 VDD.n27 VDD.n23 0.11699
R62 VDD.n17 VDD.n16 0.11665
R63 VDD.n14 VDD.n13 0.11665
R64 VDD.n28 VDD.n27 0.11665
R65 VDD.n9 VDD 0.102352
R66 VDD.n6 VDD 0.102352
R67 VDD.n32 VDD 0.102352
R68 VDD.n12 VDD 0.0942037
R69 VDD.n2 VDD 0.0942037
R70 VDD VDD.n23 0.0942037
R71 VDD.n7 VDD 0.0731172
R72 VDD.n1 VDD 0.0731172
R73 VDD.n22 VDD 0.0731172
R74 VDD.n21 VDD.n20 0.058858
R75 VDD.n18 VDD.n0 0.058858
R76 VDD.n11 VDD.n10 0.058858
R77 VDD.n30 VDD.n29 0.058858
R78 VDD.n25 VDD.n24 0.058858
R79 VDD.n39 VDD.n38 0.058858
R80 VDD.n36 VDD.n34 0.058858
R81 VDD.n37 VDD.n35 0.058858
R82 VDD.n15 VDD 0.00762963
R83 VDD VDD.n14 0.00762963
R84 VDD VDD.n28 0.00762963
R85 VDD VDD.n11 0.00559259
R86 VDD.n29 VDD 0.00559259
R87 VDD.n24 VDD 0.00559259
R88 VDD VDD.n36 0.00559259
R89 VDD.n35 VDD 0.00559259
R90 VDD.n38 VDD 0.00559259
R91 VDD.n4 VDD.t0 0.001
R92 VDD.n4 VDD.t10 0.001
R93 VSS.n35 VSS.n14 43249.4
R94 VSS.n73 VSS.n20 14600
R95 VSS.n93 VSS.n4 14600
R96 VSS.n62 VSS.n22 14600
R97 VSS.n57 VSS.n25 14600
R98 VSS.n82 VSS.n10 14600
R99 VSS.n45 VSS.n25 11624
R100 VSS.n81 VSS.n80 9482.27
R101 VSS.n81 VSS.n14 3465.31
R102 VSS.n95 VSS.n94 2949.5
R103 VSS.n35 VSS.n34 2618.27
R104 VSS.n94 VSS.n3 1794.04
R105 VSS.n36 VSS.n35 1679.96
R106 VSS.n52 VSS.n51 1294.81
R107 VSS.n94 VSS.n93 1116.63
R108 VSS.n31 VSS.n22 1071.96
R109 VSS.n16 VSS.n10 863.208
R110 VSS.n75 VSS.n10 863.208
R111 VSS.n74 VSS.n73 863.208
R112 VSS.n73 VSS.n72 863.208
R113 VSS.n69 VSS.n4 863.208
R114 VSS.n64 VSS.n4 863.208
R115 VSS.n63 VSS.n62 863.208
R116 VSS.n62 VSS.n61 863.208
R117 VSS.n58 VSS.n57 863.208
R118 VSS.n57 VSS.n56 863.208
R119 VSS.n96 VSS.n2 796.538
R120 VSS.n37 VSS.n1 796.538
R121 VSS.n34 VSS.n33 684.865
R122 VSS.n93 VSS.n92 669.976
R123 VSS.n34 VSS.n25 514.946
R124 VSS.n82 VSS.n81 483.872
R125 VSS.n9 VSS.t33 440.906
R126 VSS.n83 VSS.t25 424.318
R127 VSS.t25 VSS.n8 424.318
R128 VSS.t33 VSS.n8 424.318
R129 VSS.t10 VSS.n3 424.318
R130 VSS.n92 VSS.t37 424.318
R131 VSS.n5 VSS.t37 424.318
R132 VSS.t23 VSS.n5 424.318
R133 VSS.n7 VSS.t23 424.318
R134 VSS.n31 VSS.t16 424.318
R135 VSS.n33 VSS.t16 424.318
R136 VSS.n80 VSS.t22 403.303
R137 VSS.n15 VSS.t22 403.303
R138 VSS.t5 VSS.n15 403.303
R139 VSS.n17 VSS.t5 403.303
R140 VSS.n17 VSS.t31 403.303
R141 VSS.t31 VSS.n16 403.303
R142 VSS.n75 VSS.t35 403.303
R143 VSS.t35 VSS.n18 403.303
R144 VSS.t19 VSS.n18 403.303
R145 VSS.n74 VSS.t19 403.303
R146 VSS.n72 VSS.t2 403.303
R147 VSS.n21 VSS.t2 403.303
R148 VSS.t38 VSS.n21 403.303
R149 VSS.n69 VSS.t38 403.303
R150 VSS.n64 VSS.t40 403.303
R151 VSS.t40 VSS.n63 403.303
R152 VSS.n61 VSS.t14 403.303
R153 VSS.n23 VSS.t14 403.303
R154 VSS.t6 VSS.n23 403.303
R155 VSS.n58 VSS.t6 403.303
R156 VSS.n56 VSS.t12 403.303
R157 VSS.n26 VSS.t12 403.303
R158 VSS.t0 VSS.n26 403.303
R159 VSS.n52 VSS.t0 403.303
R160 VSS.n51 VSS.t18 403.303
R161 VSS.n28 VSS.t18 403.303
R162 VSS.t3 VSS.n28 403.303
R163 VSS.n46 VSS.t3 403.303
R164 VSS.n46 VSS.t20 403.303
R165 VSS.t20 VSS.n45 403.303
R166 VSS.n14 VSS.n13 398.269
R167 VSS.n22 VSS.n7 297.767
R168 VSS.n20 VSS.n9 262.247
R169 VSS.n13 VSS.t29 246.754
R170 VSS.t29 VSS.n2 246.754
R171 VSS.n96 VSS.t27 246.754
R172 VSS.n37 VSS.t8 246.754
R173 VSS.t8 VSS.n36 246.754
R174 VSS.n83 VSS.n82 200.994
R175 VSS.n95 VSS.n1 181.819
R176 VSS.n20 VSS.t10 178.661
R177 VSS.t27 VSS.n95 64.9356
R178 VSS.n40 VSS.t9 17.3133
R179 VSS.n0 VSS.t28 17.3133
R180 VSS.n11 VSS.t30 17.3133
R181 VSS.n29 VSS.t17 17.3133
R182 VSS.n6 VSS.t24 17.3133
R183 VSS.n85 VSS.t26 17.3133
R184 VSS.n87 VSS.t34 17.3133
R185 VSS.n88 VSS.t11 17.3133
R186 VSS.n48 VSS.t4 17.3133
R187 VSS.n43 VSS.t21 17.3133
R188 VSS.n54 VSS.t13 17.3133
R189 VSS.n47 VSS.t1 17.3133
R190 VSS.n59 VSS.t15 17.3133
R191 VSS.n53 VSS.t7 17.3133
R192 VSS.n67 VSS.t41 17.3133
R193 VSS.n68 VSS.t39 17.3133
R194 VSS.n77 VSS.t36 17.3133
R195 VSS.n78 VSS.t32 17.3133
R196 VSS.n79 VSS.n16 17.0005
R197 VSS.n79 VSS.n17 17.0005
R198 VSS.n79 VSS.n15 17.0005
R199 VSS.n80 VSS.n79 17.0005
R200 VSS.n76 VSS.n74 17.0005
R201 VSS.n76 VSS.n18 17.0005
R202 VSS.n77 VSS.n76 17.0005
R203 VSS.n76 VSS.n75 17.0005
R204 VSS.n71 VSS.n68 17.0005
R205 VSS.n71 VSS.n69 17.0005
R206 VSS.n71 VSS.n21 17.0005
R207 VSS.n72 VSS.n71 17.0005
R208 VSS.n65 VSS.n63 17.0005
R209 VSS.n65 VSS.n64 17.0005
R210 VSS.n60 VSS.n58 17.0005
R211 VSS.n60 VSS.n23 17.0005
R212 VSS.n60 VSS.n59 17.0005
R213 VSS.n61 VSS.n60 17.0005
R214 VSS.n55 VSS.n52 17.0005
R215 VSS.n55 VSS.n26 17.0005
R216 VSS.n55 VSS.n54 17.0005
R217 VSS.n56 VSS.n55 17.0005
R218 VSS.n50 VSS.n45 17.0005
R219 VSS.n50 VSS.n46 17.0005
R220 VSS.n50 VSS.n28 17.0005
R221 VSS.n50 VSS.n49 17.0005
R222 VSS.n51 VSS.n50 17.0005
R223 VSS.n84 VSS.n3 17.0005
R224 VSS.n84 VSS.n8 17.0005
R225 VSS.n85 VSS.n84 17.0005
R226 VSS.n84 VSS.n83 17.0005
R227 VSS.n91 VSS.n6 17.0005
R228 VSS.n91 VSS.n7 17.0005
R229 VSS.n91 VSS.n5 17.0005
R230 VSS.n92 VSS.n91 17.0005
R231 VSS.n33 VSS.n32 17.0005
R232 VSS.n32 VSS.n31 17.0005
R233 VSS.n12 VSS.n2 17.0005
R234 VSS.n13 VSS.n12 17.0005
R235 VSS.n97 VSS.n1 17.0005
R236 VSS.n97 VSS.n96 17.0005
R237 VSS.n38 VSS.n36 17.0005
R238 VSS.n38 VSS.n37 17.0005
R239 VSS.n12 VSS.n11 8.54382
R240 VSS.n76 VSS.n19 8.45768
R241 VSS.n71 VSS.n70 8.45768
R242 VSS.n66 VSS.n65 8.45768
R243 VSS.n60 VSS.n24 8.45768
R244 VSS.n55 VSS.n27 8.45768
R245 VSS.n89 VSS.n84 8.45768
R246 VSS.n86 VSS.n84 8.45768
R247 VSS.n91 VSS.n90 8.45768
R248 VSS.n32 VSS.n30 8.45768
R249 VSS.n98 VSS.n97 8.45768
R250 VSS.n39 VSS.n38 8.45768
R251 VSS.n50 VSS.n44 5.59122
R252 VSS.n79 VSS.n78 4.40216
R253 VSS.n42 VSS.n41 2.45001
R254 VSS.n41 VSS 2.40981
R255 VSS VSS.n42 1.76516
R256 VSS.n42 VSS 1.75897
R257 VSS.n90 VSS 0.681945
R258 VSS.n70 VSS 0.319862
R259 VSS.n19 VSS 0.248056
R260 VSS.n70 VSS 0.248056
R261 VSS.n90 VSS 0.248056
R262 VSS.n54 VSS 0.23425
R263 VSS VSS.n77 0.232722
R264 VSS.n59 VSS 0.232722
R265 VSS VSS.n19 0.228195
R266 VSS.n66 VSS 0.228195
R267 VSS VSS.n89 0.228195
R268 VSS.n30 VSS 0.228195
R269 VSS VSS.n98 0.228195
R270 VSS.n39 VSS 0.228195
R271 VSS.n84 VSS.n9 0.20688
R272 VSS.n49 VSS.n48 0.174667
R273 VSS.n44 VSS.n43 0.174067
R274 VSS.n48 VSS.n44 0.173724
R275 VSS.n59 VSS 0.160917
R276 VSS.n54 VSS 0.160917
R277 VSS VSS.n85 0.160917
R278 VSS.n43 VSS 0.142583
R279 VSS.n78 VSS 0.141056
R280 VSS.n68 VSS 0.141056
R281 VSS.n49 VSS 0.141056
R282 VSS VSS.n6 0.141056
R283 VSS VSS.n53 0.139528
R284 VSS VSS.n47 0.139528
R285 VSS VSS.n87 0.139528
R286 VSS VSS.n24 0.10139
R287 VSS VSS.n27 0.10139
R288 VSS.n86 VSS 0.10139
R289 VSS.n67 VSS.n66 0.0876395
R290 VSS.n53 VSS.n24 0.0876395
R291 VSS.n47 VSS.n27 0.0876395
R292 VSS.n89 VSS.n88 0.0876395
R293 VSS.n30 VSS.n29 0.0876395
R294 VSS.n87 VSS.n86 0.0876395
R295 VSS.n98 VSS.n0 0.0876395
R296 VSS.n40 VSS.n39 0.0876395
R297 VSS.n41 VSS 0.0310556
R298 VSS VSS.n67 0.0188333
R299 VSS.n88 VSS 0.0188333
R300 VSS.n29 VSS 0.0188333
R301 VSS.n11 VSS 0.0188333
R302 VSS VSS.n0 0.0188333
R303 VSS VSS.n40 0.0188333
R304 VSS.n77 VSS 0.01425
R305 VSS VSS.n68 0.01425
R306 VSS VSS.n6 0.01425
R307 nor_x3_custom_0.C.n3 nor_x3_custom_0.C.n2 39.5262
R308 nor_x3_custom_0.C.n5 nor_x3_custom_0.C.n1 39.3022
R309 nor_x3_custom_0.C.n9 nor_x3_custom_0.C.n8 39.2672
R310 nor_x3_custom_0.C.n4 nor_x3_custom_0.C 39.058
R311 nor_x3_custom_0.C.n10 nor_x3_custom_0.C.n6 38.9331
R312 nor_x3_custom_0.C.n9 nor_x3_custom_0.C.n7 38.9194
R313 nor_x3_custom_0.C.n3 nor_x3_custom_0.C 38.7857
R314 nor_x3_custom_0.C.n12 nor_x3_custom_0.C.n11 36.4554
R315 nor_x3_custom_0.C nor_x3_custom_0.C.t1 17.3649
R316 nor_x3_custom_0.C.n12 nor_x3_custom_0.C.t0 17.0005
R317 nor_x3_custom_0.C.n6 nor_x3_custom_0.C.t5 15.0005
R318 nor_x3_custom_0.C.n7 nor_x3_custom_0.C.t4 15.0005
R319 nor_x3_custom_0.C.n8 nor_x3_custom_0.C.t7 15.0005
R320 nor_x3_custom_0.C.n1 nor_x3_custom_0.C.t6 15.0005
R321 nor_x3_custom_0.C nor_x3_custom_0.C.t8 15.0005
R322 nor_x3_custom_0.C nor_x3_custom_0.C.t2 15.0005
R323 nor_x3_custom_0.C.n2 nor_x3_custom_0.C.t3 15.0005
R324 nor_x3_custom_0.C.n11 nor_x3_custom_0.C.n10 1.52419
R325 nor_x3_custom_0.C.n4 nor_x3_custom_0.C.n3 1.43399
R326 nor_x3_custom_0.C.n10 nor_x3_custom_0.C.n9 1.03359
R327 nor_x3_custom_0.C.n0 nor_x3_custom_0.C 0.560813
R328 nor_x3_custom_0.C.n11 nor_x3_custom_0.C.n5 0.452788
R329 nor_x3_custom_0.C.n13 nor_x3_custom_0.C 0.3525
R330 nor_x3_custom_0.C.n5 nor_x3_custom_0.C.n4 0.215828
R331 nor_x3_custom_0.C.n0 nor_x3_custom_0.C 0.162063
R332 nor_x3_custom_0.C.n6 nor_x3_custom_0.C 0.0555
R333 nor_x3_custom_0.C.n7 nor_x3_custom_0.C 0.0555
R334 nor_x3_custom_0.C.n8 nor_x3_custom_0.C 0.0555
R335 nor_x3_custom_0.C.n1 nor_x3_custom_0.C 0.0555
R336 nor_x3_custom_0.C.n2 nor_x3_custom_0.C 0.0555
R337 nor_x3_custom_0.C.n12 nor_x3_custom_0.C.n0 0.0403276
R338 nor_x3_custom_0.C.n13 nor_x3_custom_0.C.n12 0.0403276
R339 nor_x3_custom_0.C.n6 nor_x3_custom_0.C 0.0151667
R340 nor_x3_custom_0.C.n7 nor_x3_custom_0.C 0.0151667
R341 nor_x3_custom_0.C.n1 nor_x3_custom_0.C 0.0151667
R342 nor_x3_custom_0.C nor_x3_custom_0.C.n13 0.00998276
R343 nor_x3_custom_0.B.n8 nor_x3_custom_0.B.n7 31.0966
R344 nor_x3_custom_0.B.n3 nor_x3_custom_0.B.n2 30.8755
R345 nor_x3_custom_0.B.n8 nor_x3_custom_0.B.n6 29.7219
R346 nor_x3_custom_0.B.n4 nor_x3_custom_0.B.n1 29.5041
R347 nor_x3_custom_0.B.n3 nor_x3_custom_0.B 28.1792
R348 nor_x3_custom_0.B.n11 nor_x3_custom_0.B.n10 27.9729
R349 nor_x3_custom_0.B.n9 nor_x3_custom_0.B.n5 27.9592
R350 nor_x3_custom_0.B nor_x3_custom_0.B.t1 17.3649
R351 nor_x3_custom_0.B.n11 nor_x3_custom_0.B.t0 17.0005
R352 nor_x3_custom_0.B.n5 nor_x3_custom_0.B.t2 15.0005
R353 nor_x3_custom_0.B.n6 nor_x3_custom_0.B.t5 15.0005
R354 nor_x3_custom_0.B.n7 nor_x3_custom_0.B.t6 15.0005
R355 nor_x3_custom_0.B nor_x3_custom_0.B.t4 15.0005
R356 nor_x3_custom_0.B.n2 nor_x3_custom_0.B.t3 15.0005
R357 nor_x3_custom_0.B.n1 nor_x3_custom_0.B.t7 15.0005
R358 nor_x3_custom_0.B.n9 nor_x3_custom_0.B.n8 1.89379
R359 nor_x3_custom_0.B.n10 nor_x3_custom_0.B.n9 0.884041
R360 nor_x3_custom_0.B.n0 nor_x3_custom_0.B 0.560813
R361 nor_x3_custom_0.B.n12 nor_x3_custom_0.B 0.3525
R362 nor_x3_custom_0.B.n10 nor_x3_custom_0.B.n4 0.34429
R363 nor_x3_custom_0.B.n4 nor_x3_custom_0.B.n3 0.207944
R364 nor_x3_custom_0.B.n0 nor_x3_custom_0.B 0.162063
R365 nor_x3_custom_0.B.n5 nor_x3_custom_0.B 0.0555
R366 nor_x3_custom_0.B.n6 nor_x3_custom_0.B 0.0555
R367 nor_x3_custom_0.B.n7 nor_x3_custom_0.B 0.0555
R368 nor_x3_custom_0.B.n2 nor_x3_custom_0.B 0.0555
R369 nor_x3_custom_0.B.n11 nor_x3_custom_0.B.n0 0.0403276
R370 nor_x3_custom_0.B.n12 nor_x3_custom_0.B.n11 0.0403276
R371 nor_x3_custom_0.B nor_x3_custom_0.B.n12 0.00998276
R372 nor_x3_custom_0.B.n6 nor_x3_custom_0.B 0.00966667
R373 nor_x3_custom_0.B.n5 nor_x3_custom_0.B 0.00783333
R374 nor_x3_custom_0.B.n1 nor_x3_custom_0.B 0.00783333
C0 nor_x3_custom_0.A a_4391_2063# 0.00393f
C1 a_3333_2063# ST[6] 0
C2 nor_x3_custom_0.A ST[1] 0.00769f
C3 nor_x3_custom_0.A or_custom_0.OUT 0.00616f
C4 or_custom_0.inv$1_0.VIN and_custom_0.inv$1_0.VIN 0.00552f
C5 ST[3] nor_x3_custom_0.C 0.05289f
C6 ST[2] ST[1] 0.08139f
C7 ST[5] nor_x3_custom_0.C 0.03584f
C8 VDD S[1] 0.15901f
C9 a_1506_2353# nor_custom_0.A 0
C10 nor_x3_custom_0.A and_custom_0.inv$1_0.VIN 0.23858f
C11 a_2031_2353# nor_custom_0.A 0
C12 or_custom_0.inv$1_0.VIN S[0] 0
C13 a_2706_1921# ST[3] 0
C14 VDD ST[1] 0.0467f
C15 VDD or_custom_0.OUT 0.25004f
C16 nor_x3_custom_0.B nor_x3_custom_0.C 3.09529f
C17 a_3333_2063# or_custom_0.OUT 0.00359f
C18 or_custom_0.inv$1_0.VIN a_2893_2758# 0
C19 a_1506_2353# a_1620_2353# 0.04604f
C20 nor_x3_custom_0.A S[0] 0.06382f
C21 ST[7] nor_x3_custom_0.B 0.14599f
C22 a_4277_2063# nor_x3_custom_0.C 0.0047f
C23 a_2031_2353# a_1620_2353# 0.00204f
C24 VDD and_custom_0.inv$1_0.VIN 0.26393f
C25 a_4277_2063# ST[7] 0.00181f
C26 nor_x3_custom_0.A a_2893_2758# 0.00436f
C27 a_3805_2063# nor_x3_custom_0.C 0.004f
C28 ST[3] nor_x3_custom_0.B 0.00478f
C29 ST[5] nor_x3_custom_0.B 0.00518f
C30 nor_custom_0.A nor_x3_custom_0.C 0.11823f
C31 VDD S[0] 0.15838f
C32 a_3805_2063# ST[7] 0
C33 S[2] nor_x3_custom_0.C 0.0664f
C34 a_1506_2353# ST[1] 0
C35 or_custom_0.inv$1_0.VIN a_3900_3048# 0.0707f
C36 nor_x3_custom_0.A or_custom_0.inv$1_0.VIN 0.05429f
C37 ST[4] nor_x3_custom_0.C 0.06313f
C38 a_2031_2353# ST[1] 0
C39 ST[6] nor_x3_custom_0.C 0.0401f
C40 VDD a_2893_2758# 0
C41 a_1620_2353# nor_x3_custom_0.C 0.04544f
C42 nor_x3_custom_0.A a_3900_3048# 0.00686f
C43 ST[3] nor_custom_0.A 0.03893f
C44 a_3805_2063# ST[5] 0
C45 ST[6] ST[7] 0.02122f
C46 nor_x3_custom_0.A ST[2] 0.00141f
C47 a_4277_2063# nor_x3_custom_0.B 0.04614f
C48 nor_custom_0.A ST[5] 0
C49 VDD or_custom_0.inv$1_0.VIN 0.20709f
C50 S[1] nor_x3_custom_0.C 0.03692f
C51 ST[4] ST[3] 0.04499f
C52 ST[4] ST[5] 0.02719f
C53 a_3805_2063# nor_x3_custom_0.B 0.00393f
C54 a_4391_2063# nor_x3_custom_0.C 0
C55 ST[6] ST[5] 0.07958f
C56 VDD a_3900_3048# 0.08369f
C57 a_2503_2353# nor_x3_custom_0.A 0
C58 VDD nor_x3_custom_0.A 1.22774f
C59 ST[1] nor_x3_custom_0.C 0.18206f
C60 or_custom_0.OUT nor_x3_custom_0.C 0.0698f
C61 nor_custom_0.A nor_x3_custom_0.B 0.01733f
C62 VDD ST[2] 0.04859f
C63 a_3805_2063# a_4277_2063# 0.00222f
C64 a_4391_2063# ST[7] 0.07948f
C65 S[2] nor_x3_custom_0.B 0.00316f
C66 a_3333_2063# nor_x3_custom_0.A 0
C67 ST[4] nor_x3_custom_0.B 0.00183f
C68 ST[7] or_custom_0.OUT 0
C69 and_custom_0.inv$1_0.VIN nor_x3_custom_0.C 0.01832f
C70 ST[6] nor_x3_custom_0.B 0.05487f
C71 a_1620_2353# nor_x3_custom_0.B 0.00546f
C72 VDD a_2503_2353# 0.08223f
C73 ST[6] a_4277_2063# 0
C74 or_custom_0.OUT ST[5] 0.05191f
C75 VDD a_3333_2063# 0
C76 S[0] nor_x3_custom_0.C 0.00252f
C77 S[1] nor_x3_custom_0.B 0.06318f
C78 ST[4] nor_custom_0.A 0.02249f
C79 nor_x3_custom_0.A a_1506_2353# 0.0058f
C80 nor_x3_custom_0.A a_2031_2353# 0
C81 a_3805_2063# ST[6] 0.07798f
C82 ST[3] and_custom_0.inv$1_0.VIN 0
C83 a_2031_2353# ST[2] 0.06499f
C84 a_4391_2063# nor_x3_custom_0.B 0.00393f
C85 ST[6] nor_custom_0.A 0
C86 nor_custom_0.A a_1620_2353# 0
C87 ST[1] nor_x3_custom_0.B 0.087f
C88 or_custom_0.OUT nor_x3_custom_0.B 0.14407f
C89 a_2893_2758# nor_x3_custom_0.C 0.00178f
C90 a_4391_2063# a_4277_2063# 0.04604f
C91 VDD a_1506_2353# 0.07094f
C92 or_custom_0.inv$1_0.VIN nor_x3_custom_0.C 0.01312f
C93 and_custom_0.inv$1_0.VIN nor_x3_custom_0.B 0.06959f
C94 VDD a_2031_2353# 0.08038f
C95 S[1] S[2] 0.08788f
C96 a_3805_2063# or_custom_0.OUT 0
C97 nor_custom_0.A ST[1] 0
C98 or_custom_0.OUT nor_custom_0.A 0.0269f
C99 a_3900_3048# nor_x3_custom_0.C 0.00165f
C100 nor_x3_custom_0.A nor_x3_custom_0.C 0.54148f
C101 S[0] nor_x3_custom_0.B 0.02721f
C102 ST[2] nor_x3_custom_0.C 0.05683f
C103 ST[4] or_custom_0.OUT 0
C104 nor_x3_custom_0.A ST[7] 0.06095f
C105 a_4391_2063# ST[6] 0
C106 and_custom_0.inv$1_0.VIN nor_custom_0.A 0.08838f
C107 ST[6] or_custom_0.OUT 0.00194f
C108 a_1620_2353# ST[1] 0.03619f
C109 a_2893_2758# nor_x3_custom_0.B 0.00492f
C110 and_custom_0.inv$1_0.VIN S[2] 0.00162f
C111 a_2503_2353# nor_x3_custom_0.C 0.00479f
C112 ST[4] and_custom_0.inv$1_0.VIN 0.00297f
C113 VDD nor_x3_custom_0.C 1.02936f
C114 nor_x3_custom_0.A ST[3] 0.00107f
C115 ST[3] ST[2] 0.03458f
C116 nor_x3_custom_0.A ST[5] 0
C117 a_3333_2063# nor_x3_custom_0.C 0.00427f
C118 or_custom_0.inv$1_0.VIN nor_x3_custom_0.B 0.17652f
C119 VDD ST[7] 0.22735f
C120 a_3900_3048# nor_x3_custom_0.B 0.0057f
C121 a_2893_2758# nor_custom_0.A 0.00325f
C122 a_2503_2353# ST[3] 0.06499f
C123 nor_x3_custom_0.A nor_x3_custom_0.B 1.78629f
C124 VDD ST[3] 0.05781f
C125 ST[2] nor_x3_custom_0.B 0.03385f
C126 a_2893_2758# S[2] 0
C127 VDD ST[5] 0.09776f
C128 ST[4] a_2893_2758# 0
C129 nor_x3_custom_0.A a_4277_2063# 0
C130 a_3805_2063# or_custom_0.inv$1_0.VIN 0
C131 a_3333_2063# ST[5] 0.07796f
C132 and_custom_0.inv$1_0.VIN or_custom_0.OUT 0.01501f
C133 a_1506_2353# nor_x3_custom_0.C 0
C134 a_2031_2353# nor_x3_custom_0.C 0.00499f
C135 S[0] S[1] 0.08839f
C136 a_2503_2353# nor_x3_custom_0.B 0.00129f
C137 VDD nor_x3_custom_0.B 1.04587f
C138 nor_x3_custom_0.A a_3805_2063# 0
C139 nor_x3_custom_0.A nor_custom_0.A 0.01721f
C140 or_custom_0.inv$1_0.VIN ST[6] 0
C141 a_3333_2063# nor_x3_custom_0.B 0
C142 or_custom_0.OUT S[0] 0
C143 nor_custom_0.A ST[2] 0
C144 nor_x3_custom_0.A S[2] 0.00164f
C145 ST[4] nor_x3_custom_0.A 0.00106f
C146 ST[3] a_2031_2353# 0.00293f
C147 nor_x3_custom_0.A ST[6] 0.00103f
C148 a_2893_2758# or_custom_0.OUT 0
C149 nor_x3_custom_0.A a_1620_2353# 0.00144f
C150 VDD a_3805_2063# 0
C151 ST[2] a_1620_2353# 0
C152 a_2503_2353# nor_custom_0.A 0.00827f
C153 VDD nor_custom_0.A 0.25711f
C154 a_3333_2063# a_3805_2063# 0.00195f
C155 VDD S[2] 0.14207f
C156 a_2503_2353# ST[4] 0.00293f
C157 a_1506_2353# nor_x3_custom_0.B 0.04614f
C158 a_2683_2616# nor_custom_0.A -0
C159 or_custom_0.inv$1_0.VIN or_custom_0.OUT 0.07478f
C160 and_custom_0.inv$1_0.VIN a_2893_2758# 0.07133f
C161 VDD ST[4] 0.06603f
C162 nor_x3_custom_0.A S[1] 0
C163 a_2031_2353# nor_x3_custom_0.B 0.00518f
C164 ST[7] nor_x3_custom_0.C 0.03445f
C165 ST[4] a_3333_2063# 0.00277f
C166 VDD ST[6] 0.0971f
C167 VDD a_1620_2353# 0.03986f
C168 VDD VSS 5.04883f
C169 a_4115_1921# VSS 0.00419f $ **FLOATING
C170 a_4007_1921# VSS 0.00419f $ **FLOATING
C171 a_3643_1921# VSS 0.00419f $ **FLOATING
C172 a_3535_1921# VSS 0.00419f $ **FLOATING
C173 a_3171_1921# VSS 0.00419f $ **FLOATING
C174 a_3063_1921# VSS 0.00419f $ **FLOATING
C175 a_2813_1921# VSS 0.00419f $ **FLOATING
C176 a_2706_1921# VSS 0.00419f $ **FLOATING
C177 a_2342_1921# VSS 0.00419f $ **FLOATING
C178 a_2234_1921# VSS 0.00419f $ **FLOATING
C179 a_1870_1921# VSS 0.00419f $ **FLOATING
C180 a_1820_1921# VSS 0.00428f $ **FLOATING
C181 a_4391_2063# VSS 0.04543f
C182 a_4277_2063# VSS 0.07595f
C183 a_3805_2063# VSS 0.08296f
C184 ST[7] VSS 0.25438f
C185 a_3333_2063# VSS 0.08306f
C186 ST[6] VSS 0.16428f
C187 ST[5] VSS 0.16231f
C188 ST[4] VSS 0.19206f
C189 a_2503_2353# VSS 0.00345f
C190 ST[3] VSS 0.22665f
C191 a_2031_2353# VSS 0.00295f
C192 ST[2] VSS 0.22411f
C193 ST[1] VSS 0.37201f
C194 a_1620_2353# VSS 0.00237f
C195 a_1506_2353# VSS 0.0076f
C196 a_2683_2616# VSS 0.00838f $ **FLOATING
C197 a_3900_3048# VSS 0.00487f
C198 a_2893_2758# VSS 0.0849f
C199 or_custom_0.inv$1_0.VIN VSS 0.38026f
C200 or_custom_0.OUT VSS 0.41781f
C201 and_custom_0.inv$1_0.VIN VSS 0.37189f
C202 nor_custom_0.A VSS 0.54184f
C203 nor_x3_custom_0.A VSS 2.98002f
C204 S[0] VSS 0.27821f
C205 nor_x3_custom_0.B VSS 3.78467f
C206 S[1] VSS 0.20537f
C207 nor_x3_custom_0.C VSS 5.06194f
C208 S[2] VSS 0.30504f
C209 nor_x3_custom_0.B.t1 VSS 0.0215f
C210 nor_x3_custom_0.B.n0 VSS 0.02095f
C211 nor_x3_custom_0.B.t7 VSS 0.06346f
C212 nor_x3_custom_0.B.n1 VSS 0.05424f
C213 nor_x3_custom_0.B.t4 VSS 0.06346f
C214 nor_x3_custom_0.B.t3 VSS 0.05303f
C215 nor_x3_custom_0.B.n2 VSS 0.07224f
C216 nor_x3_custom_0.B.n3 VSS 0.54647f
C217 nor_x3_custom_0.B.n4 VSS 0.34495f
C218 nor_x3_custom_0.B.t2 VSS 0.06346f
C219 nor_x3_custom_0.B.n5 VSS 0.03911f
C220 nor_x3_custom_0.B.t5 VSS 0.06346f
C221 nor_x3_custom_0.B.n6 VSS 0.05166f
C222 nor_x3_custom_0.B.t6 VSS 0.05523f
C223 nor_x3_custom_0.B.n7 VSS 0.07526f
C224 nor_x3_custom_0.B.n8 VSS 0.79975f
C225 nor_x3_custom_0.B.n9 VSS 0.29376f
C226 nor_x3_custom_0.B.n10 VSS 0.22147f
C227 nor_x3_custom_0.B.t0 VSS 0.02122f
C228 nor_x3_custom_0.B.n11 VSS 0.04021f
C229 nor_x3_custom_0.B.n12 VSS 0.00461f
C230 nor_x3_custom_0.C.t1 VSS 0.01468f
C231 nor_x3_custom_0.C.n0 VSS 0.01431f
C232 nor_x3_custom_0.C.t6 VSS 0.03623f
C233 nor_x3_custom_0.C.n1 VSS 0.04824f
C234 nor_x3_custom_0.C.t8 VSS 0.04335f
C235 nor_x3_custom_0.C.t2 VSS 0.04335f
C236 nor_x3_custom_0.C.t3 VSS 0.0471f
C237 nor_x3_custom_0.C.n2 VSS 0.05464f
C238 nor_x3_custom_0.C.n3 VSS 0.54123f
C239 nor_x3_custom_0.C.n4 VSS 0.36846f
C240 nor_x3_custom_0.C.n5 VSS 0.35085f
C241 nor_x3_custom_0.C.t5 VSS 0.04335f
C242 nor_x3_custom_0.C.n6 VSS 0.04558f
C243 nor_x3_custom_0.C.t4 VSS 0.04335f
C244 nor_x3_custom_0.C.n7 VSS 0.04567f
C245 nor_x3_custom_0.C.t7 VSS 0.03623f
C246 nor_x3_custom_0.C.n8 VSS 0.05299f
C247 nor_x3_custom_0.C.n9 VSS 0.5338f
C248 nor_x3_custom_0.C.n10 VSS 0.34429f
C249 nor_x3_custom_0.C.n11 VSS 0.1743f
C250 nor_x3_custom_0.C.t0 VSS 0.01449f
C251 nor_x3_custom_0.C.n12 VSS 0.03659f
C252 nor_x3_custom_0.C.n13 VSS 0.00315f
.ends

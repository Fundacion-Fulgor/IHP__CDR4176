* NGSPICE file created from clock_gen.ext - technology: ihp-sg13g2

.subckt clock_gen_pex PH0 PH90 VDD CTRL PH180 VSS PH270
X0 VDD.t1197 6to4_0.buff_PI_d32_1.buff_PI_d16$1_0.inv_PI_d8$1_0.VOUT.t24 6to4_0.buff_PI_d32_1.inv_PI_d16$1_0.VIN VDD.t173 sg13_lv_pmos ad=0.1005p pd=1.34u as=55.5f ps=0.74u w=0.15u l=0.13u
X1 VDD.t862 6ph_rosc_0.psdiff_0.buff_d8$1_0.inv_d4$1_0.VIN 6ph_rosc_0.psdiff_0.buff_d8$1_0.inv_d8$1_0.VIN VDD.t34 sg13_lv_pmos ad=0.1005p pd=1.34u as=55.5f ps=0.74u w=0.15u l=0.13u
X2 6ph_rosc_0.psdiff_1.VOUTDN 6ph_rosc_0.psdiff_1.buff_d8$1_1.inv_d8$1_0.VIN VDD.t163 VDD.t0 sg13_lv_pmos ad=55.5f pd=0.74u as=0.1005p ps=1.34u w=0.15u l=0.13u
X3 PH90.t31 6to4_0.buff_PI_d32_0.inv_PI_d32_0.VIN VSS.t652 VSS.t651 sg13_lv_nmos ad=55.5f pd=0.74u as=0.1005p ps=1.34u w=0.15u l=0.13u
X4 VSS.t334 6to4_0.buff_PI_d32_2.inv_PI_d32_0.VIN.t48 PH270.t31 VSS.t333 sg13_lv_nmos ad=0.1005p pd=1.34u as=55.5f ps=0.74u w=0.15u l=0.13u
X5 6ph_rosc_0.psdiff_2.CLKN 6ph_rosc_0.psdiff_0.buff_d8$1_0.inv_d8$1_0.VIN VDD.t1079 VDD.t34 sg13_lv_pmos ad=55.5f pd=0.74u as=0.1005p ps=1.34u w=0.15u l=0.13u
X6 VDD.t111 6to4_0.buff_PI_d32_3.buff_PI_d16$1_0.inv_PI_d4$1_0.VIN 6to4_0.buff_PI_d32_3.buff_PI_d16$1_0.inv_PI_d4$1_0.VOUT.t10 VDD.t99 sg13_lv_pmos ad=0.1005p pd=1.34u as=55.5f ps=0.74u w=0.15u l=0.13u
X7 6to4_0.buff_PI_d32_2.buff_PI_d16$1_0.inv_PI_d4$1_0.VOUT.t10 6to4_0.buff_PI_d32_2.buff_PI_d16$1_0.inv_PI_d4$1_0.VIN VDD.t132 VDD.t126 sg13_lv_pmos ad=55.5f pd=0.74u as=55.5f ps=0.74u w=0.15u l=0.13u
X8 VDD.t644 6to4_0.buff_PI_d32_1.inv_PI_d32_0.VIN PH0.t56 VDD.t173 sg13_lv_pmos ad=0.1005p pd=1.34u as=55.5f ps=0.74u w=0.15u l=0.13u
X9 VDD.t513 a_12104_2338# 6ph_rosc_0.psdiff_0.buff_d8$1_1.VIN.t16 VDD.t503 sg13_lv_pmos ad=0.1005p pd=1.34u as=55.5f ps=0.74u w=0.15u l=0.13u
X10 VDD.t778 6to4_0.buff_PI_d32_2.buff_PI_d16$1_0.inv_PI_d8$1_0.VOUT.t24 6to4_0.buff_PI_d32_2.inv_PI_d16$1_0.VIN.t30 VDD.t198 sg13_lv_pmos ad=0.1005p pd=1.34u as=55.5f ps=0.74u w=0.15u l=0.13u
X11 VDD.t921 6to4_0.buff_PI_d32_0.inv_PI_d16$1_0.VIN.t48 6to4_0.buff_PI_d32_0.inv_PI_d32_0.VIN VDD.t341 sg13_lv_pmos ad=55.5f pd=0.74u as=55.5f ps=0.74u w=0.15u l=0.13u
X12 6ph_rosc_0.psdiff_0.buff_d8$1_1.inv_d4$1_0.VIN 6ph_rosc_0.psdiff_0.buff_d8$1_1.inv_d2$1_0.VIN VSS.t296 VSS.t295 sg13_lv_nmos ad=55.5f pd=0.74u as=0.1005p ps=1.34u w=0.15u l=0.13u
X13 VDD.t439 6to4_0.buff_PI_d32_0.inv_PI_d32_0.VIN PH90.t72 VDD.t343 sg13_lv_pmos ad=0.1005p pd=1.34u as=55.5f ps=0.74u w=0.15u l=0.13u
X14 PH0.t95 6to4_0.buff_PI_d32_1.inv_PI_d32_0.VIN VDD.t623 VDD.t547 sg13_lv_pmos ad=0.1005p pd=1.34u as=55.5f ps=0.74u w=0.15u l=0.13u
X15 6to4_0.buff_PI_d32_1.inv_PI_d16$1_0.VIN 6to4_0.buff_PI_d32_1.buff_PI_d16$1_0.inv_PI_d8$1_0.VOUT.t25 VDD.t1171 VDD.t17 sg13_lv_pmos ad=0.1005p pd=1.34u as=55.5f ps=0.74u w=0.15u l=0.13u
X16 6ph_rosc_0.PH1.t4 6ph_rosc_0.buff_d8$1_3.inv_d8$1_0.VIN VDD.t155 VDD.t75 sg13_lv_pmos ad=55.5f pd=0.74u as=0.1005p ps=1.34u w=0.15u l=0.13u
X17 CTRL 6ph_rosc_0.PH0.t10 CTRL VDD.t51 sg13_lv_pmos ad=0.19p pd=1.38u as=58.5588p ps=0.6306m w=1u l=0.13u
X18 PH0.t17 6to4_0.buff_PI_d32_1.inv_PI_d32_0.VIN VSS.t973 VSS.t972 sg13_lv_nmos ad=55.5f pd=0.74u as=0.1005p ps=1.34u w=0.15u l=0.13u
X19 6ph_rosc_0.psdiff_0.buff_d8$1_0.VIN.t27 6ph_rosc_0.psdiff_1.VOUTDP VSS.t838 VSS.t825 sg13_lv_nmos ad=55.5f pd=0.74u as=55.5f ps=0.74u w=0.15u l=0.13u
X20 VSS.t338 6to4_0.buff_PI_d32_2.inv_PI_d32_0.VIN.t49 PH270.t28 VSS.t337 sg13_lv_nmos ad=0.1005p pd=1.34u as=55.5f ps=0.74u w=0.15u l=0.13u
X21 6to4_0.buff_PI_d32_3.inv_PI_d32_0.VIN 6to4_0.buff_PI_d32_3.inv_PI_d16$1_0.VIN.t48 VSS.t1300 VSS.t1299 sg13_lv_nmos ad=55.5f pd=0.74u as=0.1005p ps=1.34u w=0.15u l=0.13u
X22 PH270.t95 6to4_0.buff_PI_d32_2.inv_PI_d32_0.VIN.t50 VDD.t206 VDD.t202 sg13_lv_pmos ad=0.1005p pd=1.34u as=55.5f ps=0.74u w=0.15u l=0.13u
X23 VDD.t397 6to4_0.buff_PI_d32_0.inv_PI_d32_0.VIN PH90.t71 VDD.t347 sg13_lv_pmos ad=55.5f pd=0.74u as=55.5f ps=0.74u w=0.15u l=0.13u
X24 6ph_rosc_0.psdiff_0.buff_d8$1_0.VIN.t31 6ph_rosc_0.psdiff_1.VOUTDP VSS.t837 VSS.t808 sg13_lv_nmos ad=55.5f pd=0.74u as=55.5f ps=0.74u w=0.15u l=0.13u
X25 CTRL 6ph_rosc_0.PH0.t10 CTRL VDD.t51 sg13_lv_pmos ad=0.19p pd=1.38u as=0 ps=0 w=1u l=0.13u
X26 VSS.t1927 6to4_0.buff_PI_d32_1.inv_PI_d16$1_0.VIN 6to4_0.buff_PI_d32_1.inv_PI_d32_0.VIN VSS.t1926 sg13_lv_nmos ad=0.1005p pd=1.34u as=55.5f ps=0.74u w=0.15u l=0.13u
X27 VSS.t1157 6ph_rosc_0.psdiff_2.VOUTDN 6ph_rosc_0.psdiff_1.buff_d8$1_1.VIN.t28 VSS.t494 sg13_lv_nmos ad=55.5f pd=0.74u as=55.5f ps=0.74u w=0.15u l=0.13u
X28 6ph_rosc_0.buff_d8$1_4.inv_d8$1_0.VIN 6ph_rosc_0.buff_d8$1_4.inv_d4$1_0.VIN VSS.t692 VSS.t691 sg13_lv_nmos ad=55.5f pd=0.74u as=0.1005p ps=1.34u w=0.15u l=0.13u
X29 6to4_0.buff_PI_d32_1.inv_PI_d16$1_0.VIN 6to4_0.buff_PI_d32_1.buff_PI_d16$1_0.inv_PI_d8$1_0.VOUT.t26 VDD.t1170 VDD.t173 sg13_lv_pmos ad=0.1005p pd=1.34u as=55.5f ps=0.74u w=0.15u l=0.13u
X30 6ph_rosc_0.psdiff_2.buff_d8$1_1.VIN.t5 6ph_rosc_0.psdiff_2.CLKP.t8 VSS.t1719 VSS.t1685 sg13_lv_nmos ad=55.5f pd=0.74u as=0.1005p ps=1.34u w=0.15u l=0.13u
X31 VSS.t1133 6to4_0.buff_PI_d32_3.inv_PI_d32_0.VIN PH180.t8 VSS.t1132 sg13_lv_nmos ad=0.1005p pd=1.34u as=55.5f ps=0.74u w=0.15u l=0.13u
X32 PH270.t11 6to4_0.buff_PI_d32_2.inv_PI_d32_0.VIN.t51 VSS.t346 VSS.t345 sg13_lv_nmos ad=55.5f pd=0.74u as=0.1005p ps=1.34u w=0.15u l=0.13u
X33 PH270.t29 6to4_0.buff_PI_d32_2.inv_PI_d32_0.VIN.t52 VSS.t350 VSS.t349 sg13_lv_nmos ad=55.5f pd=0.74u as=0.1005p ps=1.34u w=0.15u l=0.13u
X34 6to4_0.buff_PI_d32_2.inv_PI_d16$1_0.VIN.t14 6to4_0.buff_PI_d32_2.buff_PI_d16$1_0.inv_PI_d8$1_0.VOUT.t25 VSS.t1184 VSS.t1183 sg13_lv_nmos ad=55.5f pd=0.74u as=0.1005p ps=1.34u w=0.15u l=0.13u
X35 PH270.t86 6to4_0.buff_PI_d32_2.inv_PI_d32_0.VIN.t53 VDD.t217 VDD.t215 sg13_lv_pmos ad=55.5f pd=0.74u as=55.5f ps=0.74u w=0.15u l=0.13u
X36 6ph_rosc_0.psdiff_2.buff_d8$1_1.VIN.t14 6ph_rosc_0.psdiff_2.CLKP.t8 VSS.t1702 VSS.t498 sg13_lv_nmos ad=55.5f pd=0.74u as=55.5f ps=0.74u w=0.15u l=0.13u
X37 6to4_0.buff_PI_d32_0.inv_PI_d32_0.VIN 6to4_0.buff_PI_d32_0.inv_PI_d16$1_0.VIN.t49 VDD.t924 VDD.t5 sg13_lv_pmos ad=55.5f pd=0.74u as=55.5f ps=0.74u w=0.15u l=0.13u
X38 PH90.t27 6to4_0.buff_PI_d32_0.inv_PI_d32_0.VIN VSS.t650 VSS.t649 sg13_lv_nmos ad=55.5f pd=0.74u as=0.1005p ps=1.34u w=0.15u l=0.13u
X39 VSS.t1158 6ph_rosc_0.psdiff_2.VOUTDN 6ph_rosc_0.psdiff_1.buff_d8$1_1.VIN.t31 VSS.t1159 sg13_lv_nmos ad=55.5f pd=0.74u as=55.5f ps=0.74u w=0.15u l=0.13u
X40 6to4_0.buff_PI_d32_1.inv_PI_d32_0.VIN 6to4_0.buff_PI_d32_1.inv_PI_d16$1_0.VIN VDD.t1301 VDD.t17 sg13_lv_pmos ad=55.5f pd=0.74u as=0.1005p ps=1.34u w=0.15u l=0.13u
X41 6to4_0.buff_PI_d32_1.buff_PI_d16$1_0.inv_PI_d4$1_0.VIN 6to4_0.flywheel_clk_1.PH0 VSS.t67 VSS.t66 sg13_lv_nmos ad=55.5f pd=0.74u as=0.1005p ps=1.34u w=0.15u l=0.13u
X42 VSS.t1950 6ph_rosc_0.psdiff_1.VOUTDN 6ph_rosc_0.psdiff_0.buff_d8$1_1.VIN.t31 VSS.t497 sg13_lv_nmos ad=55.5f pd=0.74u as=55.5f ps=0.74u w=0.15u l=0.13u
X43 VDD.t642 6to4_0.buff_PI_d32_1.inv_PI_d32_0.VIN PH0.t84 VDD.t547 sg13_lv_pmos ad=0.1005p pd=1.34u as=55.5f ps=0.74u w=0.15u l=0.13u
X44 6ph_rosc_0.buff_d8$1_1.inv_d8$1_0.VIN 6ph_rosc_0.buff_d8$1_1.inv_d4$1_0.VIN VSS.t474 VSS.t473 sg13_lv_nmos ad=55.5f pd=0.74u as=0.1005p ps=1.34u w=0.15u l=0.13u
X45 6ph_rosc_0.psdiff_0.buff_d8$1_1.VIN.t7 VSS.t1965 VDD.t1333 VDD.t503 sg13_lv_pmos ad=55.5f pd=0.74u as=55.5f ps=0.74u w=0.15u l=0.13u
X46 PH180.t82 6to4_0.buff_PI_d32_3.inv_PI_d32_0.VIN VDD.t721 VDD.t673 sg13_lv_pmos ad=55.5f pd=0.74u as=55.5f ps=0.74u w=0.15u l=0.13u
X47 VDD.t866 6to4_0.buff_PI_d32_3.inv_PI_d16$1_0.VIN.t49 6to4_0.buff_PI_d32_3.inv_PI_d32_0.VIN VDD.t679 sg13_lv_pmos ad=55.5f pd=0.74u as=0.1005p ps=1.34u w=0.15u l=0.13u
X48 PH0.t94 6to4_0.buff_PI_d32_1.inv_PI_d32_0.VIN VDD.t593 VDD.t547 sg13_lv_pmos ad=0.1005p pd=1.34u as=55.5f ps=0.74u w=0.15u l=0.13u
X49 6to4_0.buff_PI_d32_2.buff_PI_d16$1_0.inv_PI_d4$1_0.VIN 6to4_0.buff_PI_d32_2.VIN VDD.t670 VDD.t126 sg13_lv_pmos ad=55.5f pd=0.74u as=0.1005p ps=1.34u w=0.15u l=0.13u
X50 CTRL 6ph_rosc_0.PH4.t10 CTRL VDD.t451 sg13_lv_pmos ad=0.19p pd=1.38u as=0 ps=0 w=1u l=0.13u
X51 VDD.t694 6to4_0.buff_PI_d32_3.inv_PI_d32_0.VIN PH180.t72 VDD.t673 sg13_lv_pmos ad=55.5f pd=0.74u as=55.5f ps=0.74u w=0.15u l=0.13u
X52 6to4_0.buff_PI_d32_2.inv_PI_d16$1_0.VIN.t47 6to4_0.buff_PI_d32_2.buff_PI_d16$1_0.inv_PI_d8$1_0.VOUT.t26 VDD.t782 VDD.t198 sg13_lv_pmos ad=0.1005p pd=1.34u as=55.5f ps=0.74u w=0.15u l=0.13u
X53 VDD.t122 6to4_0.PI_clk_0.inv_PI_d2$1_0.VOUT 6to4_0.flywheel_clk_0.PH0 VDD.t9 sg13_lv_pmos ad=55.5f pd=0.74u as=55.5f ps=0.74u w=0.15u l=0.13u
X54 VDD.t770 6to4_0.buff_PI_d32_3.inv_PI_d32_0.VIN PH180.t87 VDD.t677 sg13_lv_pmos ad=0.1005p pd=1.34u as=55.5f ps=0.74u w=0.15u l=0.13u
X55 6ph_rosc_0.PH3.t5 6ph_rosc_0.buff_d8$1_4.inv_d8$1_0.VIN VSS.t759 VSS.t758 sg13_lv_nmos ad=55.5f pd=0.74u as=0.1005p ps=1.34u w=0.15u l=0.13u
X56 VDD.t488 6ph_rosc_0.buff_d8$1_4.inv_d8$1_0.VIN 6ph_rosc_0.PH3.t7 VDD.t75 sg13_lv_pmos ad=0.1005p pd=1.34u as=55.5f ps=0.74u w=0.15u l=0.13u
X57 6ph_rosc_0.psdiff_2.buff_d8$1_1.inv_d2$1_0.VIN 6ph_rosc_0.psdiff_2.buff_d8$1_1.VIN.t32 VDD.t1147 VDD.t0 sg13_lv_pmos ad=0.1005p pd=1.34u as=0.1005p ps=1.34u w=0.15u l=0.13u
X58 PH180.t17 6to4_0.buff_PI_d32_3.inv_PI_d32_0.VIN VSS.t1131 VSS.t1130 sg13_lv_nmos ad=55.5f pd=0.74u as=0.1005p ps=1.34u w=0.15u l=0.13u
X59 6to4_0.buff_PI_d32_3.inv_PI_d16$1_0.VIN.t1 6to4_0.buff_PI_d32_3.buff_PI_d16$1_0.inv_PI_d8$1_0.VOUT.t24 VDD.t1199 VDD.t99 sg13_lv_pmos ad=55.5f pd=0.74u as=55.5f ps=0.74u w=0.15u l=0.13u
X60 VDD.t825 6ph_rosc_0.PH0.t11 6ph_rosc_0.PH3.t1 VDD.t824 sg13_lv_pmos ad=0.1005p pd=1.34u as=55.5f ps=0.74u w=0.15u l=0.13u
X61 CTRL 6ph_rosc_0.PH2.t10 CTRL VDD.t89 sg13_lv_pmos ad=0.19p pd=1.38u as=0 ps=0 w=1u l=0.13u
X62 VDD.t753 6to4_0.buff_PI_d32_3.inv_PI_d32_0.VIN PH180.t95 VDD.t673 sg13_lv_pmos ad=55.5f pd=0.74u as=0.1005p ps=1.34u w=0.15u l=0.13u
X63 6ph_rosc_0.buff_d8$1_4.inv_d2$1_0.VIN 6ph_rosc_0.psdiff_2.VOUTDP VDD.t147 VDD.t75 sg13_lv_pmos ad=0.1005p pd=1.34u as=0.1005p ps=1.34u w=0.15u l=0.13u
X64 VDD.t1194 6to4_0.buff_PI_d32_1.buff_PI_d16$1_0.inv_PI_d8$1_0.VOUT.t27 6to4_0.buff_PI_d32_1.inv_PI_d16$1_0.VIN VDD.t17 sg13_lv_pmos ad=0.1005p pd=1.34u as=55.5f ps=0.74u w=0.15u l=0.13u
X65 PH270.t94 6to4_0.buff_PI_d32_2.inv_PI_d32_0.VIN.t52 VDD.t212 VDD.t198 sg13_lv_pmos ad=0.1005p pd=1.34u as=55.5f ps=0.74u w=0.15u l=0.13u
X66 VDD.t323 6ph_rosc_0.buff_d8$1_1.inv_d8$1_0.VIN 6ph_rosc_0.PH5.t4 VDD.t75 sg13_lv_pmos ad=0.1005p pd=1.34u as=55.5f ps=0.74u w=0.15u l=0.13u
X67 VDD.t359 6to4_0.buff_PI_d32_0.inv_PI_d32_0.VIN PH90.t95 VDD.t347 sg13_lv_pmos ad=55.5f pd=0.74u as=0.1005p ps=1.34u w=0.15u l=0.13u
X68 VSS.t829 6ph_rosc_0.psdiff_1.VOUTDP 6ph_rosc_0.psdiff_0.buff_d8$1_0.VIN.t30 VSS.t830 sg13_lv_nmos ad=55.5f pd=0.74u as=55.5f ps=0.74u w=0.15u l=0.13u
X69 VSS.t1308 6to4_0.buff_PI_d32_3.inv_PI_d16$1_0.VIN.t50 6to4_0.buff_PI_d32_3.inv_PI_d32_0.VIN VSS.t1307 sg13_lv_nmos ad=0.1005p pd=1.34u as=55.5f ps=0.74u w=0.15u l=0.13u
X70 VDD.t1325 VSS.t1965 6ph_rosc_0.psdiff_0.buff_d8$1_0.VIN.t9 VDD.t503 sg13_lv_pmos ad=55.5f pd=0.74u as=55.5f ps=0.74u w=0.15u l=0.13u
X71 VSS.t280 6ph_rosc_0.psdiff_1.buff_d8$1_1.inv_d8$1_0.VIN 6ph_rosc_0.psdiff_1.VOUTDN VSS.t279 sg13_lv_nmos ad=0.1005p pd=1.34u as=55.5f ps=0.74u w=0.15u l=0.13u
X72 PH90.t24 6to4_0.buff_PI_d32_0.inv_PI_d32_0.VIN VSS.t648 VSS.t647 sg13_lv_nmos ad=55.5f pd=0.74u as=0.1005p ps=1.34u w=0.15u l=0.13u
X73 6to4_0.buff_PI_d32_3.inv_PI_d32_0.VIN 6to4_0.buff_PI_d32_3.inv_PI_d16$1_0.VIN.t51 VDD.t874 VDD.t679 sg13_lv_pmos ad=55.5f pd=0.74u as=0.1005p ps=1.34u w=0.15u l=0.13u
X74 6to4_0.buff_PI_d32_0.inv_PI_d16$1_0.VIN.t2 6to4_0.buff_PI_d32_0.buff_PI_d16$1_0.inv_PI_d8$1_0.VOUT.t24 VDD.t1082 VDD.t5 sg13_lv_pmos ad=55.5f pd=0.74u as=0.1005p ps=1.34u w=0.15u l=0.13u
X75 VDD.t220 6to4_0.buff_PI_d32_2.inv_PI_d32_0.VIN.t54 PH270.t69 VDD.t215 sg13_lv_pmos ad=55.5f pd=0.74u as=55.5f ps=0.74u w=0.15u l=0.13u
X76 VSS.t1855 6ph_rosc_0.PH3.t10 6to4_0.inv_PI_d2$1_3.VOUT VSS.t1854 sg13_lv_nmos ad=0.1005p pd=1.34u as=55.5f ps=0.74u w=0.15u l=0.13u
X77 VSS.t787 6ph_rosc_0.psdiff_1.buff_d8$1_1.inv_d2$1_0.VIN 6ph_rosc_0.psdiff_1.buff_d8$1_1.inv_d4$1_0.VIN VSS.t786 sg13_lv_nmos ad=0.1005p pd=1.34u as=55.5f ps=0.74u w=0.15u l=0.13u
X78 PH270.t27 6to4_0.buff_PI_d32_2.inv_PI_d32_0.VIN.t55 VSS.t362 VSS.t361 sg13_lv_nmos ad=55.5f pd=0.74u as=0.1005p ps=1.34u w=0.15u l=0.13u
X79 VSS.t65 6to4_0.flywheel_clk_1.PH0 6to4_0.buff_PI_d32_1.buff_PI_d16$1_0.inv_PI_d4$1_0.VIN VSS.t64 sg13_lv_nmos ad=0.1005p pd=1.34u as=55.5f ps=0.74u w=0.15u l=0.13u
X80 VDD.t665 6to4_0.buff_PI_d32_2.VIN 6to4_0.buff_PI_d32_2.buff_PI_d16$1_0.inv_PI_d4$1_0.VIN VDD.t126 sg13_lv_pmos ad=55.5f pd=0.74u as=0.1005p ps=1.34u w=0.15u l=0.13u
X81 6to4_0.buff_PI_d32_0.inv_PI_d16$1_0.VIN.t5 6to4_0.buff_PI_d32_0.buff_PI_d16$1_0.inv_PI_d8$1_0.VOUT.t25 VDD.t1083 VDD.t341 sg13_lv_pmos ad=0.1005p pd=1.34u as=55.5f ps=0.74u w=0.15u l=0.13u
X82 6to4_0.flywheel_clk_0.PH0 6to4_0.PI_clk_0.inv_PI_d2$1_0.VOUT VDD.t120 VDD.t9 sg13_lv_pmos ad=55.5f pd=0.74u as=55.5f ps=0.74u w=0.15u l=0.13u
X83 VDD.t36 6ph_rosc_0.psdiff_0.buff_d8$1_0.inv_d2$1_0.VIN 6ph_rosc_0.psdiff_0.buff_d8$1_0.inv_d4$1_0.VIN VDD.t34 sg13_lv_pmos ad=0.1005p pd=1.34u as=55.5f ps=0.74u w=0.15u l=0.13u
X84 6ph_rosc_0.psdiff_2.buff_d8$1_1.VIN.t19 VSS.t1966 VDD.t1357 VDD.t470 sg13_lv_pmos ad=55.5f pd=0.74u as=55.5f ps=0.74u w=0.15u l=0.13u
X85 PH90.t75 6to4_0.buff_PI_d32_0.inv_PI_d32_0.VIN VDD.t361 VDD.t343 sg13_lv_pmos ad=55.5f pd=0.74u as=55.5f ps=0.74u w=0.15u l=0.13u
X86 VDD.t1042 6to4_0.buff_PI_d32_2.buff_PI_d16$1_0.inv_PI_d4$1_0.VOUT.t12 6to4_0.buff_PI_d32_2.buff_PI_d16$1_0.inv_PI_d8$1_0.VOUT.t19 VDD.t198 sg13_lv_pmos ad=0.1005p pd=1.34u as=55.5f ps=0.74u w=0.15u l=0.13u
X87 VDD.t23 6to4_0.buff_PI_d32_1.buff_PI_d16$1_0.inv_PI_d4$1_0.VIN 6to4_0.buff_PI_d32_1.buff_PI_d16$1_0.inv_PI_d4$1_0.VOUT.t6 VDD.t17 sg13_lv_pmos ad=55.5f pd=0.74u as=55.5f ps=0.74u w=0.15u l=0.13u
X88 VSS.t63 6to4_0.flywheel_clk_1.PH0 6to4_0.inv_PI_d2$1_2.VOUT VSS.t62 sg13_lv_nmos ad=0.1005p pd=1.34u as=55.5f ps=0.74u w=0.15u l=0.13u
X89 VSS.t1604 6to4_0.buff_PI_d32_0.buff_PI_d16$1_0.inv_PI_d8$1_0.VOUT.t26 6to4_0.buff_PI_d32_0.inv_PI_d16$1_0.VIN.t6 VSS.t1603 sg13_lv_nmos ad=0.1005p pd=1.34u as=55.5f ps=0.74u w=0.15u l=0.13u
X90 VDD.t969 6to4_0.buff_PI_d32_2.inv_PI_d16$1_0.VIN.t48 6to4_0.buff_PI_d32_2.inv_PI_d32_0.VIN.t2 VDD.t126 sg13_lv_pmos ad=55.5f pd=0.74u as=0.1005p ps=1.34u w=0.15u l=0.13u
X91 6ph_rosc_0.psdiff_1.buff_d8$1_1.inv_d8$1_0.VIN 6ph_rosc_0.psdiff_1.buff_d8$1_1.inv_d4$1_0.VIN VSS.t7 VSS.t6 sg13_lv_nmos ad=55.5f pd=0.74u as=0.1005p ps=1.34u w=0.15u l=0.13u
X92 CTRL 6ph_rosc_0.PH1.t10 CTRL VDD.t80 sg13_lv_pmos ad=0.19p pd=1.38u as=0 ps=0 w=1u l=0.13u
X93 VDD.t227 6to4_0.buff_PI_d32_2.inv_PI_d32_0.VIN.t56 PH270.t67 VDD.t198 sg13_lv_pmos ad=0.1005p pd=1.34u as=55.5f ps=0.74u w=0.15u l=0.13u
X94 6ph_rosc_0.buff_d8$1_0.inv_d4$1_0.VIN 6ph_rosc_0.buff_d8$1_0.inv_d2$1_0.VIN VDD.t672 VDD.t87 sg13_lv_pmos ad=55.5f pd=0.74u as=0.1005p ps=1.34u w=0.15u l=0.13u
X95 VDD.t91 6ph_rosc_0.buff_d8$1_0.inv_d4$1_0.VIN 6ph_rosc_0.buff_d8$1_0.inv_d8$1_0.VIN VDD.t85 sg13_lv_pmos ad=0.1005p pd=1.34u as=55.5f ps=0.74u w=0.15u l=0.13u
X96 6ph_rosc_0.psdiff_2.buff_d8$1_1.VIN.t29 a_6156_2338# VDD.t477 VDD.t470 sg13_lv_pmos ad=55.5f pd=0.74u as=55.5f ps=0.74u w=0.15u l=0.13u
X97 6ph_rosc_0.psdiff_2.buff_d8$1_1.VIN.t22 VSS.t1966 VDD.t1358 VDD.t470 sg13_lv_pmos ad=55.5f pd=0.74u as=55.5f ps=0.74u w=0.15u l=0.13u
X98 CTRL 6ph_rosc_0.PH0.t10 CTRL VDD.t51 sg13_lv_pmos ad=0.19p pd=1.38u as=0 ps=0 w=1u l=0.13u
X99 6to4_0.buff_PI_d32_3.inv_PI_d16$1_0.VIN.t4 6to4_0.buff_PI_d32_3.buff_PI_d16$1_0.inv_PI_d8$1_0.VOUT.t25 VDD.t1203 VDD.t99 sg13_lv_pmos ad=55.5f pd=0.74u as=0.1005p ps=1.34u w=0.15u l=0.13u
X100 6ph_rosc_0.PH2.t7 6ph_rosc_0.buff_d8$1_0.inv_d8$1_0.VIN VDD.t448 VDD.t440 sg13_lv_pmos ad=55.5f pd=0.74u as=0.1005p ps=1.34u w=0.15u l=0.13u
X101 6to4_0.buff_PI_d32_0.inv_PI_d32_0.VIN 6to4_0.buff_PI_d32_0.inv_PI_d16$1_0.VIN.t50 VDD.t928 VDD.t341 sg13_lv_pmos ad=55.5f pd=0.74u as=0.1005p ps=1.34u w=0.15u l=0.13u
X102 VSS.t1799 6to4_0.buff_PI_d32_3.buff_PI_d16$1_0.inv_PI_d8$1_0.VOUT.t26 6to4_0.buff_PI_d32_3.inv_PI_d16$1_0.VIN.t6 VSS.t1798 sg13_lv_nmos ad=0.1005p pd=1.34u as=55.5f ps=0.74u w=0.15u l=0.13u
X103 VDD.t229 6to4_0.buff_PI_d32_2.inv_PI_d32_0.VIN.t57 PH270.t93 VDD.t215 sg13_lv_pmos ad=55.5f pd=0.74u as=0.1005p ps=1.34u w=0.15u l=0.13u
X104 PH0.t22 6to4_0.buff_PI_d32_1.inv_PI_d32_0.VIN VSS.t971 VSS.t970 sg13_lv_nmos ad=55.5f pd=0.74u as=0.1005p ps=1.34u w=0.15u l=0.13u
X105 6to4_0.flywheel_clk_1.PH0 6to4_0.inv_PI_d2$1_2.VOUT VSS.t524 VSS.t523 sg13_lv_nmos ad=55.5f pd=0.74u as=0.1005p ps=1.34u w=0.15u l=0.13u
X106 CTRL 6ph_rosc_0.PH0.t10 CTRL VDD.t51 sg13_lv_pmos ad=0.19p pd=1.38u as=0 ps=0 w=1u l=0.13u
X107 VDD.t912 6ph_rosc_0.PH1.t11 6to4_0.PI_clk_0.inv_PI_d2$1_0.VOUT VDD.t5 sg13_lv_pmos ad=55.5f pd=0.74u as=0.1005p ps=1.34u w=0.15u l=0.13u
X108 PH180.t27 6to4_0.buff_PI_d32_3.inv_PI_d32_0.VIN VSS.t1129 VSS.t1128 sg13_lv_nmos ad=55.5f pd=0.74u as=0.1005p ps=1.34u w=0.15u l=0.13u
X109 VSS.t716 6ph_rosc_0.psdiff_2.CLKN 6ph_rosc_0.psdiff_2.buff_d8$1_0.VIN.t22 VSS.t695 sg13_lv_nmos ad=55.5f pd=0.74u as=55.5f ps=0.74u w=0.15u l=0.13u
X110 VDD.t414 6to4_0.buff_PI_d32_0.inv_PI_d32_0.VIN PH90.t94 VDD.t5 sg13_lv_pmos ad=55.5f pd=0.74u as=0.1005p ps=1.34u w=0.15u l=0.13u
X111 6ph_rosc_0.psdiff_1.buff_d8$1_1.VIN.t9 VSS.t1967 VDD.t1417 VDD.t301 sg13_lv_pmos ad=55.5f pd=0.74u as=55.5f ps=0.74u w=0.15u l=0.13u
X112 CTRL 6ph_rosc_0.PH2.t10 CTRL VDD.t80 sg13_lv_pmos ad=0.34p pd=2.68u as=0 ps=0 w=1u l=0.13u
X113 VSS.t646 6to4_0.buff_PI_d32_0.inv_PI_d32_0.VIN PH90.t25 VSS.t645 sg13_lv_nmos ad=0.1005p pd=1.34u as=55.5f ps=0.74u w=0.15u l=0.13u
X114 PH270.t92 6to4_0.buff_PI_d32_2.inv_PI_d32_0.VIN.t58 VDD.t231 VDD.t126 sg13_lv_pmos ad=0.1005p pd=1.34u as=55.5f ps=0.74u w=0.15u l=0.13u
X115 6to4_0.buff_PI_d32_1.buff_PI_d16$1_0.inv_PI_d8$1_0.VOUT.t0 6to4_0.buff_PI_d32_1.buff_PI_d16$1_0.inv_PI_d4$1_0.VOUT.t12 VDD.t176 VDD.t173 sg13_lv_pmos ad=55.5f pd=0.74u as=0.1005p ps=1.34u w=0.15u l=0.13u
X116 VSS.t264 6ph_rosc_0.buff_d8$1_3.inv_d8$1_0.VIN 6ph_rosc_0.PH1.t1 VSS.t263 sg13_lv_nmos ad=0.1005p pd=1.34u as=55.5f ps=0.74u w=0.15u l=0.13u
X117 VDD.t1091 6to4_0.buff_PI_d32_0.buff_PI_d16$1_0.inv_PI_d8$1_0.VOUT.t27 6to4_0.buff_PI_d32_0.inv_PI_d16$1_0.VIN.t10 VDD.t341 sg13_lv_pmos ad=0.1005p pd=1.34u as=55.5f ps=0.74u w=0.15u l=0.13u
X118 6to4_0.buff_PI_d32_1.inv_PI_d32_0.VIN 6to4_0.buff_PI_d32_1.inv_PI_d16$1_0.VIN VSS.t1925 VSS.t1924 sg13_lv_nmos ad=55.5f pd=0.74u as=0.1005p ps=1.34u w=0.15u l=0.13u
X119 VDD.t1276 6to4_0.buff_PI_d32_1.inv_PI_d16$1_0.VIN 6to4_0.buff_PI_d32_1.inv_PI_d32_0.VIN VDD.t173 sg13_lv_pmos ad=55.5f pd=0.74u as=55.5f ps=0.74u w=0.15u l=0.13u
X120 VSS.t718 6ph_rosc_0.psdiff_2.CLKP.t8 6ph_rosc_0.psdiff_2.buff_d8$1_1.VIN.t14 VSS.t1683 sg13_lv_nmos ad=55.5f pd=0.74u as=55.5f ps=0.74u w=0.15u l=0.13u
X121 6to4_0.buff_PI_d32_2.inv_PI_d32_0.VIN.t5 6to4_0.buff_PI_d32_2.inv_PI_d16$1_0.VIN.t49 VDD.t973 VDD.t126 sg13_lv_pmos ad=55.5f pd=0.74u as=0.1005p ps=1.34u w=0.15u l=0.13u
X122 6to4_0.buff_PI_d32_3.inv_PI_d32_0.VIN 6to4_0.buff_PI_d32_3.inv_PI_d16$1_0.VIN.t52 VSS.t1316 VSS.t1315 sg13_lv_nmos ad=55.5f pd=0.74u as=0.1005p ps=1.34u w=0.15u l=0.13u
X123 6ph_rosc_0.PH5.t7 6ph_rosc_0.buff_d8$1_1.inv_d8$1_0.VIN VDD.t322 VDD.t75 sg13_lv_pmos ad=55.5f pd=0.74u as=0.1005p ps=1.34u w=0.15u l=0.13u
X124 VSS.t83 6ph_rosc_0.buff_d8$1_5.inv_d8$1_0.VIN 6ph_rosc_0.PH0.t3 VSS.t82 sg13_lv_nmos ad=0.1005p pd=1.34u as=55.5f ps=0.74u w=0.15u l=0.13u
X125 VSS.t1192 6to4_0.buff_PI_d32_2.buff_PI_d16$1_0.inv_PI_d8$1_0.VOUT.t27 6to4_0.buff_PI_d32_2.inv_PI_d16$1_0.VIN.t13 VSS.t1191 sg13_lv_nmos ad=0.1005p pd=1.34u as=55.5f ps=0.74u w=0.15u l=0.13u
X126 VSS.t701 6ph_rosc_0.psdiff_2.CLKN 6ph_rosc_0.psdiff_2.buff_d8$1_0.VIN.t21 VSS.t693 sg13_lv_nmos ad=55.5f pd=0.74u as=55.5f ps=0.74u w=0.15u l=0.13u
X127 6to4_0.buff_PI_d32_0.buff_PI_d16$1_0.inv_PI_d4$1_0.VIN 6to4_0.flywheel_clk_0.PH0 VSS.t23 VSS.t22 sg13_lv_nmos ad=55.5f pd=0.74u as=0.1005p ps=1.34u w=0.15u l=0.13u
X128 VSS.t1787 6to4_0.buff_PI_d32_1.buff_PI_d16$1_0.inv_PI_d8$1_0.VOUT.t28 6to4_0.buff_PI_d32_1.inv_PI_d16$1_0.VIN VSS.t1786 sg13_lv_nmos ad=0.1005p pd=1.34u as=55.5f ps=0.74u w=0.15u l=0.13u
X129 PH180.t58 6to4_0.buff_PI_d32_3.inv_PI_d32_0.VIN VDD.t767 VDD.t99 sg13_lv_pmos ad=55.5f pd=0.74u as=0.1005p ps=1.34u w=0.15u l=0.13u
X130 VDD.t434 6to4_0.buff_PI_d32_0.inv_PI_d32_0.VIN PH90.t47 VDD.t347 sg13_lv_pmos ad=0.1005p pd=1.34u as=55.5f ps=0.74u w=0.15u l=0.13u
X131 6ph_rosc_0.psdiff_2.buff_d8$1_1.VIN.t13 6ph_rosc_0.psdiff_2.CLKP.t8 VSS.t1692 VSS.t1693 sg13_lv_nmos ad=55.5f pd=0.74u as=55.5f ps=0.74u w=0.15u l=0.13u
X132 VDD.t33 6ph_rosc_0.psdiff_2.buff_d8$1_1.inv_d4$1_0.VIN 6ph_rosc_0.psdiff_2.buff_d8$1_1.inv_d8$1_0.VIN VDD.t0 sg13_lv_pmos ad=0.1005p pd=1.34u as=55.5f ps=0.74u w=0.15u l=0.13u
X133 CTRL 6ph_rosc_0.PH2.t10 CTRL VDD.t89 sg13_lv_pmos ad=0.19p pd=1.38u as=0 ps=0 w=1u l=0.13u
X134 6to4_0.buff_PI_d32_3.inv_PI_d16$1_0.VIN.t9 6to4_0.buff_PI_d32_3.buff_PI_d16$1_0.inv_PI_d8$1_0.VOUT.t27 VSS.t1803 VSS.t1802 sg13_lv_nmos ad=55.5f pd=0.74u as=0.1005p ps=1.34u w=0.15u l=0.13u
X135 PH0.t86 6to4_0.buff_PI_d32_1.inv_PI_d32_0.VIN VDD.t592 VDD.t17 sg13_lv_pmos ad=55.5f pd=0.74u as=55.5f ps=0.74u w=0.15u l=0.13u
X136 VDD.t203 6to4_0.buff_PI_d32_2.inv_PI_d32_0.VIN.t49 PH270.t91 VDD.t202 sg13_lv_pmos ad=55.5f pd=0.74u as=0.1005p ps=1.34u w=0.15u l=0.13u
X137 VDD.t567 6to4_0.buff_PI_d32_1.inv_PI_d32_0.VIN PH0.t70 VDD.t552 sg13_lv_pmos ad=55.5f pd=0.74u as=55.5f ps=0.74u w=0.15u l=0.13u
X138 VSS.t127 6ph_rosc_0.buff_d8$1_0.inv_d4$1_0.VIN 6ph_rosc_0.buff_d8$1_0.inv_d8$1_0.VIN VSS.t126 sg13_lv_nmos ad=0.1005p pd=1.34u as=55.5f ps=0.74u w=0.15u l=0.13u
X139 6to4_0.buff_PI_d32_3.buff_PI_d16$1_0.inv_PI_d4$1_0.VOUT.t3 6to4_0.buff_PI_d32_3.buff_PI_d16$1_0.inv_PI_d4$1_0.VIN VSS.t151 VSS.t150 sg13_lv_nmos ad=55.5f pd=0.74u as=0.1005p ps=1.34u w=0.15u l=0.13u
X140 VDD.t976 6to4_0.buff_PI_d32_2.inv_PI_d16$1_0.VIN.t50 6to4_0.buff_PI_d32_2.inv_PI_d32_0.VIN.t7 VDD.t126 sg13_lv_pmos ad=0.1005p pd=1.34u as=55.5f ps=0.74u w=0.15u l=0.13u
X141 6to4_0.PI_clk_1.inv_PI_d2$1_0.VOUT 6ph_rosc_0.PH5.t10 VSS.t1660 VSS.t1659 sg13_lv_nmos ad=55.5f pd=0.74u as=0.1005p ps=1.34u w=0.15u l=0.13u
X142 6ph_rosc_0.PH0.t2 6ph_rosc_0.buff_d8$1_5.inv_d8$1_0.VIN VSS.t81 VSS.t80 sg13_lv_nmos ad=55.5f pd=0.74u as=0.1005p ps=1.34u w=0.15u l=0.13u
X143 VSS.t522 6to4_0.inv_PI_d2$1_2.VOUT 6to4_0.buff_PI_d32_3.buff_PI_d16$1_0.inv_PI_d4$1_0.VIN VSS.t521 sg13_lv_nmos ad=0.1005p pd=1.34u as=55.5f ps=0.74u w=0.15u l=0.13u
X144 6to4_0.buff_PI_d32_3.inv_PI_d32_0.VIN 6to4_0.buff_PI_d32_3.inv_PI_d16$1_0.VIN.t53 VDD.t879 VDD.t679 sg13_lv_pmos ad=0.1005p pd=1.34u as=55.5f ps=0.74u w=0.15u l=0.13u
X145 PH270.t30 6to4_0.buff_PI_d32_2.inv_PI_d32_0.VIN.t59 VSS.t378 VSS.t377 sg13_lv_nmos ad=55.5f pd=0.74u as=0.1005p ps=1.34u w=0.15u l=0.13u
X146 6ph_rosc_0.psdiff_2.buff_d8$1_1.VIN.t12 6ph_rosc_0.psdiff_2.CLKP.t8 VSS.t1699 VSS.t1689 sg13_lv_nmos ad=55.5f pd=0.74u as=55.5f ps=0.74u w=0.15u l=0.13u
X147 CTRL 6ph_rosc_0.PH2.t10 CTRL VDD.t440 sg13_lv_pmos ad=0.19p pd=1.38u as=0 ps=0 w=1u l=0.13u
X148 PH90.t74 6to4_0.buff_PI_d32_0.inv_PI_d32_0.VIN VDD.t433 VDD.t5 sg13_lv_pmos ad=55.5f pd=0.74u as=0.1005p ps=1.34u w=0.15u l=0.13u
X149 VSS.t1127 6to4_0.buff_PI_d32_3.inv_PI_d32_0.VIN PH180.t31 VSS.t1126 sg13_lv_nmos ad=0.1005p pd=1.34u as=55.5f ps=0.74u w=0.15u l=0.13u
X150 VDD.t603 6to4_0.buff_PI_d32_1.inv_PI_d32_0.VIN PH0.t93 VDD.t552 sg13_lv_pmos ad=55.5f pd=0.74u as=0.1005p ps=1.34u w=0.15u l=0.13u
X151 VDD.t535 6ph_rosc_0.psdiff_2.buff_d8$1_1.inv_d8$1_0.VIN 6ph_rosc_0.psdiff_2.VOUTDN VDD.t0 sg13_lv_pmos ad=0.1005p pd=1.34u as=55.5f ps=0.74u w=0.15u l=0.13u
X152 VDD.t835 6to4_0.buff_PI_d32_0.buff_PI_d16$1_0.inv_PI_d4$1_0.VOUT.t12 6to4_0.buff_PI_d32_0.buff_PI_d16$1_0.inv_PI_d8$1_0.VOUT.t1 VDD.t341 sg13_lv_pmos ad=55.5f pd=0.74u as=55.5f ps=0.74u w=0.15u l=0.13u
X153 VDD.t178 6to4_0.buff_PI_d32_1.buff_PI_d16$1_0.inv_PI_d4$1_0.VOUT.t13 6to4_0.buff_PI_d32_1.buff_PI_d16$1_0.inv_PI_d8$1_0.VOUT.t4 VDD.t173 sg13_lv_pmos ad=55.5f pd=0.74u as=0.1005p ps=1.34u w=0.15u l=0.13u
X154 CTRL 6ph_rosc_0.PH4.t10 CTRL VDD.t78 sg13_lv_pmos ad=0.19p pd=1.38u as=0 ps=0 w=1u l=0.13u
X155 6to4_0.buff_PI_d32_1.inv_PI_d32_0.VIN 6to4_0.buff_PI_d32_1.inv_PI_d16$1_0.VIN VSS.t1923 VSS.t1922 sg13_lv_nmos ad=55.5f pd=0.74u as=0.1005p ps=1.34u w=0.15u l=0.13u
X156 6ph_rosc_0.psdiff_2.buff_d8$1_0.VIN.t17 6ph_rosc_0.psdiff_2.CLKN VSS.t729 VSS.t717 sg13_lv_nmos ad=55.5f pd=0.74u as=55.5f ps=0.74u w=0.15u l=0.13u
X157 VSS.t207 6ph_rosc_0.psdiff_2.buff_d8$1_0.inv_d8$1_0.VIN 6ph_rosc_0.psdiff_2.VOUTDP VSS.t206 sg13_lv_nmos ad=0.1005p pd=1.34u as=55.5f ps=0.74u w=0.15u l=0.13u
X158 6ph_rosc_0.psdiff_2.buff_d8$1_0.VIN.t9 VSS.t1966 VDD.t1354 VDD.t470 sg13_lv_pmos ad=55.5f pd=0.74u as=55.5f ps=0.74u w=0.15u l=0.13u
X159 VSS.t1376 6to4_0.buff_PI_d32_0.inv_PI_d16$1_0.VIN.t48 6to4_0.buff_PI_d32_0.inv_PI_d32_0.VIN VSS.t1375 sg13_lv_nmos ad=0.1005p pd=1.34u as=55.5f ps=0.74u w=0.15u l=0.13u
X160 6to4_0.buff_PI_d32_1.buff_PI_d16$1_0.inv_PI_d4$1_0.VOUT.t3 6to4_0.buff_PI_d32_1.buff_PI_d16$1_0.inv_PI_d4$1_0.VIN VSS.t39 VSS.t38 sg13_lv_nmos ad=55.5f pd=0.74u as=0.1005p ps=1.34u w=0.15u l=0.13u
X161 VDD.t517 a_10947_2194# 6ph_rosc_0.psdiff_0.buff_d8$1_0.VIN.t12 VDD.t503 sg13_lv_pmos ad=55.5f pd=0.74u as=55.5f ps=0.74u w=0.15u l=0.13u
X162 VDD.t325 6to4_0.inv_PI_d2$1_3.VOUT 6to4_0.inv_PI_d2$1_2.VOUT VDD.t99 sg13_lv_pmos ad=55.5f pd=0.74u as=0.1005p ps=1.34u w=0.15u l=0.13u
X163 VSS.t21 6to4_0.flywheel_clk_0.PH0 6to4_0.buff_PI_d32_0.buff_PI_d16$1_0.inv_PI_d4$1_0.VIN VSS.t20 sg13_lv_nmos ad=0.1005p pd=1.34u as=55.5f ps=0.74u w=0.15u l=0.13u
X164 6to4_0.buff_PI_d32_2.buff_PI_d16$1_0.inv_PI_d8$1_0.VOUT.t7 6to4_0.buff_PI_d32_2.buff_PI_d16$1_0.inv_PI_d4$1_0.VOUT.t13 VSS.t1540 VSS.t1539 sg13_lv_nmos ad=55.5f pd=0.74u as=0.1005p ps=1.34u w=0.15u l=0.13u
X165 6ph_rosc_0.PH2.t3 6ph_rosc_0.buff_d8$1_0.inv_d8$1_0.VIN VSS.t668 VSS.t667 sg13_lv_nmos ad=55.5f pd=0.74u as=0.1005p ps=1.34u w=0.15u l=0.13u
X166 6ph_rosc_0.buff_d8$1_2.inv_d4$1_0.VIN 6ph_rosc_0.buff_d8$1_2.inv_d2$1_0.VIN VSS.t167 VSS.t166 sg13_lv_nmos ad=55.5f pd=0.74u as=0.1005p ps=1.34u w=0.15u l=0.13u
X167 6ph_rosc_0.PH5.t3 6ph_rosc_0.buff_d8$1_1.inv_d8$1_0.VIN VSS.t490 VSS.t489 sg13_lv_nmos ad=55.5f pd=0.74u as=0.1005p ps=1.34u w=0.15u l=0.13u
X168 CTRL 6ph_rosc_0.PH1.t10 CTRL VDD.t80 sg13_lv_pmos ad=0.19p pd=1.38u as=0 ps=0 w=1u l=0.13u
X169 VDD.t432 6to4_0.buff_PI_d32_0.inv_PI_d32_0.VIN PH90.t44 VDD.t5 sg13_lv_pmos ad=0.1005p pd=1.34u as=55.5f ps=0.74u w=0.15u l=0.13u
X170 VDD.t597 6to4_0.buff_PI_d32_1.inv_PI_d32_0.VIN PH0.t47 VDD.t17 sg13_lv_pmos ad=55.5f pd=0.74u as=55.5f ps=0.74u w=0.15u l=0.13u
X171 6to4_0.buff_PI_d32_0.buff_PI_d16$1_0.inv_PI_d8$1_0.VOUT.t3 6to4_0.buff_PI_d32_0.buff_PI_d16$1_0.inv_PI_d4$1_0.VOUT.t13 VSS.t1262 VSS.t1261 sg13_lv_nmos ad=55.5f pd=0.74u as=0.1005p ps=1.34u w=0.15u l=0.13u
X172 6to4_0.buff_PI_d32_1.buff_PI_d16$1_0.inv_PI_d8$1_0.VOUT.t7 6to4_0.buff_PI_d32_1.buff_PI_d16$1_0.inv_PI_d4$1_0.VOUT.t14 VDD.t180 VDD.t173 sg13_lv_pmos ad=0.1005p pd=1.34u as=55.5f ps=0.74u w=0.15u l=0.13u
X173 VDD.t300 6ph_rosc_0.psdiff_0.buff_d8$1_1.inv_d4$1_0.VIN 6ph_rosc_0.psdiff_0.buff_d8$1_1.inv_d8$1_0.VIN VDD.t0 sg13_lv_pmos ad=0.1005p pd=1.34u as=55.5f ps=0.74u w=0.15u l=0.13u
X174 VDD.t883 6to4_0.buff_PI_d32_3.inv_PI_d16$1_0.VIN.t54 6to4_0.buff_PI_d32_3.inv_PI_d32_0.VIN VDD.t99 sg13_lv_pmos ad=0.1005p pd=1.34u as=55.5f ps=0.74u w=0.15u l=0.13u
X175 6to4_0.buff_PI_d32_2.inv_PI_d32_0.VIN.t11 6to4_0.buff_PI_d32_2.inv_PI_d16$1_0.VIN.t51 VDD.t977 VDD.t198 sg13_lv_pmos ad=55.5f pd=0.74u as=55.5f ps=0.74u w=0.15u l=0.13u
X176 6ph_rosc_0.psdiff_2.buff_d8$1_0.VIN.t23 6ph_rosc_0.psdiff_2.CLKN VSS.t707 VSS.t715 sg13_lv_nmos ad=55.5f pd=0.74u as=55.5f ps=0.74u w=0.15u l=0.13u
X177 6to4_0.buff_PI_d32_3.buff_PI_d16$1_0.inv_PI_d8$1_0.VOUT.t23 6to4_0.buff_PI_d32_3.buff_PI_d16$1_0.inv_PI_d4$1_0.VOUT.t12 VDD.t1028 VDD.t679 sg13_lv_pmos ad=0.1005p pd=1.34u as=55.5f ps=0.74u w=0.15u l=0.13u
X178 VSS.t1296 6ph_rosc_0.psdiff_0.buff_d8$1_0.inv_d4$1_0.VIN 6ph_rosc_0.psdiff_0.buff_d8$1_0.inv_d8$1_0.VIN VSS.t1295 sg13_lv_nmos ad=0.1005p pd=1.34u as=55.5f ps=0.74u w=0.15u l=0.13u
X179 VDD.t1379 VSS.t1966 6ph_rosc_0.psdiff_2.buff_d8$1_1.VIN.t24 VDD.t470 sg13_lv_pmos ad=0.1005p pd=1.34u as=55.5f ps=0.74u w=0.15u l=0.13u
X180 6ph_rosc_0.psdiff_2.buff_d8$1_0.VIN.t8 VSS.t1966 VDD.t1355 VDD.t470 sg13_lv_pmos ad=55.5f pd=0.74u as=55.5f ps=0.74u w=0.15u l=0.13u
X181 6ph_rosc_0.psdiff_1.VOUTDN 6ph_rosc_0.psdiff_1.buff_d8$1_1.inv_d8$1_0.VIN VSS.t278 VSS.t277 sg13_lv_nmos ad=55.5f pd=0.74u as=0.1005p ps=1.34u w=0.15u l=0.13u
X182 VSS.t1524 6to4_0.buff_PI_d32_3.buff_PI_d16$1_0.inv_PI_d4$1_0.VOUT.t13 6to4_0.buff_PI_d32_3.buff_PI_d16$1_0.inv_PI_d8$1_0.VOUT.t7 VSS.t1523 sg13_lv_nmos ad=0.1005p pd=1.34u as=55.5f ps=0.74u w=0.15u l=0.13u
X183 6to4_0.buff_PI_d32_1.inv_PI_d16$1_0.VIN 6to4_0.buff_PI_d32_1.buff_PI_d16$1_0.inv_PI_d8$1_0.VOUT.t25 VDD.t1193 VDD.t17 sg13_lv_pmos ad=55.5f pd=0.74u as=0.1005p ps=1.34u w=0.15u l=0.13u
X184 6ph_rosc_0.psdiff_2.VOUTDP 6ph_rosc_0.psdiff_2.buff_d8$1_0.inv_d8$1_0.VIN VSS.t205 VSS.t204 sg13_lv_nmos ad=55.5f pd=0.74u as=0.1005p ps=1.34u w=0.15u l=0.13u
X185 VDD.t671 6ph_rosc_0.buff_d8$1_0.inv_d2$1_0.VIN 6ph_rosc_0.buff_d8$1_0.inv_d4$1_0.VIN VDD.t87 sg13_lv_pmos ad=0.1005p pd=1.34u as=55.5f ps=0.74u w=0.15u l=0.13u
X186 VSS.t1125 6to4_0.buff_PI_d32_3.inv_PI_d32_0.VIN PH180.t21 VSS.t1124 sg13_lv_nmos ad=0.1005p pd=1.34u as=55.5f ps=0.74u w=0.15u l=0.13u
X187 PH180.t94 6to4_0.buff_PI_d32_3.inv_PI_d32_0.VIN VDD.t745 VDD.t99 sg13_lv_pmos ad=0.1005p pd=1.34u as=55.5f ps=0.74u w=0.15u l=0.13u
X188 VSS.t969 6to4_0.buff_PI_d32_1.inv_PI_d32_0.VIN PH0.t20 VSS.t968 sg13_lv_nmos ad=0.1005p pd=1.34u as=55.5f ps=0.74u w=0.15u l=0.13u
X189 PH270.t71 6to4_0.buff_PI_d32_2.inv_PI_d32_0.VIN.t60 VDD.t238 VDD.t198 sg13_lv_pmos ad=55.5f pd=0.74u as=55.5f ps=0.74u w=0.15u l=0.13u
X190 VSS.t767 6to4_0.inv_PI_d2$1_1.VIN 6to4_0.flywheel_clk_1.PH0 VSS.t766 sg13_lv_nmos ad=0.1005p pd=1.34u as=55.5f ps=0.74u w=0.15u l=0.13u
X191 6ph_rosc_0.buff_d8$1_5.inv_d8$1_0.VIN 6ph_rosc_0.buff_d8$1_5.inv_d4$1_0.VIN VDD.t467 VDD.t57 sg13_lv_pmos ad=55.5f pd=0.74u as=0.1005p ps=1.34u w=0.15u l=0.13u
X192 VDD.t1212 6to4_0.buff_PI_d32_3.buff_PI_d16$1_0.inv_PI_d8$1_0.VOUT.t28 6to4_0.buff_PI_d32_3.inv_PI_d16$1_0.VIN.t14 VDD.t679 sg13_lv_pmos ad=0.1005p pd=1.34u as=55.5f ps=0.74u w=0.15u l=0.13u
X193 a_9130_2338# CTRL 6ph_rosc_0.psdiff_1.buff_d8$1_0.VIN.t31 VSS.t224 sg13_lv_nmos ad=55.5f pd=0.74u as=0.1005p ps=1.34u w=0.15u l=0.13u
X194 CTRL 6ph_rosc_0.PH3.t11 CTRL VDD.t330 sg13_lv_pmos ad=0.19p pd=1.38u as=0 ps=0 w=1u l=0.13u
X195 VDD.t789 6to4_0.buff_PI_d32_2.buff_PI_d16$1_0.inv_PI_d8$1_0.VOUT.t28 6to4_0.buff_PI_d32_2.inv_PI_d16$1_0.VIN.t34 VDD.t126 sg13_lv_pmos ad=55.5f pd=0.74u as=55.5f ps=0.74u w=0.15u l=0.13u
X196 PH180.t79 6to4_0.buff_PI_d32_3.inv_PI_d32_0.VIN VDD.t738 VDD.t679 sg13_lv_pmos ad=55.5f pd=0.74u as=55.5f ps=0.74u w=0.15u l=0.13u
X197 6ph_rosc_0.psdiff_2.buff_d8$1_0.inv_d4$1_0.VIN 6ph_rosc_0.psdiff_2.buff_d8$1_0.inv_d2$1_0.VIN VDD.t165 VDD.t34 sg13_lv_pmos ad=55.5f pd=0.74u as=0.1005p ps=1.34u w=0.15u l=0.13u
X198 6ph_rosc_0.psdiff_1.VOUTDP 6ph_rosc_0.psdiff_1.buff_d8$1_0.inv_d8$1_0.VIN VDD.t662 VDD.t34 sg13_lv_pmos ad=55.5f pd=0.74u as=0.1005p ps=1.34u w=0.15u l=0.13u
X199 6ph_rosc_0.psdiff_1.buff_d8$1_0.VIN.t14 6ph_rosc_0.psdiff_2.VOUTDP VSS.t243 VSS.t234 sg13_lv_nmos ad=55.5f pd=0.74u as=55.5f ps=0.74u w=0.15u l=0.13u
X200 VSS.t520 6to4_0.inv_PI_d2$1_2.VOUT 6to4_0.flywheel_clk_1.PH0 VSS.t519 sg13_lv_nmos ad=0.1005p pd=1.34u as=55.5f ps=0.74u w=0.15u l=0.13u
X201 6ph_rosc_0.psdiff_1.VOUTDN 6ph_rosc_0.psdiff_1.buff_d8$1_1.inv_d8$1_0.VIN VDD.t162 VDD.t0 sg13_lv_pmos ad=55.5f pd=0.74u as=0.1005p ps=1.34u w=0.15u l=0.13u
X202 PH90.t86 6to4_0.buff_PI_d32_0.inv_PI_d32_0.VIN VDD.t380 VDD.t341 sg13_lv_pmos ad=55.5f pd=0.74u as=55.5f ps=0.74u w=0.15u l=0.13u
X203 VSS.t1544 6to4_0.buff_PI_d32_2.buff_PI_d16$1_0.inv_PI_d4$1_0.VOUT.t14 6to4_0.buff_PI_d32_2.buff_PI_d16$1_0.inv_PI_d8$1_0.VOUT.t5 VSS.t1543 sg13_lv_nmos ad=0.1005p pd=1.34u as=55.5f ps=0.74u w=0.15u l=0.13u
X204 PH0.t85 6to4_0.buff_PI_d32_1.inv_PI_d32_0.VIN VDD.t636 VDD.t173 sg13_lv_pmos ad=55.5f pd=0.74u as=0.1005p ps=1.34u w=0.15u l=0.13u
X205 VSS.t1608 6to4_0.buff_PI_d32_0.buff_PI_d16$1_0.inv_PI_d8$1_0.VOUT.t27 6to4_0.buff_PI_d32_0.inv_PI_d16$1_0.VIN.t9 VSS.t1607 sg13_lv_nmos ad=0.1005p pd=1.34u as=55.5f ps=0.74u w=0.15u l=0.13u
X206 CTRL 6ph_rosc_0.PH3.t11 CTRL VDD.t464 sg13_lv_pmos ad=0.19p pd=1.38u as=0 ps=0 w=1u l=0.13u
X207 VSS.t1921 6to4_0.buff_PI_d32_1.inv_PI_d16$1_0.VIN 6to4_0.buff_PI_d32_1.inv_PI_d32_0.VIN VSS.t1920 sg13_lv_nmos ad=0.1005p pd=1.34u as=55.5f ps=0.74u w=0.15u l=0.13u
X208 VSS.t1266 6to4_0.buff_PI_d32_0.buff_PI_d16$1_0.inv_PI_d4$1_0.VOUT.t14 6to4_0.buff_PI_d32_0.buff_PI_d16$1_0.inv_PI_d8$1_0.VOUT.t6 VSS.t1265 sg13_lv_nmos ad=0.1005p pd=1.34u as=55.5f ps=0.74u w=0.15u l=0.13u
X209 6ph_rosc_0.PH5.t6 6ph_rosc_0.buff_d8$1_1.inv_d8$1_0.VIN VDD.t321 VDD.t75 sg13_lv_pmos ad=55.5f pd=0.74u as=0.1005p ps=1.34u w=0.15u l=0.13u
X210 PH0.t28 6to4_0.buff_PI_d32_1.inv_PI_d32_0.VIN VSS.t967 VSS.t966 sg13_lv_nmos ad=55.5f pd=0.74u as=0.1005p ps=1.34u w=0.15u l=0.13u
X211 VDD.t764 6to4_0.buff_PI_d32_3.inv_PI_d32_0.VIN PH180.t84 VDD.t99 sg13_lv_pmos ad=0.1005p pd=1.34u as=55.5f ps=0.74u w=0.15u l=0.13u
X212 VDD.t981 6to4_0.buff_PI_d32_2.inv_PI_d16$1_0.VIN.t52 6to4_0.buff_PI_d32_2.inv_PI_d32_0.VIN.t13 VDD.t198 sg13_lv_pmos ad=55.5f pd=0.74u as=55.5f ps=0.74u w=0.15u l=0.13u
X213 VDD.t204 6to4_0.buff_PI_d32_2.inv_PI_d32_0.VIN.t49 PH270.t64 VDD.t202 sg13_lv_pmos ad=0.1005p pd=1.34u as=55.5f ps=0.74u w=0.15u l=0.13u
X214 VDD.t1259 6to4_0.buff_PI_d32_1.inv_PI_d16$1_0.VIN 6to4_0.buff_PI_d32_1.inv_PI_d32_0.VIN VDD.t17 sg13_lv_pmos ad=55.5f pd=0.74u as=0.1005p ps=1.34u w=0.15u l=0.13u
X215 PH180.t93 6to4_0.buff_PI_d32_3.inv_PI_d32_0.VIN VDD.t713 VDD.t99 sg13_lv_pmos ad=0.1005p pd=1.34u as=55.5f ps=0.74u w=0.15u l=0.13u
X216 VSS.t644 6to4_0.buff_PI_d32_0.inv_PI_d32_0.VIN PH90.t8 VSS.t643 sg13_lv_nmos ad=0.1005p pd=1.34u as=55.5f ps=0.74u w=0.15u l=0.13u
X217 VSS.t1811 6to4_0.buff_PI_d32_3.buff_PI_d16$1_0.inv_PI_d8$1_0.VOUT.t29 6to4_0.buff_PI_d32_3.inv_PI_d16$1_0.VIN.t15 VSS.t1810 sg13_lv_nmos ad=0.1005p pd=1.34u as=55.5f ps=0.74u w=0.15u l=0.13u
X218 6to4_0.buff_PI_d32_0.inv_PI_d32_0.VIN 6to4_0.buff_PI_d32_0.inv_PI_d16$1_0.VIN.t51 VDD.t929 VDD.t5 sg13_lv_pmos ad=0.1005p pd=1.34u as=55.5f ps=0.74u w=0.15u l=0.13u
X219 6to4_0.buff_PI_d32_0.inv_PI_d32_0.VIN 6to4_0.buff_PI_d32_0.inv_PI_d16$1_0.VIN.t52 VSS.t1392 VSS.t1391 sg13_lv_nmos ad=55.5f pd=0.74u as=0.1005p ps=1.34u w=0.15u l=0.13u
X220 6to4_0.buff_PI_d32_1.buff_PI_d16$1_0.inv_PI_d8$1_0.VOUT.t11 6to4_0.buff_PI_d32_1.buff_PI_d16$1_0.inv_PI_d4$1_0.VOUT.t15 VSS.t314 VSS.t313 sg13_lv_nmos ad=55.5f pd=0.74u as=0.1005p ps=1.34u w=0.15u l=0.13u
X221 VSS.t642 6to4_0.buff_PI_d32_0.inv_PI_d32_0.VIN PH90.t21 VSS.t641 sg13_lv_nmos ad=0.1005p pd=1.34u as=55.5f ps=0.74u w=0.15u l=0.13u
X222 6to4_0.buff_PI_d32_2.inv_PI_d32_0.VIN.t15 6to4_0.buff_PI_d32_2.inv_PI_d16$1_0.VIN.t53 VSS.t1460 VSS.t1459 sg13_lv_nmos ad=55.5f pd=0.74u as=0.1005p ps=1.34u w=0.15u l=0.13u
X223 VDD.t1298 6to4_0.buff_PI_d32_1.inv_PI_d16$1_0.VIN 6to4_0.buff_PI_d32_1.inv_PI_d32_0.VIN VDD.t173 sg13_lv_pmos ad=0.1005p pd=1.34u as=55.5f ps=0.74u w=0.15u l=0.13u
X224 6ph_rosc_0.psdiff_1.buff_d8$1_0.VIN.t28 a_7973_2194# VDD.t306 VDD.t301 sg13_lv_pmos ad=55.5f pd=0.74u as=55.5f ps=0.74u w=0.15u l=0.13u
X225 VDD.t1034 6to4_0.buff_PI_d32_3.buff_PI_d16$1_0.inv_PI_d4$1_0.VOUT.t14 6to4_0.buff_PI_d32_3.buff_PI_d16$1_0.inv_PI_d8$1_0.VOUT.t20 VDD.t679 sg13_lv_pmos ad=55.5f pd=0.74u as=55.5f ps=0.74u w=0.15u l=0.13u
X226 VSS.t684 6ph_rosc_0.buff_d8$1_2.inv_d8$1_0.VIN 6ph_rosc_0.PH4.t4 VSS.t683 sg13_lv_nmos ad=0.1005p pd=1.34u as=55.5f ps=0.74u w=0.15u l=0.13u
X227 VSS.t512 6ph_rosc_0.buff_d8$1_5.inv_d2$1_0.VIN 6ph_rosc_0.buff_d8$1_5.inv_d4$1_0.VIN VSS.t511 sg13_lv_nmos ad=0.1005p pd=1.34u as=55.5f ps=0.74u w=0.15u l=0.13u
X228 VSS.t711 6ph_rosc_0.psdiff_2.CLKN 6ph_rosc_0.psdiff_2.buff_d8$1_0.VIN.t26 VSS.t496 sg13_lv_nmos ad=55.5f pd=0.74u as=55.5f ps=0.74u w=0.15u l=0.13u
X229 CTRL 6ph_rosc_0.PH4.t10 CTRL VDD.t78 sg13_lv_pmos ad=0.19p pd=1.38u as=0 ps=0 w=1u l=0.13u
X230 PH0.t27 6to4_0.buff_PI_d32_1.inv_PI_d32_0.VIN VSS.t965 VSS.t964 sg13_lv_nmos ad=55.5f pd=0.74u as=0.1005p ps=1.34u w=0.15u l=0.13u
X231 6to4_0.buff_PI_d32_2.inv_PI_d32_0.VIN.t19 6to4_0.buff_PI_d32_2.inv_PI_d16$1_0.VIN.t54 VDD.t987 VDD.t126 sg13_lv_pmos ad=55.5f pd=0.74u as=55.5f ps=0.74u w=0.15u l=0.13u
X232 VSS.t386 6to4_0.buff_PI_d32_2.inv_PI_d32_0.VIN.t61 PH270.t23 VSS.t385 sg13_lv_nmos ad=0.1005p pd=1.34u as=55.5f ps=0.74u w=0.15u l=0.13u
X233 6ph_rosc_0.psdiff_0.buff_d8$1_0.VIN.t3 VSS.t1965 VDD.t1318 VDD.t503 sg13_lv_pmos ad=55.5f pd=0.74u as=55.5f ps=0.74u w=0.15u l=0.13u
X234 VDD.t384 6to4_0.buff_PI_d32_0.inv_PI_d32_0.VIN PH90.t41 VDD.t341 sg13_lv_pmos ad=55.5f pd=0.74u as=55.5f ps=0.74u w=0.15u l=0.13u
X235 PH90.t20 6to4_0.buff_PI_d32_0.inv_PI_d32_0.VIN VSS.t640 VSS.t639 sg13_lv_nmos ad=55.5f pd=0.74u as=0.1005p ps=1.34u w=0.15u l=0.13u
X236 6ph_rosc_0.psdiff_1.buff_d8$1_0.VIN.t27 a_7973_2194# VDD.t307 VDD.t301 sg13_lv_pmos ad=55.5f pd=0.74u as=55.5f ps=0.74u w=0.15u l=0.13u
X237 6to4_0.buff_PI_d32_3.buff_PI_d16$1_0.inv_PI_d4$1_0.VOUT.t11 6to4_0.buff_PI_d32_3.buff_PI_d16$1_0.inv_PI_d4$1_0.VIN VDD.t105 VDD.t99 sg13_lv_pmos ad=0.1005p pd=1.34u as=55.5f ps=0.74u w=0.15u l=0.13u
X238 VDD.t340 6to4_0.inv_PI_d2$1_2.VOUT 6to4_0.buff_PI_d32_3.buff_PI_d16$1_0.inv_PI_d4$1_0.VIN VDD.t99 sg13_lv_pmos ad=0.1005p pd=1.34u as=55.5f ps=0.74u w=0.15u l=0.13u
X239 6to4_0.buff_PI_d32_0.inv_PI_d16$1_0.VIN.t4 6to4_0.buff_PI_d32_0.buff_PI_d16$1_0.inv_PI_d8$1_0.VOUT.t25 VDD.t1084 VDD.t341 sg13_lv_pmos ad=55.5f pd=0.74u as=0.1005p ps=1.34u w=0.15u l=0.13u
X240 VDD.t95 6to4_0.PI_clk_1.inv_PI_d2$1_0.VOUT 6to4_0.buff_PI_d32_2.VIN VDD.t92 sg13_lv_pmos ad=55.5f pd=0.74u as=55.5f ps=0.74u w=0.15u l=0.13u
X241 VSS.t1785 6to4_0.buff_PI_d32_1.buff_PI_d16$1_0.inv_PI_d8$1_0.VOUT.t29 6to4_0.buff_PI_d32_1.inv_PI_d16$1_0.VIN VSS.t1784 sg13_lv_nmos ad=0.1005p pd=1.34u as=55.5f ps=0.74u w=0.15u l=0.13u
X242 6ph_rosc_0.psdiff_0.buff_d8$1_0.VIN.t6 VSS.t1965 VDD.t1328 VDD.t503 sg13_lv_pmos ad=55.5f pd=0.74u as=55.5f ps=0.74u w=0.15u l=0.13u
X243 6to4_0.buff_PI_d32_0.buff_PI_d16$1_0.inv_PI_d4$1_0.VOUT.t8 6to4_0.buff_PI_d32_0.buff_PI_d16$1_0.inv_PI_d4$1_0.VIN VDD.t62 VDD.t5 sg13_lv_pmos ad=55.5f pd=0.74u as=55.5f ps=0.74u w=0.15u l=0.13u
X244 VSS.t318 6to4_0.buff_PI_d32_1.buff_PI_d16$1_0.inv_PI_d4$1_0.VOUT.t16 6to4_0.buff_PI_d32_1.buff_PI_d16$1_0.inv_PI_d8$1_0.VOUT.t14 VSS.t317 sg13_lv_nmos ad=0.1005p pd=1.34u as=55.5f ps=0.74u w=0.15u l=0.13u
X245 6ph_rosc_0.psdiff_0.buff_d8$1_1.VIN.t14 a_12104_2338# VDD.t505 VDD.t503 sg13_lv_pmos ad=55.5f pd=0.74u as=55.5f ps=0.74u w=0.15u l=0.13u
X246 6to4_0.buff_PI_d32_2.inv_PI_d32_0.VIN.t21 6to4_0.buff_PI_d32_2.inv_PI_d16$1_0.VIN.t55 VSS.t1468 VSS.t1467 sg13_lv_nmos ad=55.5f pd=0.74u as=0.1005p ps=1.34u w=0.15u l=0.13u
X247 6to4_0.buff_PI_d32_2.buff_PI_d16$1_0.inv_PI_d4$1_0.VOUT.t3 6to4_0.buff_PI_d32_2.buff_PI_d16$1_0.inv_PI_d4$1_0.VIN VSS.t191 VSS.t190 sg13_lv_nmos ad=55.5f pd=0.74u as=0.1005p ps=1.34u w=0.15u l=0.13u
X248 6to4_0.buff_PI_d32_0.inv_PI_d16$1_0.VIN.t13 6to4_0.buff_PI_d32_0.buff_PI_d16$1_0.inv_PI_d8$1_0.VOUT.t28 VDD.t1093 VDD.t5 sg13_lv_pmos ad=55.5f pd=0.74u as=55.5f ps=0.74u w=0.15u l=0.13u
X249 6to4_0.buff_PI_d32_0.inv_PI_d32_0.VIN 6to4_0.buff_PI_d32_0.inv_PI_d16$1_0.VIN.t49 VSS.t1380 VSS.t1379 sg13_lv_nmos ad=55.5f pd=0.74u as=0.1005p ps=1.34u w=0.15u l=0.13u
X250 VSS.t963 6to4_0.buff_PI_d32_1.inv_PI_d32_0.VIN PH0.t10 VSS.t962 sg13_lv_nmos ad=0.1005p pd=1.34u as=55.5f ps=0.74u w=0.15u l=0.13u
X251 6to4_0.buff_PI_d32_1.inv_PI_d16$1_0.VIN 6to4_0.buff_PI_d32_1.buff_PI_d16$1_0.inv_PI_d8$1_0.VOUT.t30 VDD.t1192 VDD.t17 sg13_lv_pmos ad=55.5f pd=0.74u as=0.1005p ps=1.34u w=0.15u l=0.13u
X252 6ph_rosc_0.psdiff_0.buff_d8$1_0.VIN.t24 6ph_rosc_0.psdiff_1.VOUTDP VSS.t836 VSS.t825 sg13_lv_nmos ad=55.5f pd=0.74u as=55.5f ps=0.74u w=0.15u l=0.13u
X253 VSS.t726 6ph_rosc_0.psdiff_2.CLKN 6ph_rosc_0.psdiff_2.buff_d8$1_0.VIN.t25 VSS.t712 sg13_lv_nmos ad=0.1005p pd=1.34u as=55.5f ps=0.74u w=0.15u l=0.13u
X254 6to4_0.buff_PI_d32_0.inv_PI_d32_0.VIN 6to4_0.buff_PI_d32_0.inv_PI_d16$1_0.VIN.t50 VSS.t1384 VSS.t1383 sg13_lv_nmos ad=55.5f pd=0.74u as=0.1005p ps=1.34u w=0.15u l=0.13u
X255 6to4_0.buff_PI_d32_1.inv_PI_d32_0.VIN 6to4_0.buff_PI_d32_1.inv_PI_d16$1_0.VIN VDD.t1260 VDD.t173 sg13_lv_pmos ad=0.1005p pd=1.34u as=55.5f ps=0.74u w=0.15u l=0.13u
X256 VDD.t1362 VSS.t1966 6ph_rosc_0.psdiff_2.buff_d8$1_1.VIN.t23 VDD.t470 sg13_lv_pmos ad=55.5f pd=0.74u as=55.5f ps=0.74u w=0.15u l=0.13u
X257 6to4_0.buff_PI_d32_0.buff_PI_d16$1_0.inv_PI_d4$1_0.VOUT.t3 6to4_0.buff_PI_d32_0.buff_PI_d16$1_0.inv_PI_d4$1_0.VIN VSS.t99 VSS.t98 sg13_lv_nmos ad=55.5f pd=0.74u as=0.1005p ps=1.34u w=0.15u l=0.13u
X258 6ph_rosc_0.psdiff_0.buff_d8$1_1.VIN.t15 a_12104_2338# VDD.t508 VDD.t503 sg13_lv_pmos ad=55.5f pd=0.74u as=55.5f ps=0.74u w=0.15u l=0.13u
X259 VDD.t534 6ph_rosc_0.psdiff_2.buff_d8$1_1.inv_d8$1_0.VIN 6ph_rosc_0.psdiff_2.VOUTDN VDD.t0 sg13_lv_pmos ad=0.1005p pd=1.34u as=55.5f ps=0.74u w=0.15u l=0.13u
X260 PH90.t93 6to4_0.buff_PI_d32_0.inv_PI_d32_0.VIN VDD.t378 VDD.t343 sg13_lv_pmos ad=0.1005p pd=1.34u as=55.5f ps=0.74u w=0.15u l=0.13u
X261 6to4_0.buff_PI_d32_1.inv_PI_d16$1_0.VIN 6to4_0.buff_PI_d32_1.buff_PI_d16$1_0.inv_PI_d8$1_0.VOUT.t31 VSS.t1783 VSS.t1782 sg13_lv_nmos ad=55.5f pd=0.74u as=0.1005p ps=1.34u w=0.15u l=0.13u
X262 VSS.t284 6ph_rosc_0.psdiff_2.buff_d8$1_0.inv_d2$1_0.VIN 6ph_rosc_0.psdiff_2.buff_d8$1_0.inv_d4$1_0.VIN VSS.t283 sg13_lv_nmos ad=0.1005p pd=1.34u as=55.5f ps=0.74u w=0.15u l=0.13u
X263 VSS.t989 6ph_rosc_0.psdiff_1.buff_d8$1_0.inv_d8$1_0.VIN 6ph_rosc_0.psdiff_1.VOUTDP VSS.t988 sg13_lv_nmos ad=0.1005p pd=1.34u as=55.5f ps=0.74u w=0.15u l=0.13u
X264 PH0.t74 6to4_0.buff_PI_d32_1.inv_PI_d32_0.VIN VDD.t635 VDD.t17 sg13_lv_pmos ad=55.5f pd=0.74u as=0.1005p ps=1.34u w=0.15u l=0.13u
X265 VDD.t189 6to4_0.buff_PI_d32_1.buff_PI_d16$1_0.inv_PI_d4$1_0.VOUT.t17 6to4_0.buff_PI_d32_1.buff_PI_d16$1_0.inv_PI_d8$1_0.VOUT.t16 VDD.t173 sg13_lv_pmos ad=55.5f pd=0.74u as=55.5f ps=0.74u w=0.15u l=0.13u
X266 VDD.t47 6to4_0.flywheel_clk_1.PH0 6to4_0.buff_PI_d32_1.buff_PI_d16$1_0.inv_PI_d4$1_0.VIN VDD.t17 sg13_lv_pmos ad=0.1005p pd=1.34u as=55.5f ps=0.74u w=0.15u l=0.13u
X267 VSS.t817 6ph_rosc_0.psdiff_1.VOUTDP 6ph_rosc_0.psdiff_0.buff_d8$1_0.VIN.t29 VSS.t495 sg13_lv_nmos ad=55.5f pd=0.74u as=55.5f ps=0.74u w=0.15u l=0.13u
X268 VSS.t1919 6to4_0.buff_PI_d32_1.inv_PI_d16$1_0.VIN 6to4_0.buff_PI_d32_1.inv_PI_d32_0.VIN VSS.t1918 sg13_lv_nmos ad=0.1005p pd=1.34u as=55.5f ps=0.74u w=0.15u l=0.13u
X269 6to4_0.buff_PI_d32_2.inv_PI_d16$1_0.VIN.t37 6to4_0.buff_PI_d32_2.buff_PI_d16$1_0.inv_PI_d8$1_0.VOUT.t29 VDD.t793 VDD.t126 sg13_lv_pmos ad=55.5f pd=0.74u as=0.1005p ps=1.34u w=0.15u l=0.13u
X270 VSS.t276 6ph_rosc_0.psdiff_1.buff_d8$1_1.inv_d8$1_0.VIN 6ph_rosc_0.psdiff_1.VOUTDN VSS.t275 sg13_lv_nmos ad=0.1005p pd=1.34u as=55.5f ps=0.74u w=0.15u l=0.13u
X271 PH270.t24 6to4_0.buff_PI_d32_2.inv_PI_d32_0.VIN.t62 VSS.t390 VSS.t389 sg13_lv_nmos ad=55.5f pd=0.74u as=0.1005p ps=1.34u w=0.15u l=0.13u
X272 VSS.t1001 6to4_0.buff_PI_d32_2.VIN 6to4_0.buff_PI_d32_2.buff_PI_d16$1_0.inv_PI_d4$1_0.VIN VSS.t1000 sg13_lv_nmos ad=0.1005p pd=1.34u as=55.5f ps=0.74u w=0.15u l=0.13u
X273 6ph_rosc_0.PH2.t2 6ph_rosc_0.buff_d8$1_0.inv_d8$1_0.VIN VSS.t666 VSS.t665 sg13_lv_nmos ad=55.5f pd=0.74u as=0.1005p ps=1.34u w=0.15u l=0.13u
X274 CTRL 6ph_rosc_0.PH3.t11 CTRL VDD.t464 sg13_lv_pmos ad=0.19p pd=1.38u as=0 ps=0 w=1u l=0.13u
X275 VDD.t935 6to4_0.buff_PI_d32_0.inv_PI_d16$1_0.VIN.t53 6to4_0.buff_PI_d32_0.inv_PI_d32_0.VIN VDD.t341 sg13_lv_pmos ad=55.5f pd=0.74u as=0.1005p ps=1.34u w=0.15u l=0.13u
X276 VSS.t1368 6ph_rosc_0.PH1.t12 6to4_0.PI_clk_0.inv_PI_d2$1_0.VOUT VSS.t1367 sg13_lv_nmos ad=0.1005p pd=1.34u as=55.5f ps=0.74u w=0.15u l=0.13u
X277 6to4_0.PI_clk_1.inv_PI_d2$1_0.VOUT 6ph_rosc_0.PH5.t11 VDD.t1134 VDD.t1128 sg13_lv_pmos ad=55.5f pd=0.74u as=0.1005p ps=1.34u w=0.15u l=0.13u
X278 VSS.t1948 6ph_rosc_0.psdiff_1.VOUTDN 6ph_rosc_0.psdiff_0.buff_d8$1_1.VIN.t30 VSS.t497 sg13_lv_nmos ad=55.5f pd=0.74u as=55.5f ps=0.74u w=0.15u l=0.13u
X279 CTRL 6ph_rosc_0.PH5.t12 CTRL VDD.t85 sg13_lv_pmos ad=0.19p pd=1.38u as=0 ps=0 w=1u l=0.13u
X280 6to4_0.buff_PI_d32_2.inv_PI_d16$1_0.VIN.t46 6to4_0.buff_PI_d32_2.buff_PI_d16$1_0.inv_PI_d8$1_0.VOUT.t30 VDD.t794 VDD.t198 sg13_lv_pmos ad=0.1005p pd=1.34u as=55.5f ps=0.74u w=0.15u l=0.13u
X281 6to4_0.buff_PI_d32_2.VIN 6to4_0.PI_clk_1.inv_PI_d2$1_0.VOUT VDD.t93 VDD.t92 sg13_lv_pmos ad=55.5f pd=0.74u as=55.5f ps=0.74u w=0.15u l=0.13u
X282 6to4_0.inv_PI_d2$1_3.VOUT 6ph_rosc_0.PH3.t12 VDD.t1250 VDD.t99 sg13_lv_pmos ad=55.5f pd=0.74u as=55.5f ps=0.74u w=0.15u l=0.13u
X283 VDD.t502 6ph_rosc_0.psdiff_0.buff_d8$1_1.inv_d8$1_0.VIN 6ph_rosc_0.psdiff_2.CLKP.t6 VDD.t0 sg13_lv_pmos ad=0.1005p pd=1.34u as=55.5f ps=0.74u w=0.15u l=0.13u
X284 6to4_0.buff_PI_d32_0.buff_PI_d16$1_0.inv_PI_d4$1_0.VOUT.t6 6to4_0.buff_PI_d32_0.buff_PI_d16$1_0.inv_PI_d4$1_0.VIN VDD.t69 VDD.t5 sg13_lv_pmos ad=55.5f pd=0.74u as=0.1005p ps=1.34u w=0.15u l=0.13u
X285 PH270.t66 6to4_0.buff_PI_d32_2.inv_PI_d32_0.VIN.t63 VDD.t246 VDD.t202 sg13_lv_pmos ad=55.5f pd=0.74u as=55.5f ps=0.74u w=0.15u l=0.13u
X286 6ph_rosc_0.psdiff_0.buff_d8$1_1.inv_d8$1_0.VIN 6ph_rosc_0.psdiff_0.buff_d8$1_1.inv_d4$1_0.VIN VDD.t299 VDD.t0 sg13_lv_pmos ad=55.5f pd=0.74u as=0.1005p ps=1.34u w=0.15u l=0.13u
X287 6ph_rosc_0.buff_d8$1_4.inv_d4$1_0.VIN 6ph_rosc_0.buff_d8$1_4.inv_d2$1_0.VIN VSS.t791 VSS.t790 sg13_lv_nmos ad=55.5f pd=0.74u as=0.1005p ps=1.34u w=0.15u l=0.13u
X288 CTRL 6ph_rosc_0.PH3.t11 CTRL VDD.t464 sg13_lv_pmos ad=0.19p pd=1.38u as=0 ps=0 w=1u l=0.13u
X289 6to4_0.buff_PI_d32_0.inv_PI_d16$1_0.VIN.t15 6to4_0.buff_PI_d32_0.buff_PI_d16$1_0.inv_PI_d8$1_0.VOUT.t29 VSS.t1616 VSS.t1615 sg13_lv_nmos ad=55.5f pd=0.74u as=0.1005p ps=1.34u w=0.15u l=0.13u
X290 VDD.t1099 6to4_0.buff_PI_d32_0.buff_PI_d16$1_0.inv_PI_d8$1_0.VOUT.t30 6to4_0.buff_PI_d32_0.inv_PI_d16$1_0.VIN.t19 VDD.t5 sg13_lv_pmos ad=55.5f pd=0.74u as=55.5f ps=0.74u w=0.15u l=0.13u
X291 VDD.t457 6ph_rosc_0.buff_d8$1_2.inv_d8$1_0.VIN 6ph_rosc_0.PH4.t7 VDD.t330 sg13_lv_pmos ad=0.1005p pd=1.34u as=55.5f ps=0.74u w=0.15u l=0.13u
X292 6ph_rosc_0.psdiff_0.buff_d8$1_1.VIN.t21 6ph_rosc_0.psdiff_1.VOUTDN VSS.t1962 VSS.t1939 sg13_lv_nmos ad=55.5f pd=0.74u as=0.1005p ps=1.34u w=0.15u l=0.13u
X293 6ph_rosc_0.psdiff_2.buff_d8$1_0.inv_d8$1_0.VIN 6ph_rosc_0.psdiff_2.buff_d8$1_0.inv_d4$1_0.VIN VSS.t159 VSS.t158 sg13_lv_nmos ad=55.5f pd=0.74u as=0.1005p ps=1.34u w=0.15u l=0.13u
X294 VDD.t1174 6to4_0.buff_PI_d32_1.buff_PI_d16$1_0.inv_PI_d8$1_0.VOUT.t27 6to4_0.buff_PI_d32_1.inv_PI_d16$1_0.VIN VDD.t17 sg13_lv_pmos ad=55.5f pd=0.74u as=0.1005p ps=1.34u w=0.15u l=0.13u
X295 6to4_0.buff_PI_d32_2.inv_PI_d32_0.VIN.t24 6to4_0.buff_PI_d32_2.inv_PI_d16$1_0.VIN.t56 VSS.t1472 VSS.t1471 sg13_lv_nmos ad=55.5f pd=0.74u as=0.1005p ps=1.34u w=0.15u l=0.13u
X296 VDD.t1216 6to4_0.buff_PI_d32_3.buff_PI_d16$1_0.inv_PI_d8$1_0.VOUT.t30 6to4_0.buff_PI_d32_3.inv_PI_d16$1_0.VIN.t20 VDD.t99 sg13_lv_pmos ad=55.5f pd=0.74u as=55.5f ps=0.74u w=0.15u l=0.13u
X297 VDD.t1310 VSS.t1965 6ph_rosc_0.psdiff_0.buff_d8$1_1.VIN.t8 VDD.t503 sg13_lv_pmos ad=55.5f pd=0.74u as=55.5f ps=0.74u w=0.15u l=0.13u
X298 6ph_rosc_0.PH4.t9 6ph_rosc_0.buff_d8$1_2.inv_d8$1_0.VIN VDD.t456 VDD.t330 sg13_lv_pmos ad=55.5f pd=0.74u as=0.1005p ps=1.34u w=0.15u l=0.13u
X299 6ph_rosc_0.buff_d8$1_5.inv_d4$1_0.VIN 6ph_rosc_0.buff_d8$1_5.inv_d2$1_0.VIN VDD.t332 VDD.t330 sg13_lv_pmos ad=55.5f pd=0.74u as=0.1005p ps=1.34u w=0.15u l=0.13u
X300 6to4_0.buff_PI_d32_2.buff_PI_d16$1_0.inv_PI_d8$1_0.VOUT.t6 6to4_0.buff_PI_d32_2.buff_PI_d16$1_0.inv_PI_d4$1_0.VOUT.t15 VSS.t1548 VSS.t1547 sg13_lv_nmos ad=55.5f pd=0.74u as=0.1005p ps=1.34u w=0.15u l=0.13u
X301 6to4_0.buff_PI_d32_0.inv_PI_d32_0.VIN 6to4_0.buff_PI_d32_0.inv_PI_d16$1_0.VIN.t54 VSS.t1400 VSS.t1399 sg13_lv_nmos ad=55.5f pd=0.74u as=0.1005p ps=1.34u w=0.15u l=0.13u
X302 6to4_0.buff_PI_d32_1.inv_PI_d32_0.VIN 6to4_0.buff_PI_d32_1.inv_PI_d16$1_0.VIN VSS.t1917 VSS.t1916 sg13_lv_nmos ad=55.5f pd=0.74u as=0.1005p ps=1.34u w=0.15u l=0.13u
X303 VSS.t1781 6to4_0.buff_PI_d32_1.buff_PI_d16$1_0.inv_PI_d8$1_0.VOUT.t32 6to4_0.buff_PI_d32_1.inv_PI_d16$1_0.VIN VSS.t1780 sg13_lv_nmos ad=0.1005p pd=1.34u as=55.5f ps=0.74u w=0.15u l=0.13u
X304 VDD.t469 6ph_rosc_0.buff_d8$1_1.inv_d2$1_0.VIN 6ph_rosc_0.buff_d8$1_1.inv_d4$1_0.VIN VDD.t75 sg13_lv_pmos ad=0.1005p pd=1.34u as=55.5f ps=0.74u w=0.15u l=0.13u
X305 CTRL 6ph_rosc_0.PH0.t10 CTRL VDD.t57 sg13_lv_pmos ad=0.19p pd=1.38u as=0 ps=0 w=1u l=0.13u
X306 CTRL 6ph_rosc_0.PH4.t10 CTRL VDD.t78 sg13_lv_pmos ad=0.19p pd=1.38u as=0 ps=0 w=1u l=0.13u
X307 6to4_0.buff_PI_d32_2.inv_PI_d32_0.VIN.t29 6to4_0.buff_PI_d32_2.inv_PI_d16$1_0.VIN.t57 VDD.t997 VDD.t198 sg13_lv_pmos ad=55.5f pd=0.74u as=0.1005p ps=1.34u w=0.15u l=0.13u
X308 6ph_rosc_0.psdiff_1.VOUTDP 6ph_rosc_0.psdiff_1.buff_d8$1_0.inv_d8$1_0.VIN VDD.t661 VDD.t34 sg13_lv_pmos ad=55.5f pd=0.74u as=0.1005p ps=1.34u w=0.15u l=0.13u
X309 6ph_rosc_0.psdiff_2.CLKP.t7 6ph_rosc_0.psdiff_0.buff_d8$1_1.inv_d8$1_0.VIN VDD.t501 VDD.t0 sg13_lv_pmos ad=55.5f pd=0.74u as=0.1005p ps=1.34u w=0.15u l=0.13u
X310 VDD.t1401 VSS.t1967 6ph_rosc_0.psdiff_1.buff_d8$1_0.VIN.t24 VDD.t301 sg13_lv_pmos ad=55.5f pd=0.74u as=55.5f ps=0.74u w=0.15u l=0.13u
X311 VSS.t1328 6to4_0.buff_PI_d32_3.inv_PI_d16$1_0.VIN.t55 6to4_0.buff_PI_d32_3.inv_PI_d32_0.VIN VSS.t1327 sg13_lv_nmos ad=0.1005p pd=1.34u as=55.5f ps=0.74u w=0.15u l=0.13u
X312 PH0.t92 6to4_0.buff_PI_d32_1.inv_PI_d32_0.VIN VDD.t585 VDD.t547 sg13_lv_pmos ad=0.1005p pd=1.34u as=55.5f ps=0.74u w=0.15u l=0.13u
X313 VSS.t1258 6to4_0.buff_PI_d32_0.buff_PI_d16$1_0.inv_PI_d4$1_0.VOUT.t12 6to4_0.buff_PI_d32_0.buff_PI_d16$1_0.inv_PI_d8$1_0.VOUT.t0 VSS.t1257 sg13_lv_nmos ad=0.1005p pd=1.34u as=55.5f ps=0.74u w=0.15u l=0.13u
X314 6to4_0.flywheel_clk_0.PH0 6to4_0.buff_PI_d32_2.VIN VDD.t668 VDD.t9 sg13_lv_pmos ad=55.5f pd=0.74u as=0.1005p ps=1.34u w=0.15u l=0.13u
X315 VDD.t686 6to4_0.buff_PI_d32_3.inv_PI_d32_0.VIN PH180.t64 VDD.t673 sg13_lv_pmos ad=55.5f pd=0.74u as=55.5f ps=0.74u w=0.15u l=0.13u
X316 VDD.t1065 6ph_rosc_0.PH4.t11 6to4_0.PI_clk_1.inv_PI_d2$1_0.VOUT VDD.t126 sg13_lv_pmos ad=55.5f pd=0.74u as=0.1005p ps=1.34u w=0.15u l=0.13u
X317 6ph_rosc_0.psdiff_2.CLKN 6ph_rosc_0.psdiff_0.buff_d8$1_0.inv_d8$1_0.VIN VSS.t1592 VSS.t1591 sg13_lv_nmos ad=55.5f pd=0.74u as=0.1005p ps=1.34u w=0.15u l=0.13u
X318 CTRL 6ph_rosc_0.PH5.t12 CTRL VDD.t85 sg13_lv_pmos ad=0.19p pd=1.38u as=0 ps=0 w=1u l=0.13u
X319 6to4_0.buff_PI_d32_3.inv_PI_d32_0.VIN 6to4_0.buff_PI_d32_3.inv_PI_d16$1_0.VIN.t49 VSS.t1304 VSS.t1303 sg13_lv_nmos ad=55.5f pd=0.74u as=0.1005p ps=1.34u w=0.15u l=0.13u
X320 VSS.t1552 6to4_0.buff_PI_d32_2.buff_PI_d16$1_0.inv_PI_d4$1_0.VOUT.t16 6to4_0.buff_PI_d32_2.buff_PI_d16$1_0.inv_PI_d8$1_0.VOUT.t2 VSS.t1551 sg13_lv_nmos ad=0.1005p pd=1.34u as=55.5f ps=0.74u w=0.15u l=0.13u
X321 6to4_0.buff_PI_d32_1.inv_PI_d32_0.VIN 6to4_0.buff_PI_d32_1.inv_PI_d16$1_0.VIN VDD.t1287 VDD.t173 sg13_lv_pmos ad=55.5f pd=0.74u as=55.5f ps=0.74u w=0.15u l=0.13u
X322 CTRL 6ph_rosc_0.PH4.t10 CTRL VDD.t451 sg13_lv_pmos ad=0.19p pd=1.38u as=0 ps=0 w=1u l=0.13u
X323 6ph_rosc_0.psdiff_0.buff_d8$1_1.VIN.t23 6ph_rosc_0.psdiff_1.VOUTDN VSS.t1942 VSS.t493 sg13_lv_nmos ad=55.5f pd=0.74u as=55.5f ps=0.74u w=0.15u l=0.13u
X324 VSS.t1861 6ph_rosc_0.PH3.t13 6ph_rosc_0.PH0.t8 VSS.t1860 sg13_lv_nmos ad=0.1005p pd=1.34u as=55.5f ps=0.74u w=0.15u l=0.13u
X325 VDD.t250 6to4_0.buff_PI_d32_2.inv_PI_d32_0.VIN.t64 PH270.t90 VDD.t126 sg13_lv_pmos ad=55.5f pd=0.74u as=0.1005p ps=1.34u w=0.15u l=0.13u
X326 VDD.t169 6ph_rosc_0.buff_d8$1_3.inv_d4$1_0.VIN 6ph_rosc_0.buff_d8$1_3.inv_d8$1_0.VIN VDD.t75 sg13_lv_pmos ad=0.1005p pd=1.34u as=55.5f ps=0.74u w=0.15u l=0.13u
X327 6ph_rosc_0.psdiff_0.buff_d8$1_0.VIN.t2 VSS.t1965 VDD.t1337 VDD.t503 sg13_lv_pmos ad=55.5f pd=0.74u as=0.1005p ps=1.34u w=0.15u l=0.13u
X328 6to4_0.buff_PI_d32_3.inv_PI_d16$1_0.VIN.t22 6to4_0.buff_PI_d32_3.buff_PI_d16$1_0.inv_PI_d8$1_0.VOUT.t31 VDD.t1220 VDD.t99 sg13_lv_pmos ad=55.5f pd=0.74u as=55.5f ps=0.74u w=0.15u l=0.13u
X329 VDD.t541 a_9130_2338# 6ph_rosc_0.psdiff_1.buff_d8$1_1.VIN.t16 VDD.t301 sg13_lv_pmos ad=55.5f pd=0.74u as=55.5f ps=0.74u w=0.15u l=0.13u
X330 VSS.t1823 6to4_0.buff_PI_d32_3.buff_PI_d16$1_0.inv_PI_d8$1_0.VOUT.t32 6to4_0.buff_PI_d32_3.inv_PI_d16$1_0.VIN.t24 VSS.t1822 sg13_lv_nmos ad=0.1005p pd=1.34u as=55.5f ps=0.74u w=0.15u l=0.13u
X331 6to4_0.buff_PI_d32_0.inv_PI_d16$1_0.VIN.t23 6to4_0.buff_PI_d32_0.buff_PI_d16$1_0.inv_PI_d8$1_0.VOUT.t31 VDD.t1103 VDD.t341 sg13_lv_pmos ad=55.5f pd=0.74u as=0.1005p ps=1.34u w=0.15u l=0.13u
X332 PH90.t83 6to4_0.buff_PI_d32_0.inv_PI_d32_0.VIN VDD.t409 VDD.t343 sg13_lv_pmos ad=55.5f pd=0.74u as=55.5f ps=0.74u w=0.15u l=0.13u
X333 VDD.t799 6to4_0.buff_PI_d32_2.buff_PI_d16$1_0.inv_PI_d8$1_0.VOUT.t31 6to4_0.buff_PI_d32_2.inv_PI_d16$1_0.VIN.t38 VDD.t198 sg13_lv_pmos ad=0.1005p pd=1.34u as=55.5f ps=0.74u w=0.15u l=0.13u
X334 VDD.t725 6to4_0.buff_PI_d32_3.inv_PI_d32_0.VIN PH180.t92 VDD.t673 sg13_lv_pmos ad=55.5f pd=0.74u as=0.1005p ps=1.34u w=0.15u l=0.13u
X335 6ph_rosc_0.psdiff_0.buff_d8$1_1.VIN.t26 6ph_rosc_0.psdiff_1.VOUTDN VSS.t1951 VSS.t1947 sg13_lv_nmos ad=55.5f pd=0.74u as=55.5f ps=0.74u w=0.15u l=0.13u
X336 6ph_rosc_0.psdiff_1.buff_d8$1_0.VIN.t5 6ph_rosc_0.psdiff_2.VOUTDP VSS.t227 VSS.t220 sg13_lv_nmos ad=55.5f pd=0.74u as=55.5f ps=0.74u w=0.15u l=0.13u
X337 CTRL 6ph_rosc_0.PH4.t10 CTRL VDD.t451 sg13_lv_pmos ad=0.34p pd=2.68u as=0 ps=0 w=1u l=0.13u
X338 PH90.t66 6to4_0.buff_PI_d32_0.inv_PI_d32_0.VIN VDD.t428 VDD.t341 sg13_lv_pmos ad=55.5f pd=0.74u as=0.1005p ps=1.34u w=0.15u l=0.13u
X339 6to4_0.buff_PI_d32_1.inv_PI_d16$1_0.VIN 6to4_0.buff_PI_d32_1.buff_PI_d16$1_0.inv_PI_d8$1_0.VOUT.t33 VSS.t1779 VSS.t1778 sg13_lv_nmos ad=55.5f pd=0.74u as=0.1005p ps=1.34u w=0.15u l=0.13u
X340 CTRL 6ph_rosc_0.PH0.t10 CTRL VDD.t51 sg13_lv_pmos ad=0.19p pd=1.38u as=0 ps=0 w=1u l=0.13u
X341 VDD.t845 6to4_0.buff_PI_d32_0.buff_PI_d16$1_0.inv_PI_d4$1_0.VOUT.t15 6to4_0.buff_PI_d32_0.buff_PI_d16$1_0.inv_PI_d8$1_0.VOUT.t10 VDD.t341 sg13_lv_pmos ad=0.1005p pd=1.34u as=55.5f ps=0.74u w=0.15u l=0.13u
X342 PH90.t82 6to4_0.buff_PI_d32_0.inv_PI_d32_0.VIN VDD.t427 VDD.t347 sg13_lv_pmos ad=55.5f pd=0.74u as=0.1005p ps=1.34u w=0.15u l=0.13u
X343 VDD.t1349 VSS.t1966 6ph_rosc_0.psdiff_2.buff_d8$1_0.VIN.t4 VDD.t470 sg13_lv_pmos ad=55.5f pd=0.74u as=55.5f ps=0.74u w=0.15u l=0.13u
X344 VSS.t682 6ph_rosc_0.buff_d8$1_2.inv_d8$1_0.VIN 6ph_rosc_0.PH4.t3 VSS.t681 sg13_lv_nmos ad=0.1005p pd=1.34u as=55.5f ps=0.74u w=0.15u l=0.13u
X345 6to4_0.buff_PI_d32_1.inv_PI_d32_0.VIN 6to4_0.buff_PI_d32_1.inv_PI_d16$1_0.VIN VSS.t1915 VSS.t1914 sg13_lv_nmos ad=55.5f pd=0.74u as=0.1005p ps=1.34u w=0.15u l=0.13u
X346 VDD.t1105 6to4_0.buff_PI_d32_0.buff_PI_d16$1_0.inv_PI_d8$1_0.VOUT.t32 6to4_0.buff_PI_d32_0.inv_PI_d16$1_0.VIN.t26 VDD.t5 sg13_lv_pmos ad=55.5f pd=0.74u as=0.1005p ps=1.34u w=0.15u l=0.13u
X347 6ph_rosc_0.psdiff_1.buff_d8$1_0.VIN.t13 6ph_rosc_0.psdiff_2.VOUTDP VSS.t226 VSS.t218 sg13_lv_nmos ad=55.5f pd=0.74u as=55.5f ps=0.74u w=0.15u l=0.13u
X348 CTRL 6ph_rosc_0.PH0.t10 CTRL VDD.t51 sg13_lv_pmos ad=0.19p pd=1.38u as=0 ps=0 w=1u l=0.13u
X349 6to4_0.PI_clk_0.inv_PI_d2$1_0.VOUT 6ph_rosc_0.PH2.t11 VSS.t1672 VSS.t1671 sg13_lv_nmos ad=55.5f pd=0.74u as=0.1005p ps=1.34u w=0.15u l=0.13u
X350 6to4_0.buff_PI_d32_3.inv_PI_d16$1_0.VIN.t3 6to4_0.buff_PI_d32_3.buff_PI_d16$1_0.inv_PI_d8$1_0.VOUT.t25 VSS.t1795 VSS.t1794 sg13_lv_nmos ad=55.5f pd=0.74u as=0.1005p ps=1.34u w=0.15u l=0.13u
X351 VDD.t591 6to4_0.buff_PI_d32_1.inv_PI_d32_0.VIN PH0.t44 VDD.t173 sg13_lv_pmos ad=55.5f pd=0.74u as=55.5f ps=0.74u w=0.15u l=0.13u
X352 PH0.t23 6to4_0.buff_PI_d32_1.inv_PI_d32_0.VIN VSS.t961 VSS.t960 sg13_lv_nmos ad=55.5f pd=0.74u as=0.1005p ps=1.34u w=0.15u l=0.13u
X353 VSS.t302 6to4_0.buff_PI_d32_1.buff_PI_d16$1_0.inv_PI_d4$1_0.VOUT.t12 6to4_0.buff_PI_d32_1.buff_PI_d16$1_0.inv_PI_d8$1_0.VOUT.t2 VSS.t301 sg13_lv_nmos ad=0.1005p pd=1.34u as=55.5f ps=0.74u w=0.15u l=0.13u
X354 VSS.t690 6ph_rosc_0.buff_d8$1_4.inv_d4$1_0.VIN 6ph_rosc_0.buff_d8$1_4.inv_d8$1_0.VIN VSS.t689 sg13_lv_nmos ad=0.1005p pd=1.34u as=55.5f ps=0.74u w=0.15u l=0.13u
X355 VDD.t1359 VSS.t1966 6ph_rosc_0.psdiff_2.buff_d8$1_0.VIN.t3 VDD.t470 sg13_lv_pmos ad=55.5f pd=0.74u as=55.5f ps=0.74u w=0.15u l=0.13u
X356 VSS.t119 6ph_rosc_0.buff_d8$1_2.inv_d4$1_0.VIN 6ph_rosc_0.buff_d8$1_2.inv_d8$1_0.VIN VSS.t118 sg13_lv_nmos ad=0.1005p pd=1.34u as=55.5f ps=0.74u w=0.15u l=0.13u
X357 6to4_0.PI_clk_1.inv_PI_d2$1_0.VOUT 6ph_rosc_0.PH5.t11 VDD.t1132 VDD.t1128 sg13_lv_pmos ad=0.1005p pd=1.34u as=55.5f ps=0.74u w=0.15u l=0.13u
X358 PH270.t65 6to4_0.buff_PI_d32_2.inv_PI_d32_0.VIN.t58 VDD.t232 VDD.t126 sg13_lv_pmos ad=55.5f pd=0.74u as=0.1005p ps=1.34u w=0.15u l=0.13u
X359 VDD.t1056 6to4_0.buff_PI_d32_2.buff_PI_d16$1_0.inv_PI_d4$1_0.VOUT.t17 6to4_0.buff_PI_d32_2.buff_PI_d16$1_0.inv_PI_d8$1_0.VOUT.t11 VDD.t198 sg13_lv_pmos ad=55.5f pd=0.74u as=55.5f ps=0.74u w=0.15u l=0.13u
X360 6ph_rosc_0.psdiff_1.buff_d8$1_1.VIN.t3 VSS.t1967 VDD.t1397 VDD.t301 sg13_lv_pmos ad=55.5f pd=0.74u as=55.5f ps=0.74u w=0.15u l=0.13u
X361 VSS.t1123 6to4_0.buff_PI_d32_3.inv_PI_d32_0.VIN PH180.t19 VSS.t1122 sg13_lv_nmos ad=0.1005p pd=1.34u as=55.5f ps=0.74u w=0.15u l=0.13u
X362 VDD.t1089 6to4_0.buff_PI_d32_0.buff_PI_d16$1_0.inv_PI_d8$1_0.VOUT.t27 6to4_0.buff_PI_d32_0.inv_PI_d16$1_0.VIN.t11 VDD.t341 sg13_lv_pmos ad=55.5f pd=0.74u as=0.1005p ps=1.34u w=0.15u l=0.13u
X363 VSS.t466 6ph_rosc_0.psdiff_0.buff_d8$1_1.inv_d4$1_0.VIN 6ph_rosc_0.psdiff_0.buff_d8$1_1.inv_d8$1_0.VIN VSS.t465 sg13_lv_nmos ad=0.1005p pd=1.34u as=55.5f ps=0.74u w=0.15u l=0.13u
X364 PH0.t75 6to4_0.buff_PI_d32_1.inv_PI_d32_0.VIN VDD.t583 VDD.t547 sg13_lv_pmos ad=55.5f pd=0.74u as=55.5f ps=0.74u w=0.15u l=0.13u
X365 VDD.t393 6to4_0.buff_PI_d32_0.inv_PI_d32_0.VIN PH90.t62 VDD.t343 sg13_lv_pmos ad=55.5f pd=0.74u as=55.5f ps=0.74u w=0.15u l=0.13u
X366 VSS.t1444 6to4_0.buff_PI_d32_2.inv_PI_d16$1_0.VIN.t49 6to4_0.buff_PI_d32_2.inv_PI_d32_0.VIN.t3 VSS.t1443 sg13_lv_nmos ad=0.1005p pd=1.34u as=55.5f ps=0.74u w=0.15u l=0.13u
X367 6ph_rosc_0.buff_d8$1_3.inv_d8$1_0.VIN 6ph_rosc_0.buff_d8$1_3.inv_d4$1_0.VIN VDD.t168 VDD.t75 sg13_lv_pmos ad=55.5f pd=0.74u as=0.1005p ps=1.34u w=0.15u l=0.13u
X368 6to4_0.buff_PI_d32_0.buff_PI_d16$1_0.inv_PI_d4$1_0.VOUT.t11 6to4_0.buff_PI_d32_0.buff_PI_d16$1_0.inv_PI_d4$1_0.VIN VDD.t61 VDD.t5 sg13_lv_pmos ad=0.1005p pd=1.34u as=55.5f ps=0.74u w=0.15u l=0.13u
X369 VSS.t959 6to4_0.buff_PI_d32_1.inv_PI_d32_0.VIN PH0.t31 VSS.t958 sg13_lv_nmos ad=0.1005p pd=1.34u as=55.5f ps=0.74u w=0.15u l=0.13u
X370 VDD.t560 6to4_0.buff_PI_d32_1.inv_PI_d32_0.VIN PH0.t64 VDD.t547 sg13_lv_pmos ad=55.5f pd=0.74u as=55.5f ps=0.74u w=0.15u l=0.13u
X371 6to4_0.buff_PI_d32_0.inv_PI_d16$1_0.VIN.t0 6to4_0.buff_PI_d32_0.buff_PI_d16$1_0.inv_PI_d8$1_0.VOUT.t24 VSS.t1596 VSS.t1595 sg13_lv_nmos ad=55.5f pd=0.74u as=0.1005p ps=1.34u w=0.15u l=0.13u
X372 6to4_0.buff_PI_d32_1.buff_PI_d16$1_0.inv_PI_d4$1_0.VOUT.t10 6to4_0.buff_PI_d32_1.buff_PI_d16$1_0.inv_PI_d4$1_0.VIN VDD.t22 VDD.t17 sg13_lv_pmos ad=55.5f pd=0.74u as=55.5f ps=0.74u w=0.15u l=0.13u
X373 VSS.t1404 6to4_0.buff_PI_d32_0.inv_PI_d16$1_0.VIN.t55 6to4_0.buff_PI_d32_0.inv_PI_d32_0.VIN VSS.t1403 sg13_lv_nmos ad=0.1005p pd=1.34u as=55.5f ps=0.74u w=0.15u l=0.13u
X374 VSS.t472 6ph_rosc_0.buff_d8$1_1.inv_d4$1_0.VIN 6ph_rosc_0.buff_d8$1_1.inv_d8$1_0.VIN VSS.t471 sg13_lv_nmos ad=0.1005p pd=1.34u as=55.5f ps=0.74u w=0.15u l=0.13u
X375 CTRL 6ph_rosc_0.PH5.t12 CTRL VDD.t89 sg13_lv_pmos ad=0.19p pd=1.38u as=0 ps=0 w=1u l=0.13u
X376 VDD.t471 a_6156_2338# 6ph_rosc_0.psdiff_2.buff_d8$1_1.VIN.t30 VDD.t470 sg13_lv_pmos ad=55.5f pd=0.74u as=55.5f ps=0.74u w=0.15u l=0.13u
X377 6to4_0.buff_PI_d32_2.buff_PI_d16$1_0.inv_PI_d4$1_0.VOUT.t2 6to4_0.buff_PI_d32_2.buff_PI_d16$1_0.inv_PI_d4$1_0.VIN VSS.t189 VSS.t188 sg13_lv_nmos ad=55.5f pd=0.74u as=0.1005p ps=1.34u w=0.15u l=0.13u
X378 VDD.t1190 6to4_0.buff_PI_d32_1.buff_PI_d16$1_0.inv_PI_d8$1_0.VOUT.t34 6to4_0.buff_PI_d32_1.inv_PI_d16$1_0.VIN VDD.t173 sg13_lv_pmos ad=0.1005p pd=1.34u as=55.5f ps=0.74u w=0.15u l=0.13u
X379 PH180.t75 6to4_0.buff_PI_d32_3.inv_PI_d32_0.VIN VDD.t734 VDD.t677 sg13_lv_pmos ad=55.5f pd=0.74u as=55.5f ps=0.74u w=0.15u l=0.13u
X380 6ph_rosc_0.psdiff_1.buff_d8$1_1.VIN.t8 VSS.t1967 VDD.t1396 VDD.t301 sg13_lv_pmos ad=55.5f pd=0.74u as=55.5f ps=0.74u w=0.15u l=0.13u
X381 CTRL 6ph_rosc_0.PH2.t10 CTRL VDD.t89 sg13_lv_pmos ad=0.19p pd=1.38u as=0 ps=0 w=1u l=0.13u
X382 VDD.t615 6to4_0.buff_PI_d32_1.inv_PI_d32_0.VIN PH0.t91 VDD.t547 sg13_lv_pmos ad=55.5f pd=0.74u as=0.1005p ps=1.34u w=0.15u l=0.13u
X383 VDD.t254 6to4_0.buff_PI_d32_2.inv_PI_d32_0.VIN.t65 PH270.t38 VDD.t126 sg13_lv_pmos ad=0.1005p pd=1.34u as=55.5f ps=0.74u w=0.15u l=0.13u
X384 VSS.t987 6ph_rosc_0.psdiff_1.buff_d8$1_0.inv_d8$1_0.VIN 6ph_rosc_0.psdiff_1.VOUTDP VSS.t986 sg13_lv_nmos ad=0.1005p pd=1.34u as=55.5f ps=0.74u w=0.15u l=0.13u
X385 6ph_rosc_0.psdiff_2.VOUTDN 6ph_rosc_0.psdiff_2.buff_d8$1_1.inv_d8$1_0.VIN VDD.t533 VDD.t0 sg13_lv_pmos ad=55.5f pd=0.74u as=0.1005p ps=1.34u w=0.15u l=0.13u
X386 6ph_rosc_0.psdiff_2.buff_d8$1_1.VIN.t11 6ph_rosc_0.psdiff_2.CLKP.t8 VSS.t1695 VSS.t1693 sg13_lv_nmos ad=55.5f pd=0.74u as=55.5f ps=0.74u w=0.15u l=0.13u
X387 6ph_rosc_0.psdiff_2.buff_d8$1_1.inv_d4$1_0.VIN 6ph_rosc_0.psdiff_2.buff_d8$1_1.inv_d2$1_0.VIN VDD.t774 VDD.t0 sg13_lv_pmos ad=55.5f pd=0.74u as=0.1005p ps=1.34u w=0.15u l=0.13u
X388 VSS.t1676 6ph_rosc_0.PH2.t12 6to4_0.PI_clk_0.inv_PI_d2$1_0.VOUT VSS.t1675 sg13_lv_nmos ad=0.1005p pd=1.34u as=55.5f ps=0.74u w=0.15u l=0.13u
X389 PH270.t81 6to4_0.buff_PI_d32_2.inv_PI_d32_0.VIN.t66 VDD.t257 VDD.t215 sg13_lv_pmos ad=55.5f pd=0.74u as=0.1005p ps=1.34u w=0.15u l=0.13u
X390 PH180.t24 6to4_0.buff_PI_d32_3.inv_PI_d32_0.VIN VSS.t1121 VSS.t1120 sg13_lv_nmos ad=55.5f pd=0.74u as=0.1005p ps=1.34u w=0.15u l=0.13u
X391 PH0.t49 6to4_0.buff_PI_d32_1.inv_PI_d32_0.VIN VDD.t553 VDD.t552 sg13_lv_pmos ad=55.5f pd=0.74u as=55.5f ps=0.74u w=0.15u l=0.13u
X392 6to4_0.inv_PI_d2$1_1.VIN 6ph_rosc_0.PH0.t12 VSS.t1246 VSS.t1245 sg13_lv_nmos ad=55.5f pd=0.74u as=0.1005p ps=1.34u w=0.15u l=0.13u
X393 VDD.t544 a_9130_2338# 6ph_rosc_0.psdiff_1.buff_d8$1_1.VIN.t15 VDD.t301 sg13_lv_pmos ad=0.1005p pd=1.34u as=55.5f ps=0.74u w=0.15u l=0.13u
X394 CTRL 6ph_rosc_0.PH2.t10 CTRL VDD.t440 sg13_lv_pmos ad=0.19p pd=1.38u as=0 ps=0 w=1u l=0.13u
X395 VSS.t1153 6ph_rosc_0.psdiff_2.VOUTDN 6ph_rosc_0.psdiff_1.buff_d8$1_1.VIN.t30 VSS.t1154 sg13_lv_nmos ad=55.5f pd=0.74u as=55.5f ps=0.74u w=0.15u l=0.13u
X396 VSS.t826 6ph_rosc_0.psdiff_1.VOUTDN 6ph_rosc_0.psdiff_0.buff_d8$1_1.VIN.t28 VSS.t1938 sg13_lv_nmos ad=55.5f pd=0.74u as=55.5f ps=0.74u w=0.15u l=0.13u
X397 VSS.t638 6to4_0.buff_PI_d32_0.inv_PI_d32_0.VIN PH90.t5 VSS.t637 sg13_lv_nmos ad=0.1005p pd=1.34u as=55.5f ps=0.74u w=0.15u l=0.13u
X398 6to4_0.buff_PI_d32_3.buff_PI_d16$1_0.inv_PI_d4$1_0.VIN 6to4_0.inv_PI_d2$1_2.VOUT VSS.t518 VSS.t517 sg13_lv_nmos ad=55.5f pd=0.74u as=0.1005p ps=1.34u w=0.15u l=0.13u
X399 VDD.t867 6to4_0.buff_PI_d32_3.inv_PI_d16$1_0.VIN.t49 6to4_0.buff_PI_d32_3.inv_PI_d32_0.VIN VDD.t679 sg13_lv_pmos ad=0.1005p pd=1.34u as=55.5f ps=0.74u w=0.15u l=0.13u
X400 PH0.t4 6to4_0.buff_PI_d32_1.inv_PI_d32_0.VIN VSS.t957 VSS.t956 sg13_lv_nmos ad=55.5f pd=0.74u as=0.1005p ps=1.34u w=0.15u l=0.13u
X401 6ph_rosc_0.psdiff_2.buff_d8$1_1.VIN.t10 6ph_rosc_0.psdiff_2.CLKP.t8 VSS.t1697 VSS.t1689 sg13_lv_nmos ad=55.5f pd=0.74u as=55.5f ps=0.74u w=0.15u l=0.13u
X402 VDD.t500 6ph_rosc_0.psdiff_0.buff_d8$1_1.inv_d8$1_0.VIN 6ph_rosc_0.psdiff_2.CLKP.t7 VDD.t0 sg13_lv_pmos ad=0.1005p pd=1.34u as=55.5f ps=0.74u w=0.15u l=0.13u
X403 VSS.t636 6to4_0.buff_PI_d32_0.inv_PI_d32_0.VIN PH90.t17 VSS.t635 sg13_lv_nmos ad=0.1005p pd=1.34u as=55.5f ps=0.74u w=0.15u l=0.13u
X404 6to4_0.buff_PI_d32_1.inv_PI_d16$1_0.VIN 6to4_0.buff_PI_d32_1.buff_PI_d16$1_0.inv_PI_d8$1_0.VOUT.t35 VSS.t1777 VSS.t1776 sg13_lv_nmos ad=55.5f pd=0.74u as=0.1005p ps=1.34u w=0.15u l=0.13u
X405 VDD.t67 6to4_0.buff_PI_d32_0.buff_PI_d16$1_0.inv_PI_d4$1_0.VIN 6to4_0.buff_PI_d32_0.buff_PI_d16$1_0.inv_PI_d4$1_0.VOUT.t4 VDD.t5 sg13_lv_pmos ad=0.1005p pd=1.34u as=55.5f ps=0.74u w=0.15u l=0.13u
X406 VSS.t1632 6to4_0.buff_PI_d32_0.buff_PI_d16$1_0.inv_PI_d8$1_0.VOUT.t33 6to4_0.buff_PI_d32_0.inv_PI_d16$1_0.VIN.t27 VSS.t1631 sg13_lv_nmos ad=0.1005p pd=1.34u as=55.5f ps=0.74u w=0.15u l=0.13u
X407 VSS.t1119 6to4_0.buff_PI_d32_3.inv_PI_d32_0.VIN PH180.t30 VSS.t1118 sg13_lv_nmos ad=0.1005p pd=1.34u as=55.5f ps=0.74u w=0.15u l=0.13u
X408 6to4_0.buff_PI_d32_2.inv_PI_d16$1_0.VIN.t15 6to4_0.buff_PI_d32_2.buff_PI_d16$1_0.inv_PI_d8$1_0.VOUT.t26 VSS.t1188 VSS.t1187 sg13_lv_nmos ad=55.5f pd=0.74u as=0.1005p ps=1.34u w=0.15u l=0.13u
X409 VDD.t379 6to4_0.buff_PI_d32_0.inv_PI_d32_0.VIN PH90.t92 VDD.t343 sg13_lv_pmos ad=55.5f pd=0.74u as=0.1005p ps=1.34u w=0.15u l=0.13u
X410 VSS.t1476 6to4_0.buff_PI_d32_2.inv_PI_d16$1_0.VIN.t57 6to4_0.buff_PI_d32_2.inv_PI_d32_0.VIN.t27 VSS.t1475 sg13_lv_nmos ad=0.1005p pd=1.34u as=55.5f ps=0.74u w=0.15u l=0.13u
X411 6to4_0.buff_PI_d32_1.buff_PI_d16$1_0.inv_PI_d4$1_0.VIN 6to4_0.flywheel_clk_1.PH0 VDD.t46 VDD.t17 sg13_lv_pmos ad=55.5f pd=0.74u as=0.1005p ps=1.34u w=0.15u l=0.13u
X412 6ph_rosc_0.psdiff_0.buff_d8$1_0.inv_d8$1_0.VIN 6ph_rosc_0.psdiff_0.buff_d8$1_0.inv_d4$1_0.VIN VSS.t1294 VSS.t1293 sg13_lv_nmos ad=55.5f pd=0.74u as=0.1005p ps=1.34u w=0.15u l=0.13u
X413 CTRL 6ph_rosc_0.PH4.t10 CTRL VDD.t451 sg13_lv_pmos ad=0.19p pd=1.38u as=0 ps=0 w=1u l=0.13u
X414 6to4_0.buff_PI_d32_0.inv_PI_d16$1_0.VIN.t3 6to4_0.buff_PI_d32_0.buff_PI_d16$1_0.inv_PI_d8$1_0.VOUT.t25 VSS.t1600 VSS.t1599 sg13_lv_nmos ad=55.5f pd=0.74u as=0.1005p ps=1.34u w=0.15u l=0.13u
X415 6to4_0.buff_PI_d32_1.inv_PI_d16$1_0.VIN 6to4_0.buff_PI_d32_1.buff_PI_d16$1_0.inv_PI_d8$1_0.VOUT.t36 VDD.t1153 VDD.t173 sg13_lv_pmos ad=0.1005p pd=1.34u as=55.5f ps=0.74u w=0.15u l=0.13u
X416 6ph_rosc_0.PH4.t8 6ph_rosc_0.buff_d8$1_2.inv_d8$1_0.VIN VDD.t455 VDD.t451 sg13_lv_pmos ad=55.5f pd=0.74u as=0.1005p ps=1.34u w=0.15u l=0.13u
X417 PH270.t80 6to4_0.buff_PI_d32_2.inv_PI_d32_0.VIN.t55 VDD.t222 VDD.t198 sg13_lv_pmos ad=55.5f pd=0.74u as=55.5f ps=0.74u w=0.15u l=0.13u
X418 PH180.t23 6to4_0.buff_PI_d32_3.inv_PI_d32_0.VIN VSS.t1117 VSS.t1116 sg13_lv_nmos ad=55.5f pd=0.74u as=0.1005p ps=1.34u w=0.15u l=0.13u
X419 VDD.t946 6to4_0.buff_PI_d32_0.inv_PI_d16$1_0.VIN.t56 6to4_0.buff_PI_d32_0.inv_PI_d32_0.VIN VDD.t5 sg13_lv_pmos ad=0.1005p pd=1.34u as=55.5f ps=0.74u w=0.15u l=0.13u
X420 CTRL 6ph_rosc_0.PH0.t10 CTRL VDD.t51 sg13_lv_pmos ad=0.19p pd=1.38u as=0 ps=0 w=1u l=0.13u
X421 6to4_0.flywheel_clk_0.PH0 6to4_0.PI_clk_0.inv_PI_d2$1_0.VOUT VSS.t175 VSS.t174 sg13_lv_nmos ad=55.5f pd=0.74u as=0.1005p ps=1.34u w=0.15u l=0.13u
X422 VDD.t1317 VSS.t1965 6ph_rosc_0.psdiff_0.buff_d8$1_0.VIN.t7 VDD.t503 sg13_lv_pmos ad=55.5f pd=0.74u as=55.5f ps=0.74u w=0.15u l=0.13u
X423 VSS.t508 6to4_0.inv_PI_d2$1_3.VOUT 6to4_0.inv_PI_d2$1_2.VOUT VSS.t507 sg13_lv_nmos ad=0.1005p pd=1.34u as=55.5f ps=0.74u w=0.15u l=0.13u
X424 VSS.t1480 6to4_0.buff_PI_d32_2.inv_PI_d16$1_0.VIN.t58 6to4_0.buff_PI_d32_2.inv_PI_d32_0.VIN.t30 VSS.t1479 sg13_lv_nmos ad=0.1005p pd=1.34u as=55.5f ps=0.74u w=0.15u l=0.13u
X425 PH0.t90 6to4_0.buff_PI_d32_1.inv_PI_d32_0.VIN VDD.t571 VDD.t173 sg13_lv_pmos ad=0.1005p pd=1.34u as=55.5f ps=0.74u w=0.15u l=0.13u
X426 6to4_0.buff_PI_d32_3.inv_PI_d32_0.VIN 6to4_0.buff_PI_d32_3.inv_PI_d16$1_0.VIN.t51 VDD.t872 VDD.t679 sg13_lv_pmos ad=0.1005p pd=1.34u as=55.5f ps=0.74u w=0.15u l=0.13u
X427 6to4_0.buff_PI_d32_2.inv_PI_d32_0.VIN.t17 6to4_0.buff_PI_d32_2.inv_PI_d16$1_0.VIN.t53 VDD.t983 VDD.t126 sg13_lv_pmos ad=0.1005p pd=1.34u as=55.5f ps=0.74u w=0.15u l=0.13u
X428 VSS.t1688 6ph_rosc_0.psdiff_2.CLKP.t8 6ph_rosc_0.psdiff_2.buff_d8$1_1.VIN.t4 VSS.t1703 sg13_lv_nmos ad=55.5f pd=0.74u as=55.5f ps=0.74u w=0.15u l=0.13u
X429 PH90.t29 6to4_0.buff_PI_d32_0.inv_PI_d32_0.VIN VSS.t634 VSS.t633 sg13_lv_nmos ad=55.5f pd=0.74u as=0.1005p ps=1.34u w=0.15u l=0.13u
X430 VSS.t1320 6to4_0.buff_PI_d32_3.inv_PI_d16$1_0.VIN.t53 6to4_0.buff_PI_d32_3.inv_PI_d32_0.VIN VSS.t1319 sg13_lv_nmos ad=0.1005p pd=1.34u as=55.5f ps=0.74u w=0.15u l=0.13u
X431 CTRL 6ph_rosc_0.PH0.t10 CTRL VDD.t51 sg13_lv_pmos ad=0.19p pd=1.38u as=0 ps=0 w=1u l=0.13u
X432 6to4_0.buff_PI_d32_3.inv_PI_d16$1_0.VIN.t27 6to4_0.buff_PI_d32_3.buff_PI_d16$1_0.inv_PI_d8$1_0.VOUT.t33 VSS.t1827 VSS.t1826 sg13_lv_nmos ad=55.5f pd=0.74u as=0.1005p ps=1.34u w=0.15u l=0.13u
X433 VDD.t759 6to4_0.buff_PI_d32_3.inv_PI_d32_0.VIN PH180.t62 VDD.t679 sg13_lv_pmos ad=0.1005p pd=1.34u as=55.5f ps=0.74u w=0.15u l=0.13u
X434 6to4_0.buff_PI_d32_0.buff_PI_d16$1_0.inv_PI_d8$1_0.VOUT.t14 6to4_0.buff_PI_d32_0.buff_PI_d16$1_0.inv_PI_d4$1_0.VOUT.t16 VDD.t846 VDD.t341 sg13_lv_pmos ad=55.5f pd=0.74u as=55.5f ps=0.74u w=0.15u l=0.13u
X435 VSS.t1700 6ph_rosc_0.psdiff_2.CLKP.t8 6ph_rosc_0.psdiff_2.buff_d8$1_1.VIN.t3 VSS.t492 sg13_lv_nmos ad=55.5f pd=0.74u as=55.5f ps=0.74u w=0.15u l=0.13u
X436 6ph_rosc_0.psdiff_2.buff_d8$1_1.VIN.t21 VSS.t1966 VDD.t1351 VDD.t470 sg13_lv_pmos ad=55.5f pd=0.74u as=55.5f ps=0.74u w=0.15u l=0.13u
X437 VSS.t1212 6to4_0.buff_PI_d32_2.buff_PI_d16$1_0.inv_PI_d8$1_0.VOUT.t32 6to4_0.buff_PI_d32_2.inv_PI_d16$1_0.VIN.t4 VSS.t1211 sg13_lv_nmos ad=0.1005p pd=1.34u as=55.5f ps=0.74u w=0.15u l=0.13u
X438 VSS.t955 6to4_0.buff_PI_d32_1.inv_PI_d32_0.VIN PH0.t18 VSS.t954 sg13_lv_nmos ad=0.1005p pd=1.34u as=55.5f ps=0.74u w=0.15u l=0.13u
X439 VDD.t41 6to4_0.flywheel_clk_1.PH0 6to4_0.buff_PI_d32_1.buff_PI_d16$1_0.inv_PI_d4$1_0.VIN VDD.t17 sg13_lv_pmos ad=55.5f pd=0.74u as=0.1005p ps=1.34u w=0.15u l=0.13u
X440 VSS.t1636 6to4_0.buff_PI_d32_0.buff_PI_d16$1_0.inv_PI_d8$1_0.VOUT.t34 6to4_0.buff_PI_d32_0.inv_PI_d16$1_0.VIN.t30 VSS.t1635 sg13_lv_nmos ad=0.1005p pd=1.34u as=55.5f ps=0.74u w=0.15u l=0.13u
X441 VDD.t487 6ph_rosc_0.buff_d8$1_4.inv_d8$1_0.VIN 6ph_rosc_0.PH3.t9 VDD.t75 sg13_lv_pmos ad=0.1005p pd=1.34u as=55.5f ps=0.74u w=0.15u l=0.13u
X442 VDD.t259 6to4_0.buff_PI_d32_2.inv_PI_d32_0.VIN.t67 PH270.t35 VDD.t198 sg13_lv_pmos ad=55.5f pd=0.74u as=55.5f ps=0.74u w=0.15u l=0.13u
X443 VSS.t1570 6ph_rosc_0.PH4.t12 6ph_rosc_0.PH1.t8 VSS.t1569 sg13_lv_nmos ad=0.1005p pd=1.34u as=55.5f ps=0.74u w=0.15u l=0.13u
X444 PH90.t91 6to4_0.buff_PI_d32_0.inv_PI_d32_0.VIN VDD.t373 VDD.t5 sg13_lv_pmos ad=0.1005p pd=1.34u as=55.5f ps=0.74u w=0.15u l=0.13u
X445 6to4_0.buff_PI_d32_1.inv_PI_d16$1_0.VIN 6to4_0.buff_PI_d32_1.buff_PI_d16$1_0.inv_PI_d8$1_0.VOUT.t37 VSS.t1775 VSS.t1774 sg13_lv_nmos ad=55.5f pd=0.74u as=0.1005p ps=1.34u w=0.15u l=0.13u
X446 VDD.t1224 6to4_0.buff_PI_d32_3.buff_PI_d16$1_0.inv_PI_d8$1_0.VOUT.t32 6to4_0.buff_PI_d32_3.inv_PI_d16$1_0.VIN.t26 VDD.t99 sg13_lv_pmos ad=0.1005p pd=1.34u as=55.5f ps=0.74u w=0.15u l=0.13u
X447 PH90.t22 6to4_0.buff_PI_d32_0.inv_PI_d32_0.VIN VSS.t632 VSS.t631 sg13_lv_nmos ad=55.5f pd=0.74u as=0.1005p ps=1.34u w=0.15u l=0.13u
X448 VDD.t188 6to4_0.buff_PI_d32_1.buff_PI_d16$1_0.inv_PI_d4$1_0.VOUT.t16 6to4_0.buff_PI_d32_1.buff_PI_d16$1_0.inv_PI_d8$1_0.VOUT.t12 VDD.t173 sg13_lv_pmos ad=0.1005p pd=1.34u as=55.5f ps=0.74u w=0.15u l=0.13u
X449 6ph_rosc_0.psdiff_2.buff_d8$1_1.VIN.t20 VSS.t1966 VDD.t1365 VDD.t470 sg13_lv_pmos ad=55.5f pd=0.74u as=55.5f ps=0.74u w=0.15u l=0.13u
X450 6to4_0.buff_PI_d32_3.inv_PI_d16$1_0.VIN.t5 6to4_0.buff_PI_d32_3.buff_PI_d16$1_0.inv_PI_d8$1_0.VOUT.t25 VDD.t1201 VDD.t99 sg13_lv_pmos ad=0.1005p pd=1.34u as=55.5f ps=0.74u w=0.15u l=0.13u
X451 6to4_0.buff_PI_d32_2.inv_PI_d16$1_0.VIN.t32 6to4_0.buff_PI_d32_2.buff_PI_d16$1_0.inv_PI_d8$1_0.VOUT.t30 VDD.t795 VDD.t198 sg13_lv_pmos ad=55.5f pd=0.74u as=0.1005p ps=1.34u w=0.15u l=0.13u
X452 CTRL 6ph_rosc_0.PH2.t10 CTRL VDD.t89 sg13_lv_pmos ad=0.19p pd=1.38u as=0 ps=0 w=1u l=0.13u
X453 VSS.t1520 6to4_0.buff_PI_d32_3.buff_PI_d16$1_0.inv_PI_d4$1_0.VOUT.t12 6to4_0.buff_PI_d32_3.buff_PI_d16$1_0.inv_PI_d8$1_0.VOUT.t6 VSS.t1519 sg13_lv_nmos ad=0.1005p pd=1.34u as=55.5f ps=0.74u w=0.15u l=0.13u
X454 VDD.t1285 6to4_0.buff_PI_d32_1.inv_PI_d16$1_0.VIN 6to4_0.buff_PI_d32_1.inv_PI_d32_0.VIN VDD.t17 sg13_lv_pmos ad=55.5f pd=0.74u as=0.1005p ps=1.34u w=0.15u l=0.13u
X455 6to4_0.buff_PI_d32_2.buff_PI_d16$1_0.inv_PI_d4$1_0.VOUT.t7 6to4_0.buff_PI_d32_2.buff_PI_d16$1_0.inv_PI_d4$1_0.VIN VDD.t129 VDD.t126 sg13_lv_pmos ad=55.5f pd=0.74u as=55.5f ps=0.74u w=0.15u l=0.13u
X456 PH270.t21 6to4_0.buff_PI_d32_2.inv_PI_d32_0.VIN.t68 VSS.t414 VSS.t413 sg13_lv_nmos ad=55.5f pd=0.74u as=0.1005p ps=1.34u w=0.15u l=0.13u
X457 VDD.t320 6ph_rosc_0.buff_d8$1_1.inv_d8$1_0.VIN 6ph_rosc_0.PH5.t7 VDD.t75 sg13_lv_pmos ad=0.1005p pd=1.34u as=55.5f ps=0.74u w=0.15u l=0.13u
X458 VSS.t1174 6ph_rosc_0.psdiff_2.buff_d8$1_1.inv_d2$1_0.VIN 6ph_rosc_0.psdiff_2.buff_d8$1_1.inv_d4$1_0.VIN VSS.t1173 sg13_lv_nmos ad=0.1005p pd=1.34u as=55.5f ps=0.74u w=0.15u l=0.13u
X459 VSS.t1115 6to4_0.buff_PI_d32_3.inv_PI_d32_0.VIN PH180.t15 VSS.t1114 sg13_lv_nmos ad=0.1005p pd=1.34u as=55.5f ps=0.74u w=0.15u l=0.13u
X460 VSS.t630 6to4_0.buff_PI_d32_0.inv_PI_d32_0.VIN PH90.t30 VSS.t629 sg13_lv_nmos ad=0.1005p pd=1.34u as=55.5f ps=0.74u w=0.15u l=0.13u
X461 VDD.t627 6to4_0.buff_PI_d32_1.inv_PI_d32_0.VIN PH0.t65 VDD.t173 sg13_lv_pmos ad=0.1005p pd=1.34u as=55.5f ps=0.74u w=0.15u l=0.13u
X462 6to4_0.buff_PI_d32_2.inv_PI_d16$1_0.VIN.t31 6to4_0.buff_PI_d32_2.buff_PI_d16$1_0.inv_PI_d8$1_0.VOUT.t25 VDD.t780 VDD.t126 sg13_lv_pmos ad=55.5f pd=0.74u as=55.5f ps=0.74u w=0.15u l=0.13u
X463 6ph_rosc_0.psdiff_1.buff_d8$1_1.VIN.t11 CTRL a_7973_2194# VSS.t500 sg13_lv_nmos ad=0.1005p pd=1.34u as=55.5f ps=0.74u w=0.15u l=0.13u
X464 6to4_0.buff_PI_d32_3.inv_PI_d16$1_0.VIN.t32 6to4_0.buff_PI_d32_3.buff_PI_d16$1_0.inv_PI_d8$1_0.VOUT.t34 VDD.t1228 VDD.t679 sg13_lv_pmos ad=0.1005p pd=1.34u as=55.5f ps=0.74u w=0.15u l=0.13u
X465 VDD.t146 6ph_rosc_0.psdiff_2.buff_d8$1_0.inv_d8$1_0.VIN 6ph_rosc_0.psdiff_2.VOUTDP VDD.t34 sg13_lv_pmos ad=0.1005p pd=1.34u as=55.5f ps=0.74u w=0.15u l=0.13u
X466 CTRL 6ph_rosc_0.PH2.t10 CTRL VDD.t440 sg13_lv_pmos ad=0.19p pd=1.38u as=0 ps=0 w=1u l=0.13u
X467 6to4_0.buff_PI_d32_3.buff_PI_d16$1_0.inv_PI_d4$1_0.VOUT.t2 6to4_0.buff_PI_d32_3.buff_PI_d16$1_0.inv_PI_d4$1_0.VIN VSS.t149 VSS.t148 sg13_lv_nmos ad=55.5f pd=0.74u as=0.1005p ps=1.34u w=0.15u l=0.13u
X468 6to4_0.buff_PI_d32_0.buff_PI_d16$1_0.inv_PI_d8$1_0.VOUT.t17 6to4_0.buff_PI_d32_0.buff_PI_d16$1_0.inv_PI_d4$1_0.VOUT.t17 VDD.t851 VDD.t341 sg13_lv_pmos ad=55.5f pd=0.74u as=0.1005p ps=1.34u w=0.15u l=0.13u
X469 VDD.t716 6to4_0.buff_PI_d32_3.inv_PI_d32_0.VIN PH180.t81 VDD.t679 sg13_lv_pmos ad=55.5f pd=0.74u as=55.5f ps=0.74u w=0.15u l=0.13u
X470 PH270.t89 6to4_0.buff_PI_d32_2.inv_PI_d32_0.VIN.t62 VDD.t243 VDD.t202 sg13_lv_pmos ad=0.1005p pd=1.34u as=55.5f ps=0.74u w=0.15u l=0.13u
X471 VSS.t783 6ph_rosc_0.psdiff_0.buff_d8$1_1.inv_d8$1_0.VIN 6ph_rosc_0.psdiff_2.CLKP.t3 VSS.t782 sg13_lv_nmos ad=0.1005p pd=1.34u as=55.5f ps=0.74u w=0.15u l=0.13u
X472 VSS.t1107 6to4_0.buff_PI_d32_3.inv_PI_d32_0.VIN PH180.t26 VSS.t1106 sg13_lv_nmos ad=0.1005p pd=1.34u as=55.5f ps=0.74u w=0.15u l=0.13u
X473 6ph_rosc_0.psdiff_2.buff_d8$1_1.inv_d8$1_0.VIN 6ph_rosc_0.psdiff_2.buff_d8$1_1.inv_d4$1_0.VIN VSS.t47 VSS.t46 sg13_lv_nmos ad=55.5f pd=0.74u as=0.1005p ps=1.34u w=0.15u l=0.13u
X474 VSS.t709 6ph_rosc_0.psdiff_2.CLKN 6ph_rosc_0.psdiff_2.buff_d8$1_0.VIN.t24 VSS.t496 sg13_lv_nmos ad=55.5f pd=0.74u as=55.5f ps=0.74u w=0.15u l=0.13u
X475 6ph_rosc_0.psdiff_0.buff_d8$1_0.VIN.t11 CTRL a_12104_2338# VSS.t499 sg13_lv_nmos ad=0.1005p pd=1.34u as=55.5f ps=0.74u w=0.15u l=0.13u
X476 PH0.t89 6to4_0.buff_PI_d32_1.inv_PI_d32_0.VIN VDD.t579 VDD.t17 sg13_lv_pmos ad=0.1005p pd=1.34u as=55.5f ps=0.74u w=0.15u l=0.13u
X477 VSS.t406 6to4_0.buff_PI_d32_2.inv_PI_d32_0.VIN.t66 PH270.t19 VSS.t405 sg13_lv_nmos ad=0.1005p pd=1.34u as=55.5f ps=0.74u w=0.15u l=0.13u
X478 VDD.t888 6to4_0.buff_PI_d32_3.inv_PI_d16$1_0.VIN.t56 6to4_0.buff_PI_d32_3.inv_PI_d32_0.VIN VDD.t679 sg13_lv_pmos ad=55.5f pd=0.74u as=0.1005p ps=1.34u w=0.15u l=0.13u
X479 VDD.t1001 6to4_0.buff_PI_d32_2.inv_PI_d16$1_0.VIN.t59 6to4_0.buff_PI_d32_2.inv_PI_d32_0.VIN.t35 VDD.t198 sg13_lv_pmos ad=55.5f pd=0.74u as=0.1005p ps=1.34u w=0.15u l=0.13u
X480 VSS.t1773 6to4_0.buff_PI_d32_1.buff_PI_d16$1_0.inv_PI_d8$1_0.VOUT.t34 6to4_0.buff_PI_d32_1.inv_PI_d16$1_0.VIN VSS.t1772 sg13_lv_nmos ad=0.1005p pd=1.34u as=55.5f ps=0.74u w=0.15u l=0.13u
X481 PH270.t22 6to4_0.buff_PI_d32_2.inv_PI_d32_0.VIN.t69 VSS.t418 VSS.t417 sg13_lv_nmos ad=55.5f pd=0.74u as=0.1005p ps=1.34u w=0.15u l=0.13u
X482 6ph_rosc_0.psdiff_1.buff_d8$1_0.inv_d4$1_0.VIN 6ph_rosc_0.psdiff_1.buff_d8$1_0.inv_d2$1_0.VIN VSS.t163 VSS.t162 sg13_lv_nmos ad=55.5f pd=0.74u as=0.1005p ps=1.34u w=0.15u l=0.13u
X483 VDD.t376 6to4_0.buff_PI_d32_0.inv_PI_d32_0.VIN PH90.t36 VDD.t347 sg13_lv_pmos ad=55.5f pd=0.74u as=55.5f ps=0.74u w=0.15u l=0.13u
X484 VDD.t918 6ph_rosc_0.PH1.t13 6ph_rosc_0.PH4.t1 VDD.t917 sg13_lv_pmos ad=0.1005p pd=1.34u as=55.5f ps=0.74u w=0.15u l=0.13u
X485 PH180.t91 6to4_0.buff_PI_d32_3.inv_PI_d32_0.VIN VDD.t702 VDD.t99 sg13_lv_pmos ad=0.1005p pd=1.34u as=55.5f ps=0.74u w=0.15u l=0.13u
X486 6to4_0.buff_PI_d32_0.inv_PI_d32_0.VIN 6to4_0.buff_PI_d32_0.inv_PI_d16$1_0.VIN.t57 VDD.t947 VDD.t5 sg13_lv_pmos ad=55.5f pd=0.74u as=55.5f ps=0.74u w=0.15u l=0.13u
X487 PH90.t0 6to4_0.buff_PI_d32_0.inv_PI_d32_0.VIN VSS.t628 VSS.t627 sg13_lv_nmos ad=55.5f pd=0.74u as=0.1005p ps=1.34u w=0.15u l=0.13u
X488 VDD.t117 6ph_rosc_0.psdiff_1.buff_d8$1_0.inv_d2$1_0.VIN 6ph_rosc_0.psdiff_1.buff_d8$1_0.inv_d4$1_0.VIN VDD.t34 sg13_lv_pmos ad=0.1005p pd=1.34u as=55.5f ps=0.74u w=0.15u l=0.13u
X489 VDD.t1078 6ph_rosc_0.psdiff_0.buff_d8$1_0.inv_d8$1_0.VIN 6ph_rosc_0.psdiff_2.CLKN VDD.t34 sg13_lv_pmos ad=0.1005p pd=1.34u as=55.5f ps=0.74u w=0.15u l=0.13u
X490 6to4_0.buff_PI_d32_1.inv_PI_d32_0.VIN 6to4_0.buff_PI_d32_1.inv_PI_d16$1_0.VIN VDD.t1294 VDD.t17 sg13_lv_pmos ad=55.5f pd=0.74u as=0.1005p ps=1.34u w=0.15u l=0.13u
X491 PH90.t26 6to4_0.buff_PI_d32_0.inv_PI_d32_0.VIN VSS.t626 VSS.t625 sg13_lv_nmos ad=55.5f pd=0.74u as=0.1005p ps=1.34u w=0.15u l=0.13u
X492 6ph_rosc_0.psdiff_2.buff_d8$1_1.VIN.t8 6ph_rosc_0.psdiff_2.CLKP.t8 VSS.t1706 VSS.t1687 sg13_lv_nmos ad=55.5f pd=0.74u as=55.5f ps=0.74u w=0.15u l=0.13u
X493 6ph_rosc_0.PH1.t7 6ph_rosc_0.buff_d8$1_3.inv_d8$1_0.VIN VDD.t154 VDD.t75 sg13_lv_pmos ad=55.5f pd=0.74u as=0.1005p ps=1.34u w=0.15u l=0.13u
X494 VSS.t1771 6to4_0.buff_PI_d32_1.buff_PI_d16$1_0.inv_PI_d8$1_0.VOUT.t30 6to4_0.buff_PI_d32_1.inv_PI_d16$1_0.VIN VSS.t1770 sg13_lv_nmos ad=0.1005p pd=1.34u as=55.5f ps=0.74u w=0.15u l=0.13u
X495 6to4_0.buff_PI_d32_0.inv_PI_d16$1_0.VIN.t12 6to4_0.buff_PI_d32_0.buff_PI_d16$1_0.inv_PI_d8$1_0.VOUT.t28 VSS.t1612 VSS.t1611 sg13_lv_nmos ad=55.5f pd=0.74u as=0.1005p ps=1.34u w=0.15u l=0.13u
X496 6to4_0.buff_PI_d32_2.buff_PI_d16$1_0.inv_PI_d4$1_0.VOUT.t5 6to4_0.buff_PI_d32_2.buff_PI_d16$1_0.inv_PI_d4$1_0.VIN VDD.t136 VDD.t126 sg13_lv_pmos ad=55.5f pd=0.74u as=0.1005p ps=1.34u w=0.15u l=0.13u
X497 VDD.t16 6to4_0.flywheel_clk_0.PH0 6to4_0.buff_PI_d32_2.VIN VDD.t9 sg13_lv_pmos ad=0.1005p pd=1.34u as=55.5f ps=0.74u w=0.15u l=0.13u
X498 VDD.t786 6to4_0.buff_PI_d32_2.buff_PI_d16$1_0.inv_PI_d8$1_0.VOUT.t27 6to4_0.buff_PI_d32_2.inv_PI_d16$1_0.VIN.t17 VDD.t126 sg13_lv_pmos ad=55.5f pd=0.74u as=55.5f ps=0.74u w=0.15u l=0.13u
X499 VSS.t953 6to4_0.buff_PI_d32_1.inv_PI_d32_0.VIN PH0.t30 VSS.t952 sg13_lv_nmos ad=0.1005p pd=1.34u as=55.5f ps=0.74u w=0.15u l=0.13u
X500 CTRL 6ph_rosc_0.PH1.t10 CTRL VDD.t82 sg13_lv_pmos ad=0.19p pd=1.38u as=0 ps=0 w=1u l=0.13u
X501 6to4_0.buff_PI_d32_3.inv_PI_d32_0.VIN 6to4_0.buff_PI_d32_3.inv_PI_d16$1_0.VIN.t57 VDD.t891 VDD.t99 sg13_lv_pmos ad=55.5f pd=0.74u as=55.5f ps=0.74u w=0.15u l=0.13u
X502 VDD.t1038 6to4_0.buff_PI_d32_3.buff_PI_d16$1_0.inv_PI_d4$1_0.VOUT.t15 6to4_0.buff_PI_d32_3.buff_PI_d16$1_0.inv_PI_d8$1_0.VOUT.t12 VDD.t679 sg13_lv_pmos ad=55.5f pd=0.74u as=55.5f ps=0.74u w=0.15u l=0.13u
X503 VSS.t1113 6to4_0.buff_PI_d32_3.inv_PI_d32_0.VIN PH180.t14 VSS.t1112 sg13_lv_nmos ad=0.1005p pd=1.34u as=55.5f ps=0.74u w=0.15u l=0.13u
X504 VDD.t516 a_10947_2194# 6ph_rosc_0.psdiff_0.buff_d8$1_0.VIN.t16 VDD.t503 sg13_lv_pmos ad=55.5f pd=0.74u as=55.5f ps=0.74u w=0.15u l=0.13u
X505 6to4_0.buff_PI_d32_3.buff_PI_d16$1_0.inv_PI_d8$1_0.VOUT.t5 6to4_0.buff_PI_d32_3.buff_PI_d16$1_0.inv_PI_d4$1_0.VOUT.t14 VSS.t1528 VSS.t1527 sg13_lv_nmos ad=55.5f pd=0.74u as=0.1005p ps=1.34u w=0.15u l=0.13u
X506 6to4_0.buff_PI_d32_3.buff_PI_d16$1_0.inv_PI_d8$1_0.VOUT.t15 6to4_0.buff_PI_d32_3.buff_PI_d16$1_0.inv_PI_d4$1_0.VOUT.t16 VDD.t1016 VDD.t679 sg13_lv_pmos ad=55.5f pd=0.74u as=55.5f ps=0.74u w=0.15u l=0.13u
X507 VDD.t625 6to4_0.buff_PI_d32_1.inv_PI_d32_0.VIN PH0.t79 VDD.t552 sg13_lv_pmos ad=0.1005p pd=1.34u as=55.5f ps=0.74u w=0.15u l=0.13u
X508 VDD.t843 6to4_0.buff_PI_d32_0.buff_PI_d16$1_0.inv_PI_d4$1_0.VOUT.t15 6to4_0.buff_PI_d32_0.buff_PI_d16$1_0.inv_PI_d8$1_0.VOUT.t11 VDD.t341 sg13_lv_pmos ad=55.5f pd=0.74u as=0.1005p ps=1.34u w=0.15u l=0.13u
X509 VSS.t1200 6to4_0.buff_PI_d32_2.buff_PI_d16$1_0.inv_PI_d8$1_0.VOUT.t29 6to4_0.buff_PI_d32_2.inv_PI_d16$1_0.VIN.t3 VSS.t1199 sg13_lv_nmos ad=0.1005p pd=1.34u as=55.5f ps=0.74u w=0.15u l=0.13u
X510 PH180.t0 6to4_0.buff_PI_d32_3.inv_PI_d32_0.VIN VSS.t1111 VSS.t1110 sg13_lv_nmos ad=55.5f pd=0.74u as=0.1005p ps=1.34u w=0.15u l=0.13u
X511 PH0.t9 6to4_0.buff_PI_d32_1.inv_PI_d32_0.VIN VSS.t949 VSS.t948 sg13_lv_nmos ad=55.5f pd=0.74u as=0.1005p ps=1.34u w=0.15u l=0.13u
X512 VDD.t1293 6to4_0.buff_PI_d32_1.inv_PI_d16$1_0.VIN 6to4_0.buff_PI_d32_1.inv_PI_d32_0.VIN VDD.t17 sg13_lv_pmos ad=0.1005p pd=1.34u as=55.5f ps=0.74u w=0.15u l=0.13u
X513 CTRL 6ph_rosc_0.PH1.t10 CTRL VDD.t78 sg13_lv_pmos ad=0.19p pd=1.38u as=0 ps=0 w=1u l=0.13u
X514 6ph_rosc_0.PH1.t9 6ph_rosc_0.PH4.t13 VDD.t1068 VDD.t917 sg13_lv_pmos ad=55.5f pd=0.74u as=0.1005p ps=1.34u w=0.15u l=0.13u
X515 VSS.t814 6ph_rosc_0.psdiff_1.VOUTDP 6ph_rosc_0.psdiff_0.buff_d8$1_0.VIN.t26 VSS.t495 sg13_lv_nmos ad=55.5f pd=0.74u as=55.5f ps=0.74u w=0.15u l=0.13u
X516 CTRL 6ph_rosc_0.PH3.t11 CTRL VDD.t464 sg13_lv_pmos ad=0.19p pd=1.38u as=0 ps=0 w=1u l=0.13u
X517 6ph_rosc_0.psdiff_2.buff_d8$1_0.VIN.t20 6ph_rosc_0.psdiff_2.CLKN VSS.t704 VSS.t491 sg13_lv_nmos ad=55.5f pd=0.74u as=55.5f ps=0.74u w=0.15u l=0.13u
X518 6to4_0.buff_PI_d32_3.buff_PI_d16$1_0.inv_PI_d8$1_0.VOUT.t21 6to4_0.buff_PI_d32_3.buff_PI_d16$1_0.inv_PI_d4$1_0.VOUT.t12 VDD.t1029 VDD.t679 sg13_lv_pmos ad=55.5f pd=0.74u as=0.1005p ps=1.34u w=0.15u l=0.13u
X519 6ph_rosc_0.psdiff_2.buff_d8$1_0.VIN.t5 VSS.t1966 VDD.t1364 VDD.t470 sg13_lv_pmos ad=55.5f pd=0.74u as=55.5f ps=0.74u w=0.15u l=0.13u
X520 VDD.t951 6to4_0.buff_PI_d32_0.inv_PI_d16$1_0.VIN.t58 6to4_0.buff_PI_d32_0.inv_PI_d32_0.VIN VDD.t341 sg13_lv_pmos ad=55.5f pd=0.74u as=0.1005p ps=1.34u w=0.15u l=0.13u
X521 VDD.t519 a_10947_2194# 6ph_rosc_0.psdiff_0.buff_d8$1_0.VIN.t13 VDD.t503 sg13_lv_pmos ad=55.5f pd=0.74u as=55.5f ps=0.74u w=0.15u l=0.13u
X522 PH180.t29 6to4_0.buff_PI_d32_3.inv_PI_d32_0.VIN VSS.t1109 VSS.t1108 sg13_lv_nmos ad=55.5f pd=0.74u as=0.1005p ps=1.34u w=0.15u l=0.13u
X523 VDD.t328 6to4_0.inv_PI_d2$1_3.VOUT 6to4_0.inv_PI_d2$1_2.VOUT VDD.t99 sg13_lv_pmos ad=0.1005p pd=1.34u as=55.5f ps=0.74u w=0.15u l=0.13u
X524 VSS.t422 6to4_0.buff_PI_d32_2.inv_PI_d32_0.VIN.t70 PH270.t10 VSS.t421 sg13_lv_nmos ad=0.1005p pd=1.34u as=55.5f ps=0.74u w=0.15u l=0.13u
X525 VSS.t488 6ph_rosc_0.buff_d8$1_1.inv_d8$1_0.VIN 6ph_rosc_0.PH5.t3 VSS.t487 sg13_lv_nmos ad=0.1005p pd=1.34u as=55.5f ps=0.74u w=0.15u l=0.13u
X526 VDD.t271 6to4_0.buff_PI_d32_2.inv_PI_d32_0.VIN.t71 PH270.t55 VDD.t215 sg13_lv_pmos ad=55.5f pd=0.74u as=55.5f ps=0.74u w=0.15u l=0.13u
X527 PH270.t31 6to4_0.buff_PI_d32_2.inv_PI_d32_0.VIN.t48 VSS.t332 VSS.t331 sg13_lv_nmos ad=55.5f pd=0.74u as=0.1005p ps=1.34u w=0.15u l=0.13u
X528 6to4_0.buff_PI_d32_2.inv_PI_d16$1_0.VIN.t41 6to4_0.buff_PI_d32_2.buff_PI_d16$1_0.inv_PI_d8$1_0.VOUT.t33 VDD.t805 VDD.t198 sg13_lv_pmos ad=55.5f pd=0.74u as=0.1005p ps=1.34u w=0.15u l=0.13u
X529 CTRL 6ph_rosc_0.PH3.t11 CTRL VDD.t464 sg13_lv_pmos ad=0.19p pd=1.38u as=0 ps=0 w=1u l=0.13u
X530 6to4_0.buff_PI_d32_2.inv_PI_d16$1_0.VIN.t10 6to4_0.buff_PI_d32_2.buff_PI_d16$1_0.inv_PI_d8$1_0.VOUT.t34 VSS.t1220 VSS.t1219 sg13_lv_nmos ad=55.5f pd=0.74u as=0.1005p ps=1.34u w=0.15u l=0.13u
X531 PH270.t76 6to4_0.buff_PI_d32_2.inv_PI_d32_0.VIN.t72 VDD.t274 VDD.t202 sg13_lv_pmos ad=55.5f pd=0.74u as=55.5f ps=0.74u w=0.15u l=0.13u
X532 PH90.t18 6to4_0.buff_PI_d32_0.inv_PI_d32_0.VIN VSS.t624 VSS.t623 sg13_lv_nmos ad=55.5f pd=0.74u as=0.1005p ps=1.34u w=0.15u l=0.13u
X533 6ph_rosc_0.psdiff_2.buff_d8$1_0.VIN.t19 6ph_rosc_0.psdiff_2.CLKN VSS.t714 VSS.t708 sg13_lv_nmos ad=55.5f pd=0.74u as=55.5f ps=0.74u w=0.15u l=0.13u
X534 CTRL 6ph_rosc_0.PH1.t10 CTRL VDD.t80 sg13_lv_pmos ad=0.19p pd=1.38u as=0 ps=0 w=1u l=0.13u
X535 VDD.t1247 6ph_rosc_0.PH3.t10 6to4_0.inv_PI_d2$1_3.VOUT VDD.t99 sg13_lv_pmos ad=55.5f pd=0.74u as=55.5f ps=0.74u w=0.15u l=0.13u
X536 PH0.t24 6to4_0.buff_PI_d32_1.inv_PI_d32_0.VIN VSS.t951 VSS.t950 sg13_lv_nmos ad=55.5f pd=0.74u as=0.1005p ps=1.34u w=0.15u l=0.13u
X537 PH180.t69 6to4_0.buff_PI_d32_3.inv_PI_d32_0.VIN VDD.t701 VDD.t99 sg13_lv_pmos ad=55.5f pd=0.74u as=55.5f ps=0.74u w=0.15u l=0.13u
X538 PH270.t59 6to4_0.buff_PI_d32_2.inv_PI_d32_0.VIN.t52 VDD.t213 VDD.t198 sg13_lv_pmos ad=55.5f pd=0.74u as=0.1005p ps=1.34u w=0.15u l=0.13u
X539 VDD.t319 6ph_rosc_0.buff_d8$1_1.inv_d8$1_0.VIN 6ph_rosc_0.PH5.t6 VDD.t75 sg13_lv_pmos ad=0.1005p pd=1.34u as=55.5f ps=0.74u w=0.15u l=0.13u
X540 VDD.t676 6to4_0.buff_PI_d32_3.inv_PI_d32_0.VIN PH180.t56 VDD.t99 sg13_lv_pmos ad=55.5f pd=0.74u as=55.5f ps=0.74u w=0.15u l=0.13u
X541 6to4_0.buff_PI_d32_1.inv_PI_d32_0.VIN 6to4_0.buff_PI_d32_1.inv_PI_d16$1_0.VIN VDD.t1266 VDD.t173 sg13_lv_pmos ad=55.5f pd=0.74u as=55.5f ps=0.74u w=0.15u l=0.13u
X542 6ph_rosc_0.psdiff_0.buff_d8$1_1.VIN.t19 6ph_rosc_0.psdiff_1.VOUTDN VSS.t1958 VSS.t1939 sg13_lv_nmos ad=55.5f pd=0.74u as=0.1005p ps=1.34u w=0.15u l=0.13u
X543 VDD.t1048 6to4_0.buff_PI_d32_2.buff_PI_d16$1_0.inv_PI_d4$1_0.VOUT.t14 6to4_0.buff_PI_d32_2.buff_PI_d16$1_0.inv_PI_d8$1_0.VOUT.t16 VDD.t198 sg13_lv_pmos ad=0.1005p pd=1.34u as=55.5f ps=0.74u w=0.15u l=0.13u
X544 CTRL 6ph_rosc_0.PH0.t10 CTRL VDD.t57 sg13_lv_pmos ad=0.19p pd=1.38u as=0 ps=0 w=1u l=0.13u
X545 VDD.t1386 VSS.t1967 6ph_rosc_0.psdiff_1.buff_d8$1_0.VIN.t23 VDD.t301 sg13_lv_pmos ad=55.5f pd=0.74u as=55.5f ps=0.74u w=0.15u l=0.13u
X546 6ph_rosc_0.buff_d8$1_1.inv_d2$1_0.VIN 6ph_rosc_0.psdiff_2.CLKN VDD.t462 VDD.t75 sg13_lv_pmos ad=0.1005p pd=1.34u as=0.1005p ps=1.34u w=0.15u l=0.13u
X547 VDD.t810 6to4_0.buff_PI_d32_2.buff_PI_d16$1_0.inv_PI_d8$1_0.VOUT.t35 6to4_0.buff_PI_d32_2.inv_PI_d16$1_0.VIN.t45 VDD.t126 sg13_lv_pmos ad=55.5f pd=0.74u as=0.1005p ps=1.34u w=0.15u l=0.13u
X548 VSS.t1815 6to4_0.buff_PI_d32_3.buff_PI_d16$1_0.inv_PI_d8$1_0.VOUT.t30 6to4_0.buff_PI_d32_3.inv_PI_d16$1_0.VIN.t18 VSS.t1814 sg13_lv_nmos ad=0.1005p pd=1.34u as=55.5f ps=0.74u w=0.15u l=0.13u
X549 PH90.t90 6to4_0.buff_PI_d32_0.inv_PI_d32_0.VIN VDD.t366 VDD.t341 sg13_lv_pmos ad=0.1005p pd=1.34u as=55.5f ps=0.74u w=0.15u l=0.13u
X550 PH0.t68 6to4_0.buff_PI_d32_1.inv_PI_d32_0.VIN VDD.t588 VDD.t173 sg13_lv_pmos ad=55.5f pd=0.74u as=55.5f ps=0.74u w=0.15u l=0.13u
X551 VDD.t1417 VSS.t1967 6ph_rosc_0.psdiff_1.buff_d8$1_1.VIN.t4 VDD.t301 sg13_lv_pmos ad=55.5f pd=0.74u as=55.5f ps=0.74u w=0.15u l=0.13u
X552 VDD.t737 6to4_0.buff_PI_d32_3.inv_PI_d32_0.VIN PH180.t90 VDD.t99 sg13_lv_pmos ad=55.5f pd=0.74u as=0.1005p ps=1.34u w=0.15u l=0.13u
X553 6to4_0.buff_PI_d32_3.inv_PI_d16$1_0.VIN.t34 6to4_0.buff_PI_d32_3.buff_PI_d16$1_0.inv_PI_d8$1_0.VOUT.t35 VDD.t1233 VDD.t679 sg13_lv_pmos ad=55.5f pd=0.74u as=0.1005p ps=1.34u w=0.15u l=0.13u
X554 PH90.t89 6to4_0.buff_PI_d32_0.inv_PI_d32_0.VIN VDD.t357 VDD.t347 sg13_lv_pmos ad=0.1005p pd=1.34u as=55.5f ps=0.74u w=0.15u l=0.13u
X555 CTRL 6ph_rosc_0.PH5.t12 CTRL VDD.t85 sg13_lv_pmos ad=0.19p pd=1.38u as=0 ps=0 w=1u l=0.13u
X556 6to4_0.buff_PI_d32_0.inv_PI_d32_0.VIN 6to4_0.buff_PI_d32_0.inv_PI_d16$1_0.VIN.t59 VDD.t955 VDD.t341 sg13_lv_pmos ad=55.5f pd=0.74u as=0.1005p ps=1.34u w=0.15u l=0.13u
X557 6ph_rosc_0.PH1.t3 6ph_rosc_0.buff_d8$1_3.inv_d8$1_0.VIN VSS.t262 VSS.t261 sg13_lv_nmos ad=55.5f pd=0.74u as=0.1005p ps=1.34u w=0.15u l=0.13u
X558 VDD.t1109 6to4_0.buff_PI_d32_0.buff_PI_d16$1_0.inv_PI_d8$1_0.VOUT.t33 6to4_0.buff_PI_d32_0.inv_PI_d16$1_0.VIN.t28 VDD.t5 sg13_lv_pmos ad=0.1005p pd=1.34u as=55.5f ps=0.74u w=0.15u l=0.13u
X559 VDD.t1177 6to4_0.buff_PI_d32_1.buff_PI_d16$1_0.inv_PI_d8$1_0.VOUT.t38 6to4_0.buff_PI_d32_1.inv_PI_d16$1_0.VIN VDD.t17 sg13_lv_pmos ad=55.5f pd=0.74u as=55.5f ps=0.74u w=0.15u l=0.13u
X560 PH180.t40 6to4_0.buff_PI_d32_3.inv_PI_d32_0.VIN VDD.t753 VDD.t673 sg13_lv_pmos ad=55.5f pd=0.74u as=55.5f ps=0.74u w=0.15u l=0.13u
X561 VDD.t217 6to4_0.buff_PI_d32_2.inv_PI_d32_0.VIN.t53 PH270.t88 VDD.t215 sg13_lv_pmos ad=55.5f pd=0.74u as=0.1005p ps=1.34u w=0.15u l=0.13u
X562 VDD.t797 6to4_0.buff_PI_d32_2.buff_PI_d16$1_0.inv_PI_d8$1_0.VOUT.t31 6to4_0.buff_PI_d32_2.inv_PI_d16$1_0.VIN.t44 VDD.t198 sg13_lv_pmos ad=55.5f pd=0.74u as=0.1005p ps=1.34u w=0.15u l=0.13u
X563 VDD.t277 6to4_0.buff_PI_d32_2.inv_PI_d32_0.VIN.t73 PH270.t53 VDD.t202 sg13_lv_pmos ad=55.5f pd=0.74u as=55.5f ps=0.74u w=0.15u l=0.13u
X564 VDD.t58 6ph_rosc_0.buff_d8$1_5.inv_d8$1_0.VIN 6ph_rosc_0.PH0.t7 VDD.t57 sg13_lv_pmos ad=0.1005p pd=1.34u as=55.5f ps=0.74u w=0.15u l=0.13u
X565 6to4_0.buff_PI_d32_2.buff_PI_d16$1_0.inv_PI_d4$1_0.VOUT.t11 6to4_0.buff_PI_d32_2.buff_PI_d16$1_0.inv_PI_d4$1_0.VIN VDD.t128 VDD.t126 sg13_lv_pmos ad=0.1005p pd=1.34u as=55.5f ps=0.74u w=0.15u l=0.13u
X566 VDD.t1205 6to4_0.buff_PI_d32_3.buff_PI_d16$1_0.inv_PI_d8$1_0.VOUT.t26 6to4_0.buff_PI_d32_3.inv_PI_d16$1_0.VIN.t7 VDD.t99 sg13_lv_pmos ad=55.5f pd=0.74u as=55.5f ps=0.74u w=0.15u l=0.13u
X567 VDD.t365 6to4_0.buff_PI_d32_0.inv_PI_d32_0.VIN PH90.t88 VDD.t5 sg13_lv_pmos ad=55.5f pd=0.74u as=0.1005p ps=1.34u w=0.15u l=0.13u
X568 6to4_0.buff_PI_d32_3.buff_PI_d16$1_0.inv_PI_d4$1_0.VOUT.t5 6to4_0.buff_PI_d32_3.buff_PI_d16$1_0.inv_PI_d4$1_0.VIN VDD.t104 VDD.t99 sg13_lv_pmos ad=55.5f pd=0.74u as=55.5f ps=0.74u w=0.15u l=0.13u
X569 VSS.t622 6to4_0.buff_PI_d32_0.inv_PI_d32_0.VIN PH90.t15 VSS.t621 sg13_lv_nmos ad=0.1005p pd=1.34u as=55.5f ps=0.74u w=0.15u l=0.13u
X570 PH0.t19 6to4_0.buff_PI_d32_1.inv_PI_d32_0.VIN VSS.t947 VSS.t946 sg13_lv_nmos ad=55.5f pd=0.74u as=0.1005p ps=1.34u w=0.15u l=0.13u
X571 6to4_0.flywheel_clk_0.PH0 6to4_0.PI_clk_0.inv_PI_d2$1_0.VOUT VDD.t123 VDD.t9 sg13_lv_pmos ad=55.5f pd=0.74u as=0.1005p ps=1.34u w=0.15u l=0.13u
X572 VDD.t940 6to4_0.buff_PI_d32_0.inv_PI_d16$1_0.VIN.t54 6to4_0.buff_PI_d32_0.inv_PI_d32_0.VIN VDD.t341 sg13_lv_pmos ad=0.1005p pd=1.34u as=55.5f ps=0.74u w=0.15u l=0.13u
X573 VDD.t1270 6to4_0.buff_PI_d32_1.inv_PI_d16$1_0.VIN 6to4_0.buff_PI_d32_1.inv_PI_d32_0.VIN VDD.t173 sg13_lv_pmos ad=55.5f pd=0.74u as=55.5f ps=0.74u w=0.15u l=0.13u
X574 6ph_rosc_0.psdiff_1.buff_d8$1_0.VIN.t3 6ph_rosc_0.psdiff_2.VOUTDP VSS.t225 VSS.t220 sg13_lv_nmos ad=55.5f pd=0.74u as=55.5f ps=0.74u w=0.15u l=0.13u
X575 6ph_rosc_0.psdiff_1.buff_d8$1_0.VIN.t29 a_7973_2194# VDD.t305 VDD.t301 sg13_lv_pmos ad=55.5f pd=0.74u as=55.5f ps=0.74u w=0.15u l=0.13u
X576 6ph_rosc_0.psdiff_2.VOUTDP 6ph_rosc_0.psdiff_2.buff_d8$1_0.inv_d8$1_0.VIN VDD.t145 VDD.t34 sg13_lv_pmos ad=55.5f pd=0.74u as=0.1005p ps=1.34u w=0.15u l=0.13u
X577 VSS.t781 6ph_rosc_0.psdiff_0.buff_d8$1_1.inv_d8$1_0.VIN 6ph_rosc_0.psdiff_2.CLKP.t2 VSS.t780 sg13_lv_nmos ad=0.1005p pd=1.34u as=55.5f ps=0.74u w=0.15u l=0.13u
X578 VSS.t438 6to4_0.buff_PI_d32_2.inv_PI_d32_0.VIN.t74 PH270.t16 VSS.t437 sg13_lv_nmos ad=0.1005p pd=1.34u as=55.5f ps=0.74u w=0.15u l=0.13u
X579 VDD.t1144 6ph_rosc_0.PH2.t12 6to4_0.PI_clk_0.inv_PI_d2$1_0.VOUT VDD.t1138 sg13_lv_pmos ad=0.1005p pd=1.34u as=55.5f ps=0.74u w=0.15u l=0.13u
X580 CTRL 6ph_rosc_0.PH1.t10 CTRL VDD.t82 sg13_lv_pmos ad=0.19p pd=1.38u as=0 ps=0 w=1u l=0.13u
X581 VSS.t1340 6to4_0.buff_PI_d32_3.inv_PI_d16$1_0.VIN.t58 6to4_0.buff_PI_d32_3.inv_PI_d32_0.VIN VSS.t1339 sg13_lv_nmos ad=0.1005p pd=1.34u as=55.5f ps=0.74u w=0.15u l=0.13u
X582 6to4_0.buff_PI_d32_3.buff_PI_d16$1_0.inv_PI_d4$1_0.VOUT.t9 6to4_0.buff_PI_d32_3.buff_PI_d16$1_0.inv_PI_d4$1_0.VIN VDD.t108 VDD.t99 sg13_lv_pmos ad=55.5f pd=0.74u as=0.1005p ps=1.34u w=0.15u l=0.13u
X583 6ph_rosc_0.psdiff_0.buff_d8$1_0.VIN.t8 VSS.t1965 VDD.t1323 VDD.t503 sg13_lv_pmos ad=55.5f pd=0.74u as=55.5f ps=0.74u w=0.15u l=0.13u
X584 6ph_rosc_0.PH4.t5 6ph_rosc_0.buff_d8$1_2.inv_d8$1_0.VIN VSS.t680 VSS.t679 sg13_lv_nmos ad=55.5f pd=0.74u as=0.1005p ps=1.34u w=0.15u l=0.13u
X585 6to4_0.buff_PI_d32_1.inv_PI_d32_0.VIN 6to4_0.buff_PI_d32_1.inv_PI_d16$1_0.VIN VSS.t1913 VSS.t1912 sg13_lv_nmos ad=55.5f pd=0.74u as=0.1005p ps=1.34u w=0.15u l=0.13u
X586 VDD.t418 6to4_0.buff_PI_d32_0.inv_PI_d32_0.VIN PH90.t55 VDD.t347 sg13_lv_pmos ad=0.1005p pd=1.34u as=55.5f ps=0.74u w=0.15u l=0.13u
X587 6to4_0.buff_PI_d32_3.inv_PI_d32_0.VIN 6to4_0.buff_PI_d32_3.inv_PI_d16$1_0.VIN.t48 VDD.t865 VDD.t679 sg13_lv_pmos ad=55.5f pd=0.74u as=0.1005p ps=1.34u w=0.15u l=0.13u
X588 VSS.t1620 6to4_0.buff_PI_d32_0.buff_PI_d16$1_0.inv_PI_d8$1_0.VOUT.t30 6to4_0.buff_PI_d32_0.inv_PI_d16$1_0.VIN.t18 VSS.t1619 sg13_lv_nmos ad=0.1005p pd=1.34u as=55.5f ps=0.74u w=0.15u l=0.13u
X589 6ph_rosc_0.psdiff_1.buff_d8$1_0.VIN.t12 6ph_rosc_0.psdiff_2.VOUTDP VSS.t223 VSS.t218 sg13_lv_nmos ad=55.5f pd=0.74u as=55.5f ps=0.74u w=0.15u l=0.13u
X590 CTRL 6ph_rosc_0.PH3.t11 CTRL VDD.t464 sg13_lv_pmos ad=0.19p pd=1.38u as=0 ps=0 w=1u l=0.13u
X591 6to4_0.buff_PI_d32_0.inv_PI_d16$1_0.VIN.t35 6to4_0.buff_PI_d32_0.buff_PI_d16$1_0.inv_PI_d8$1_0.VOUT.t35 VDD.t1113 VDD.t5 sg13_lv_pmos ad=0.1005p pd=1.34u as=55.5f ps=0.74u w=0.15u l=0.13u
X592 VSS.t1839 6to4_0.buff_PI_d32_3.buff_PI_d16$1_0.inv_PI_d8$1_0.VOUT.t36 6to4_0.buff_PI_d32_3.inv_PI_d16$1_0.VIN.t36 VSS.t1838 sg13_lv_nmos ad=0.1005p pd=1.34u as=55.5f ps=0.74u w=0.15u l=0.13u
X593 VSS.t1151 6ph_rosc_0.psdiff_2.VOUTDN 6ph_rosc_0.psdiff_1.buff_d8$1_1.VIN.t26 VSS.t1137 sg13_lv_nmos ad=55.5f pd=0.74u as=55.5f ps=0.74u w=0.15u l=0.13u
X594 CTRL 6ph_rosc_0.PH1.t10 CTRL VDD.t78 sg13_lv_pmos ad=0.19p pd=1.38u as=0 ps=0 w=1u l=0.13u
X595 VDD.t1077 6ph_rosc_0.psdiff_0.buff_d8$1_0.inv_d8$1_0.VIN 6ph_rosc_0.psdiff_2.CLKN VDD.t34 sg13_lv_pmos ad=0.1005p pd=1.34u as=55.5f ps=0.74u w=0.15u l=0.13u
X596 6ph_rosc_0.psdiff_1.buff_d8$1_1.inv_d8$1_0.VIN 6ph_rosc_0.psdiff_1.buff_d8$1_1.inv_d4$1_0.VIN VDD.t4 VDD.t0 sg13_lv_pmos ad=55.5f pd=0.74u as=0.1005p ps=1.34u w=0.15u l=0.13u
X597 VDD.t134 6to4_0.buff_PI_d32_2.buff_PI_d16$1_0.inv_PI_d4$1_0.VIN 6to4_0.buff_PI_d32_2.buff_PI_d16$1_0.inv_PI_d4$1_0.VOUT.t10 VDD.t126 sg13_lv_pmos ad=0.1005p pd=1.34u as=55.5f ps=0.74u w=0.15u l=0.13u
X598 6to4_0.buff_PI_d32_1.inv_PI_d32_0.VIN 6to4_0.buff_PI_d32_1.inv_PI_d16$1_0.VIN VDD.t1271 VDD.t17 sg13_lv_pmos ad=55.5f pd=0.74u as=55.5f ps=0.74u w=0.15u l=0.13u
X599 VDD.t447 6ph_rosc_0.buff_d8$1_0.inv_d8$1_0.VIN 6ph_rosc_0.PH2.t7 VDD.t89 sg13_lv_pmos ad=0.1005p pd=1.34u as=55.5f ps=0.74u w=0.15u l=0.13u
X600 CTRL 6ph_rosc_0.PH5.t12 CTRL VDD.t89 sg13_lv_pmos ad=0.19p pd=1.38u as=0 ps=0 w=1u l=0.13u
X601 VDD.t752 6to4_0.buff_PI_d32_3.inv_PI_d32_0.VIN PH180.t53 VDD.t677 sg13_lv_pmos ad=0.1005p pd=1.34u as=55.5f ps=0.74u w=0.15u l=0.13u
X602 VDD.t667 6to4_0.buff_PI_d32_2.VIN 6to4_0.flywheel_clk_0.PH0 VDD.t9 sg13_lv_pmos ad=0.1005p pd=1.34u as=55.5f ps=0.74u w=0.15u l=0.13u
X603 VDD.t241 6to4_0.buff_PI_d32_2.inv_PI_d32_0.VIN.t61 PH270.t87 VDD.t202 sg13_lv_pmos ad=55.5f pd=0.74u as=0.1005p ps=1.34u w=0.15u l=0.13u
X604 PH270.t15 6to4_0.buff_PI_d32_2.inv_PI_d32_0.VIN.t75 VSS.t442 VSS.t441 sg13_lv_nmos ad=55.5f pd=0.74u as=0.1005p ps=1.34u w=0.15u l=0.13u
X605 CTRL 6ph_rosc_0.PH3.t11 CTRL VDD.t464 sg13_lv_pmos ad=0.19p pd=1.38u as=0 ps=0 w=1u l=0.13u
X606 6ph_rosc_0.psdiff_0.buff_d8$1_1.inv_d8$1_0.VIN 6ph_rosc_0.psdiff_0.buff_d8$1_1.inv_d4$1_0.VIN VSS.t464 VSS.t463 sg13_lv_nmos ad=55.5f pd=0.74u as=0.1005p ps=1.34u w=0.15u l=0.13u
X607 VDD.t336 6to4_0.inv_PI_d2$1_2.VOUT 6to4_0.buff_PI_d32_3.buff_PI_d16$1_0.inv_PI_d4$1_0.VIN VDD.t99 sg13_lv_pmos ad=55.5f pd=0.74u as=0.1005p ps=1.34u w=0.15u l=0.13u
X608 VSS.t945 6to4_0.buff_PI_d32_1.inv_PI_d32_0.VIN PH0.t29 VSS.t944 sg13_lv_nmos ad=0.1005p pd=1.34u as=55.5f ps=0.74u w=0.15u l=0.13u
X609 6ph_rosc_0.psdiff_0.buff_d8$1_1.VIN.t13 a_12104_2338# VDD.t507 VDD.t503 sg13_lv_pmos ad=55.5f pd=0.74u as=55.5f ps=0.74u w=0.15u l=0.13u
X610 VDD.t1000 6to4_0.buff_PI_d32_2.inv_PI_d16$1_0.VIN.t58 6to4_0.buff_PI_d32_2.inv_PI_d32_0.VIN.t32 VDD.t126 sg13_lv_pmos ad=0.1005p pd=1.34u as=55.5f ps=0.74u w=0.15u l=0.13u
X611 6to4_0.buff_PI_d32_1.buff_PI_d16$1_0.inv_PI_d4$1_0.VOUT.t2 6to4_0.buff_PI_d32_1.buff_PI_d16$1_0.inv_PI_d4$1_0.VIN VSS.t37 VSS.t36 sg13_lv_nmos ad=55.5f pd=0.74u as=0.1005p ps=1.34u w=0.15u l=0.13u
X612 VSS.t789 6ph_rosc_0.buff_d8$1_4.inv_d2$1_0.VIN 6ph_rosc_0.buff_d8$1_4.inv_d4$1_0.VIN VSS.t788 sg13_lv_nmos ad=0.1005p pd=1.34u as=55.5f ps=0.74u w=0.15u l=0.13u
X613 6ph_rosc_0.psdiff_2.buff_d8$1_0.VIN.t27 a_4999_2194# VDD.t654 VDD.t470 sg13_lv_pmos ad=55.5f pd=0.74u as=0.1005p ps=1.34u w=0.15u l=0.13u
X614 CTRL 6ph_rosc_0.PH0.t10 CTRL VDD.t57 sg13_lv_pmos ad=0.19p pd=1.38u as=0 ps=0 w=1u l=0.13u
X615 VSS.t211 6ph_rosc_0.psdiff_2.VOUTDN 6ph_rosc_0.psdiff_1.buff_d8$1_1.VIN.t29 VSS.t1152 sg13_lv_nmos ad=55.5f pd=0.74u as=55.5f ps=0.74u w=0.15u l=0.13u
X616 VSS.t809 6ph_rosc_0.psdiff_1.VOUTDP 6ph_rosc_0.psdiff_0.buff_d8$1_0.VIN.t22 VSS.t812 sg13_lv_nmos ad=55.5f pd=0.74u as=55.5f ps=0.74u w=0.15u l=0.13u
X617 VDD.t1398 VSS.t1967 6ph_rosc_0.psdiff_1.buff_d8$1_0.VIN.t21 VDD.t301 sg13_lv_pmos ad=55.5f pd=0.74u as=55.5f ps=0.74u w=0.15u l=0.13u
X618 VDD.t1087 6to4_0.buff_PI_d32_0.buff_PI_d16$1_0.inv_PI_d8$1_0.VOUT.t26 6to4_0.buff_PI_d32_0.inv_PI_d16$1_0.VIN.t7 VDD.t341 sg13_lv_pmos ad=55.5f pd=0.74u as=55.5f ps=0.74u w=0.15u l=0.13u
X619 VSS.t1216 6to4_0.buff_PI_d32_2.buff_PI_d16$1_0.inv_PI_d8$1_0.VOUT.t33 6to4_0.buff_PI_d32_2.inv_PI_d16$1_0.VIN.t9 VSS.t1215 sg13_lv_nmos ad=0.1005p pd=1.34u as=55.5f ps=0.74u w=0.15u l=0.13u
X620 6ph_rosc_0.buff_d8$1_3.inv_d4$1_0.VIN 6ph_rosc_0.buff_d8$1_3.inv_d2$1_0.VIN VDD.t77 VDD.t75 sg13_lv_pmos ad=55.5f pd=0.74u as=0.1005p ps=1.34u w=0.15u l=0.13u
X621 6ph_rosc_0.psdiff_2.buff_d8$1_0.VIN.t31 a_4999_2194# VDD.t647 VDD.t470 sg13_lv_pmos ad=55.5f pd=0.74u as=55.5f ps=0.74u w=0.15u l=0.13u
X622 6to4_0.buff_PI_d32_0.buff_PI_d16$1_0.inv_PI_d8$1_0.VOUT.t15 6to4_0.buff_PI_d32_0.buff_PI_d16$1_0.inv_PI_d4$1_0.VOUT.t17 VSS.t1278 VSS.t1277 sg13_lv_nmos ad=55.5f pd=0.74u as=0.1005p ps=1.34u w=0.15u l=0.13u
X623 VSS.t243 6ph_rosc_0.psdiff_2.VOUTDP 6ph_rosc_0.psdiff_1.buff_d8$1_0.VIN.t6 VSS.t228 sg13_lv_nmos ad=55.5f pd=0.74u as=55.5f ps=0.74u w=0.15u l=0.13u
X624 VSS.t620 6to4_0.buff_PI_d32_0.inv_PI_d32_0.VIN PH90.t28 VSS.t619 sg13_lv_nmos ad=0.1005p pd=1.34u as=55.5f ps=0.74u w=0.15u l=0.13u
X625 CTRL 6ph_rosc_0.PH5.t12 CTRL VDD.t85 sg13_lv_pmos ad=0.19p pd=1.38u as=0 ps=0 w=1u l=0.13u
X626 VSS.t1314 6to4_0.buff_PI_d32_3.inv_PI_d16$1_0.VIN.t52 6to4_0.buff_PI_d32_3.inv_PI_d32_0.VIN VSS.t1313 sg13_lv_nmos ad=0.1005p pd=1.34u as=55.5f ps=0.74u w=0.15u l=0.13u
X627 6to4_0.buff_PI_d32_2.buff_PI_d16$1_0.inv_PI_d8$1_0.VOUT.t20 6to4_0.buff_PI_d32_2.buff_PI_d16$1_0.inv_PI_d4$1_0.VOUT.t15 VDD.t1049 VDD.t198 sg13_lv_pmos ad=55.5f pd=0.74u as=55.5f ps=0.74u w=0.15u l=0.13u
X628 6to4_0.buff_PI_d32_1.inv_PI_d16$1_0.VIN 6to4_0.buff_PI_d32_1.buff_PI_d16$1_0.inv_PI_d8$1_0.VOUT.t31 VDD.t1187 VDD.t17 sg13_lv_pmos ad=55.5f pd=0.74u as=0.1005p ps=1.34u w=0.15u l=0.13u
X629 VSS.t823 6ph_rosc_0.psdiff_1.VOUTDN 6ph_rosc_0.psdiff_0.buff_d8$1_1.VIN.t27 VSS.t1938 sg13_lv_nmos ad=55.5f pd=0.74u as=55.5f ps=0.74u w=0.15u l=0.13u
X630 6to4_0.buff_PI_d32_3.inv_PI_d32_0.VIN 6to4_0.buff_PI_d32_3.inv_PI_d16$1_0.VIN.t59 VSS.t1344 VSS.t1343 sg13_lv_nmos ad=55.5f pd=0.74u as=0.1005p ps=1.34u w=0.15u l=0.13u
X631 VDD.t623 6to4_0.buff_PI_d32_1.inv_PI_d32_0.VIN PH0.t53 VDD.t547 sg13_lv_pmos ad=55.5f pd=0.74u as=55.5f ps=0.74u w=0.15u l=0.13u
X632 VDD.t216 6to4_0.buff_PI_d32_2.inv_PI_d32_0.VIN.t53 PH270.t86 VDD.t215 sg13_lv_pmos ad=0.1005p pd=1.34u as=55.5f ps=0.74u w=0.15u l=0.13u
X633 VSS.t61 6to4_0.flywheel_clk_1.PH0 6to4_0.buff_PI_d32_1.buff_PI_d16$1_0.inv_PI_d4$1_0.VIN VSS.t60 sg13_lv_nmos ad=0.1005p pd=1.34u as=55.5f ps=0.74u w=0.15u l=0.13u
X634 VSS.t838 6ph_rosc_0.psdiff_1.VOUTDP 6ph_rosc_0.psdiff_0.buff_d8$1_0.VIN.t23 VSS.t810 sg13_lv_nmos ad=55.5f pd=0.74u as=55.5f ps=0.74u w=0.15u l=0.13u
X635 VSS.t1448 6to4_0.buff_PI_d32_2.inv_PI_d16$1_0.VIN.t50 6to4_0.buff_PI_d32_2.inv_PI_d32_0.VIN.t6 VSS.t1447 sg13_lv_nmos ad=0.1005p pd=1.34u as=55.5f ps=0.74u w=0.15u l=0.13u
X636 CTRL 6ph_rosc_0.PH4.t10 CTRL VDD.t451 sg13_lv_pmos ad=0.19p pd=1.38u as=0 ps=0 w=1u l=0.13u
X637 VSS.t943 6to4_0.buff_PI_d32_1.inv_PI_d32_0.VIN PH0.t14 VSS.t942 sg13_lv_nmos ad=0.1005p pd=1.34u as=55.5f ps=0.74u w=0.15u l=0.13u
X638 VDD.t417 6to4_0.buff_PI_d32_0.inv_PI_d32_0.VIN PH90.t53 VDD.t5 sg13_lv_pmos ad=0.1005p pd=1.34u as=55.5f ps=0.74u w=0.15u l=0.13u
X639 6to4_0.buff_PI_d32_1.inv_PI_d16$1_0.VIN 6to4_0.buff_PI_d32_1.buff_PI_d16$1_0.inv_PI_d8$1_0.VOUT.t37 VDD.t1159 VDD.t173 sg13_lv_pmos ad=0.1005p pd=1.34u as=55.5f ps=0.74u w=0.15u l=0.13u
X640 VDD.t710 6to4_0.buff_PI_d32_3.inv_PI_d32_0.VIN PH180.t78 VDD.t677 sg13_lv_pmos ad=55.5f pd=0.74u as=55.5f ps=0.74u w=0.15u l=0.13u
X641 VDD.t1234 6to4_0.buff_PI_d32_3.buff_PI_d16$1_0.inv_PI_d8$1_0.VOUT.t36 6to4_0.buff_PI_d32_3.inv_PI_d16$1_0.VIN.t38 VDD.t99 sg13_lv_pmos ad=55.5f pd=0.74u as=0.1005p ps=1.34u w=0.15u l=0.13u
X642 6to4_0.flywheel_clk_0.PH0 6to4_0.PI_clk_0.inv_PI_d2$1_0.VOUT VDD.t122 VDD.t9 sg13_lv_pmos ad=0.1005p pd=1.34u as=55.5f ps=0.74u w=0.15u l=0.13u
X643 6to4_0.buff_PI_d32_3.inv_PI_d32_0.VIN 6to4_0.buff_PI_d32_3.inv_PI_d16$1_0.VIN.t60 VSS.t1348 VSS.t1347 sg13_lv_nmos ad=55.5f pd=0.74u as=0.1005p ps=1.34u w=0.15u l=0.13u
X644 VDD.t586 6to4_0.buff_PI_d32_1.inv_PI_d32_0.VIN PH0.t88 VDD.t547 sg13_lv_pmos ad=55.5f pd=0.74u as=0.1005p ps=1.34u w=0.15u l=0.13u
X645 VSS.t1105 6to4_0.buff_PI_d32_3.inv_PI_d32_0.VIN PH180.t28 VSS.t1104 sg13_lv_nmos ad=0.1005p pd=1.34u as=55.5f ps=0.74u w=0.15u l=0.13u
X646 VSS.t446 6to4_0.buff_PI_d32_2.inv_PI_d32_0.VIN.t76 PH270.t20 VSS.t445 sg13_lv_nmos ad=0.1005p pd=1.34u as=55.5f ps=0.74u w=0.15u l=0.13u
X647 VDD.t1305 VSS.t1965 6ph_rosc_0.psdiff_0.buff_d8$1_1.VIN.t4 VDD.t503 sg13_lv_pmos ad=55.5f pd=0.74u as=55.5f ps=0.74u w=0.15u l=0.13u
X648 PH270.t85 6to4_0.buff_PI_d32_2.inv_PI_d32_0.VIN.t68 VDD.t261 VDD.t126 sg13_lv_pmos ad=0.1005p pd=1.34u as=55.5f ps=0.74u w=0.15u l=0.13u
X649 VSS.t1270 6to4_0.buff_PI_d32_0.buff_PI_d16$1_0.inv_PI_d4$1_0.VOUT.t15 6to4_0.buff_PI_d32_0.buff_PI_d16$1_0.inv_PI_d8$1_0.VOUT.t9 VSS.t1269 sg13_lv_nmos ad=0.1005p pd=1.34u as=55.5f ps=0.74u w=0.15u l=0.13u
X650 6to4_0.inv_PI_d2$1_2.VOUT 6to4_0.inv_PI_d2$1_3.VOUT VSS.t506 VSS.t505 sg13_lv_nmos ad=55.5f pd=0.74u as=0.1005p ps=1.34u w=0.15u l=0.13u
X651 PH90.t23 6to4_0.buff_PI_d32_0.inv_PI_d32_0.VIN VSS.t590 VSS.t589 sg13_lv_nmos ad=55.5f pd=0.74u as=0.1005p ps=1.34u w=0.15u l=0.13u
X652 VDD.t1333 VSS.t1965 6ph_rosc_0.psdiff_0.buff_d8$1_1.VIN.t5 VDD.t503 sg13_lv_pmos ad=55.5f pd=0.74u as=55.5f ps=0.74u w=0.15u l=0.13u
X653 VDD.t904 6to4_0.buff_PI_d32_3.inv_PI_d16$1_0.VIN.t61 6to4_0.buff_PI_d32_3.inv_PI_d32_0.VIN VDD.t679 sg13_lv_pmos ad=0.1005p pd=1.34u as=55.5f ps=0.74u w=0.15u l=0.13u
X654 6ph_rosc_0.psdiff_0.buff_d8$1_1.VIN.t29 6ph_rosc_0.psdiff_1.VOUTDN VSS.t1946 VSS.t1943 sg13_lv_nmos ad=55.5f pd=0.74u as=55.5f ps=0.74u w=0.15u l=0.13u
X655 6to4_0.buff_PI_d32_0.inv_PI_d32_0.VIN 6to4_0.buff_PI_d32_0.inv_PI_d16$1_0.VIN.t60 VDD.t957 VDD.t341 sg13_lv_pmos ad=55.5f pd=0.74u as=55.5f ps=0.74u w=0.15u l=0.13u
X656 VSS.t5 6ph_rosc_0.psdiff_1.buff_d8$1_1.inv_d4$1_0.VIN 6ph_rosc_0.psdiff_1.buff_d8$1_1.inv_d8$1_0.VIN VSS.t4 sg13_lv_nmos ad=0.1005p pd=1.34u as=55.5f ps=0.74u w=0.15u l=0.13u
X657 6to4_0.buff_PI_d32_3.inv_PI_d32_0.VIN 6to4_0.buff_PI_d32_3.inv_PI_d16$1_0.VIN.t62 VDD.t905 VDD.t679 sg13_lv_pmos ad=0.1005p pd=1.34u as=55.5f ps=0.74u w=0.15u l=0.13u
X658 6to4_0.buff_PI_d32_0.inv_PI_d32_0.VIN 6to4_0.buff_PI_d32_0.inv_PI_d16$1_0.VIN.t61 VDD.t959 VDD.t5 sg13_lv_pmos ad=0.1005p pd=1.34u as=55.5f ps=0.74u w=0.15u l=0.13u
X659 6to4_0.buff_PI_d32_1.buff_PI_d16$1_0.inv_PI_d8$1_0.VOUT.t8 6to4_0.buff_PI_d32_1.buff_PI_d16$1_0.inv_PI_d4$1_0.VOUT.t14 VSS.t310 VSS.t309 sg13_lv_nmos ad=55.5f pd=0.74u as=0.1005p ps=1.34u w=0.15u l=0.13u
X660 6to4_0.buff_PI_d32_1.inv_PI_d32_0.VIN 6to4_0.buff_PI_d32_1.inv_PI_d16$1_0.VIN VDD.t1289 VDD.t173 sg13_lv_pmos ad=55.5f pd=0.74u as=0.1005p ps=1.34u w=0.15u l=0.13u
X661 6to4_0.buff_PI_d32_2.buff_PI_d16$1_0.inv_PI_d8$1_0.VOUT.t17 6to4_0.buff_PI_d32_2.buff_PI_d16$1_0.inv_PI_d4$1_0.VOUT.t13 VDD.t1045 VDD.t198 sg13_lv_pmos ad=55.5f pd=0.74u as=0.1005p ps=1.34u w=0.15u l=0.13u
X662 PH90.t77 6to4_0.buff_PI_d32_0.inv_PI_d32_0.VIN VDD.t416 VDD.t343 sg13_lv_pmos ad=55.5f pd=0.74u as=0.1005p ps=1.34u w=0.15u l=0.13u
X663 6to4_0.buff_PI_d32_2.inv_PI_d32_0.VIN.t36 6to4_0.buff_PI_d32_2.inv_PI_d16$1_0.VIN.t60 VSS.t1488 VSS.t1487 sg13_lv_nmos ad=55.5f pd=0.74u as=0.1005p ps=1.34u w=0.15u l=0.13u
X664 6ph_rosc_0.buff_d8$1_4.inv_d8$1_0.VIN 6ph_rosc_0.buff_d8$1_4.inv_d4$1_0.VIN VDD.t461 VDD.t75 sg13_lv_pmos ad=55.5f pd=0.74u as=0.1005p ps=1.34u w=0.15u l=0.13u
X665 VDD.t914 6ph_rosc_0.PH1.t12 6to4_0.PI_clk_0.inv_PI_d2$1_0.VOUT VDD.t5 sg13_lv_pmos ad=55.5f pd=0.74u as=55.5f ps=0.74u w=0.15u l=0.13u
X666 VSS.t1103 6to4_0.buff_PI_d32_3.inv_PI_d32_0.VIN PH180.t11 VSS.t1102 sg13_lv_nmos ad=0.1005p pd=1.34u as=55.5f ps=0.74u w=0.15u l=0.13u
X667 VDD.t492 6to4_0.inv_PI_d2$1_1.VIN 6to4_0.flywheel_clk_1.PH0 VDD.t17 sg13_lv_pmos ad=55.5f pd=0.74u as=0.1005p ps=1.34u w=0.15u l=0.13u
X668 VDD.t750 6to4_0.buff_PI_d32_3.inv_PI_d32_0.VIN PH180.t77 VDD.t673 sg13_lv_pmos ad=0.1005p pd=1.34u as=55.5f ps=0.74u w=0.15u l=0.13u
X669 6to4_0.buff_PI_d32_3.inv_PI_d16$1_0.VIN.t40 6to4_0.buff_PI_d32_3.buff_PI_d16$1_0.inv_PI_d8$1_0.VOUT.t37 VDD.t1238 VDD.t679 sg13_lv_pmos ad=55.5f pd=0.74u as=55.5f ps=0.74u w=0.15u l=0.13u
X670 6to4_0.inv_PI_d2$1_2.VOUT 6to4_0.flywheel_clk_1.PH0 VDD.t44 VDD.t37 sg13_lv_pmos ad=55.5f pd=0.74u as=0.1005p ps=1.34u w=0.15u l=0.13u
X671 6to4_0.buff_PI_d32_0.inv_PI_d32_0.VIN 6to4_0.buff_PI_d32_0.inv_PI_d16$1_0.VIN.t51 VSS.t1388 VSS.t1387 sg13_lv_nmos ad=55.5f pd=0.74u as=0.1005p ps=1.34u w=0.15u l=0.13u
X672 PH90.t59 6to4_0.buff_PI_d32_0.inv_PI_d32_0.VIN VDD.t374 VDD.t347 sg13_lv_pmos ad=55.5f pd=0.74u as=55.5f ps=0.74u w=0.15u l=0.13u
X673 6ph_rosc_0.PH0.t4 6ph_rosc_0.buff_d8$1_5.inv_d8$1_0.VIN VDD.t56 VDD.t48 sg13_lv_pmos ad=55.5f pd=0.74u as=0.1005p ps=1.34u w=0.15u l=0.13u
X674 CTRL 6ph_rosc_0.PH5.t12 CTRL VDD.t89 sg13_lv_pmos ad=0.19p pd=1.38u as=0 ps=0 w=1u l=0.13u
X675 PH180.t1 6to4_0.buff_PI_d32_3.inv_PI_d32_0.VIN VSS.t1101 VSS.t1100 sg13_lv_nmos ad=55.5f pd=0.74u as=0.1005p ps=1.34u w=0.15u l=0.13u
X676 6ph_rosc_0.psdiff_1.buff_d8$1_0.VIN.t10 6ph_rosc_0.psdiff_2.VOUTDP VSS.t217 VSS.t212 sg13_lv_nmos ad=55.5f pd=0.74u as=55.5f ps=0.74u w=0.15u l=0.13u
X677 VDD.t606 6to4_0.buff_PI_d32_1.inv_PI_d32_0.VIN PH0.t87 VDD.t17 sg13_lv_pmos ad=55.5f pd=0.74u as=0.1005p ps=1.34u w=0.15u l=0.13u
X678 VDD.t1185 6to4_0.buff_PI_d32_1.buff_PI_d16$1_0.inv_PI_d8$1_0.VOUT.t29 6to4_0.buff_PI_d32_1.inv_PI_d16$1_0.VIN VDD.t173 sg13_lv_pmos ad=0.1005p pd=1.34u as=55.5f ps=0.74u w=0.15u l=0.13u
X679 6ph_rosc_0.psdiff_2.VOUTDP 6ph_rosc_0.psdiff_2.buff_d8$1_0.inv_d8$1_0.VIN VDD.t144 VDD.t34 sg13_lv_pmos ad=55.5f pd=0.74u as=0.1005p ps=1.34u w=0.15u l=0.13u
X680 CTRL 6ph_rosc_0.PH0.t10 CTRL VDD.t57 sg13_lv_pmos ad=0.19p pd=1.38u as=0 ps=0 w=1u l=0.13u
X681 6to4_0.buff_PI_d32_2.inv_PI_d32_0.VIN.t1 6to4_0.buff_PI_d32_2.inv_PI_d16$1_0.VIN.t48 VDD.t969 VDD.t126 sg13_lv_pmos ad=55.5f pd=0.74u as=55.5f ps=0.74u w=0.15u l=0.13u
X682 VDD.t1352 VSS.t1966 6ph_rosc_0.psdiff_2.buff_d8$1_0.VIN.t2 VDD.t470 sg13_lv_pmos ad=55.5f pd=0.74u as=55.5f ps=0.74u w=0.15u l=0.13u
X683 6ph_rosc_0.psdiff_1.buff_d8$1_0.VIN.t11 6ph_rosc_0.psdiff_2.VOUTDP VSS.t241 VSS.t210 sg13_lv_nmos ad=55.5f pd=0.74u as=55.5f ps=0.74u w=0.15u l=0.13u
X684 6ph_rosc_0.psdiff_2.CLKP.t1 6ph_rosc_0.psdiff_0.buff_d8$1_1.inv_d8$1_0.VIN VSS.t779 VSS.t778 sg13_lv_nmos ad=55.5f pd=0.74u as=0.1005p ps=1.34u w=0.15u l=0.13u
X685 VSS.t1312 6to4_0.buff_PI_d32_3.inv_PI_d16$1_0.VIN.t51 6to4_0.buff_PI_d32_3.inv_PI_d32_0.VIN VSS.t1311 sg13_lv_nmos ad=0.1005p pd=1.34u as=55.5f ps=0.74u w=0.15u l=0.13u
X686 6ph_rosc_0.PH3.t9 6ph_rosc_0.buff_d8$1_4.inv_d8$1_0.VIN VDD.t486 VDD.t75 sg13_lv_pmos ad=55.5f pd=0.74u as=0.1005p ps=1.34u w=0.15u l=0.13u
X687 VDD.t1235 6to4_0.buff_PI_d32_3.buff_PI_d16$1_0.inv_PI_d8$1_0.VOUT.t36 6to4_0.buff_PI_d32_3.inv_PI_d16$1_0.VIN.t37 VDD.t99 sg13_lv_pmos ad=0.1005p pd=1.34u as=55.5f ps=0.74u w=0.15u l=0.13u
X688 6to4_0.buff_PI_d32_0.inv_PI_d16$1_0.VIN.t38 6to4_0.buff_PI_d32_0.buff_PI_d16$1_0.inv_PI_d8$1_0.VOUT.t36 VDD.t1118 VDD.t341 sg13_lv_pmos ad=55.5f pd=0.74u as=0.1005p ps=1.34u w=0.15u l=0.13u
X689 VDD.t1353 VSS.t1966 6ph_rosc_0.psdiff_2.buff_d8$1_0.VIN.t7 VDD.t470 sg13_lv_pmos ad=55.5f pd=0.74u as=55.5f ps=0.74u w=0.15u l=0.13u
X690 PH90.t16 6to4_0.buff_PI_d32_0.inv_PI_d32_0.VIN VSS.t618 VSS.t617 sg13_lv_nmos ad=55.5f pd=0.74u as=0.1005p ps=1.34u w=0.15u l=0.13u
X691 VSS.t326 6to4_0.buff_PI_d32_1.buff_PI_d16$1_0.inv_PI_d4$1_0.VOUT.t18 6to4_0.buff_PI_d32_1.buff_PI_d16$1_0.inv_PI_d8$1_0.VOUT.t20 VSS.t325 sg13_lv_nmos ad=0.1005p pd=1.34u as=55.5f ps=0.74u w=0.15u l=0.13u
X692 6ph_rosc_0.psdiff_0.buff_d8$1_0.inv_d4$1_0.VIN 6ph_rosc_0.psdiff_0.buff_d8$1_0.inv_d2$1_0.VIN VDD.t35 VDD.t34 sg13_lv_pmos ad=55.5f pd=0.74u as=0.1005p ps=1.34u w=0.15u l=0.13u
X693 VDD.t474 a_6156_2338# 6ph_rosc_0.psdiff_2.buff_d8$1_1.VIN.t28 VDD.t470 sg13_lv_pmos ad=55.5f pd=0.74u as=55.5f ps=0.74u w=0.15u l=0.13u
X694 VDD.t1240 6to4_0.buff_PI_d32_3.buff_PI_d16$1_0.inv_PI_d8$1_0.VOUT.t38 6to4_0.buff_PI_d32_3.inv_PI_d16$1_0.VIN.t44 VDD.t679 sg13_lv_pmos ad=55.5f pd=0.74u as=55.5f ps=0.74u w=0.15u l=0.13u
X695 VSS.t59 6to4_0.flywheel_clk_1.PH0 6to4_0.inv_PI_d2$1_2.VOUT VSS.t58 sg13_lv_nmos ad=0.1005p pd=1.34u as=55.5f ps=0.74u w=0.15u l=0.13u
X696 6to4_0.buff_PI_d32_0.inv_PI_d16$1_0.VIN.t41 6to4_0.buff_PI_d32_0.buff_PI_d16$1_0.inv_PI_d8$1_0.VOUT.t37 VDD.t1119 VDD.t5 sg13_lv_pmos ad=55.5f pd=0.74u as=55.5f ps=0.74u w=0.15u l=0.13u
X697 VDD.t1046 6to4_0.buff_PI_d32_2.buff_PI_d16$1_0.inv_PI_d4$1_0.VOUT.t14 6to4_0.buff_PI_d32_2.buff_PI_d16$1_0.inv_PI_d8$1_0.VOUT.t23 VDD.t198 sg13_lv_pmos ad=55.5f pd=0.74u as=0.1005p ps=1.34u w=0.15u l=0.13u
X698 6ph_rosc_0.psdiff_1.buff_d8$1_1.VIN.t6 VSS.t1967 VDD.t1390 VDD.t301 sg13_lv_pmos ad=55.5f pd=0.74u as=55.5f ps=0.74u w=0.15u l=0.13u
X699 6to4_0.buff_PI_d32_0.inv_PI_d32_0.VIN 6to4_0.buff_PI_d32_0.inv_PI_d16$1_0.VIN.t59 VSS.t1420 VSS.t1419 sg13_lv_nmos ad=55.5f pd=0.74u as=0.1005p ps=1.34u w=0.15u l=0.13u
X700 6to4_0.PI_clk_1.inv_PI_d2$1_0.VOUT 6ph_rosc_0.PH5.t11 VSS.t1664 VSS.t1663 sg13_lv_nmos ad=55.5f pd=0.74u as=0.1005p ps=1.34u w=0.15u l=0.13u
X701 6to4_0.PI_clk_0.inv_PI_d2$1_0.VOUT 6ph_rosc_0.PH1.t11 VDD.t912 VDD.t5 sg13_lv_pmos ad=55.5f pd=0.74u as=55.5f ps=0.74u w=0.15u l=0.13u
X702 6to4_0.buff_PI_d32_0.buff_PI_d16$1_0.inv_PI_d4$1_0.VOUT.t2 6to4_0.buff_PI_d32_0.buff_PI_d16$1_0.inv_PI_d4$1_0.VIN VSS.t97 VSS.t96 sg13_lv_nmos ad=55.5f pd=0.74u as=0.1005p ps=1.34u w=0.15u l=0.13u
X703 VDD.t475 a_4999_2194# 6ph_rosc_0.psdiff_2.buff_d8$1_0.VIN.t31 VDD.t470 sg13_lv_pmos ad=55.5f pd=0.74u as=55.5f ps=0.74u w=0.15u l=0.13u
X704 PH180.t36 6to4_0.buff_PI_d32_3.inv_PI_d32_0.VIN VDD.t691 VDD.t679 sg13_lv_pmos ad=55.5f pd=0.74u as=55.5f ps=0.74u w=0.15u l=0.13u
X705 CTRL 6ph_rosc_0.PH4.t10 CTRL VDD.t451 sg13_lv_pmos ad=0.19p pd=1.38u as=0 ps=0 w=1u l=0.13u
X706 PH90.t57 6to4_0.buff_PI_d32_0.inv_PI_d32_0.VIN VDD.t414 VDD.t5 sg13_lv_pmos ad=55.5f pd=0.74u as=55.5f ps=0.74u w=0.15u l=0.13u
X707 6to4_0.buff_PI_d32_2.inv_PI_d32_0.VIN.t39 6to4_0.buff_PI_d32_2.inv_PI_d16$1_0.VIN.t61 VSS.t1492 VSS.t1491 sg13_lv_nmos ad=55.5f pd=0.74u as=0.1005p ps=1.34u w=0.15u l=0.13u
X708 6ph_rosc_0.psdiff_1.buff_d8$1_1.VIN.t7 VSS.t1967 VDD.t1400 VDD.t301 sg13_lv_pmos ad=55.5f pd=0.74u as=55.5f ps=0.74u w=0.15u l=0.13u
X709 PH0.t62 6to4_0.buff_PI_d32_1.inv_PI_d32_0.VIN VDD.t620 VDD.t17 sg13_lv_pmos ad=55.5f pd=0.74u as=0.1005p ps=1.34u w=0.15u l=0.13u
X710 VDD.t174 6to4_0.buff_PI_d32_1.buff_PI_d16$1_0.inv_PI_d4$1_0.VOUT.t12 6to4_0.buff_PI_d32_1.buff_PI_d16$1_0.inv_PI_d8$1_0.VOUT.t0 VDD.t173 sg13_lv_pmos ad=55.5f pd=0.74u as=55.5f ps=0.74u w=0.15u l=0.13u
X711 VDD.t477 a_6156_2338# 6ph_rosc_0.psdiff_2.buff_d8$1_1.VIN.t27 VDD.t470 sg13_lv_pmos ad=55.5f pd=0.74u as=55.5f ps=0.74u w=0.15u l=0.13u
X712 VDD.t1011 6to4_0.buff_PI_d32_2.inv_PI_d16$1_0.VIN.t62 6to4_0.buff_PI_d32_2.inv_PI_d32_0.VIN.t44 VDD.t198 sg13_lv_pmos ad=55.5f pd=0.74u as=0.1005p ps=1.34u w=0.15u l=0.13u
X713 VSS.t1911 6to4_0.buff_PI_d32_1.inv_PI_d16$1_0.VIN 6to4_0.buff_PI_d32_1.inv_PI_d32_0.VIN VSS.t1910 sg13_lv_nmos ad=0.1005p pd=1.34u as=55.5f ps=0.74u w=0.15u l=0.13u
X714 6to4_0.buff_PI_d32_1.buff_PI_d16$1_0.inv_PI_d4$1_0.VOUT.t1 6to4_0.buff_PI_d32_1.buff_PI_d16$1_0.inv_PI_d4$1_0.VIN VSS.t35 VSS.t34 sg13_lv_nmos ad=55.5f pd=0.74u as=0.1005p ps=1.34u w=0.15u l=0.13u
X715 VDD.t877 6to4_0.buff_PI_d32_3.inv_PI_d16$1_0.VIN.t52 6to4_0.buff_PI_d32_3.inv_PI_d32_0.VIN VDD.t99 sg13_lv_pmos ad=0.1005p pd=1.34u as=55.5f ps=0.74u w=0.15u l=0.13u
X716 VSS.t19 6to4_0.flywheel_clk_0.PH0 6to4_0.buff_PI_d32_0.buff_PI_d16$1_0.inv_PI_d4$1_0.VIN VSS.t18 sg13_lv_nmos ad=0.1005p pd=1.34u as=55.5f ps=0.74u w=0.15u l=0.13u
X717 6ph_rosc_0.psdiff_2.buff_d8$1_1.VIN.t6 6ph_rosc_0.psdiff_2.CLKP.t8 VSS.t1704 VSS.t1687 sg13_lv_nmos ad=55.5f pd=0.74u as=55.5f ps=0.74u w=0.15u l=0.13u
X718 VSS.t1831 6to4_0.buff_PI_d32_3.buff_PI_d16$1_0.inv_PI_d8$1_0.VOUT.t34 6to4_0.buff_PI_d32_3.inv_PI_d16$1_0.VIN.t30 VSS.t1830 sg13_lv_nmos ad=0.1005p pd=1.34u as=55.5f ps=0.74u w=0.15u l=0.13u
X719 VDD.t619 6to4_0.buff_PI_d32_1.inv_PI_d32_0.VIN PH0.t86 VDD.t17 sg13_lv_pmos ad=0.1005p pd=1.34u as=55.5f ps=0.74u w=0.15u l=0.13u
X720 6to4_0.buff_PI_d32_3.buff_PI_d16$1_0.inv_PI_d4$1_0.VOUT.t1 6to4_0.buff_PI_d32_3.buff_PI_d16$1_0.inv_PI_d4$1_0.VIN VSS.t147 VSS.t146 sg13_lv_nmos ad=55.5f pd=0.74u as=0.1005p ps=1.34u w=0.15u l=0.13u
X721 VDD.t707 6to4_0.buff_PI_d32_3.inv_PI_d32_0.VIN PH180.t73 VDD.t679 sg13_lv_pmos ad=55.5f pd=0.74u as=55.5f ps=0.74u w=0.15u l=0.13u
X722 VDD.t841 6to4_0.buff_PI_d32_0.buff_PI_d16$1_0.inv_PI_d4$1_0.VOUT.t14 6to4_0.buff_PI_d32_0.buff_PI_d16$1_0.inv_PI_d8$1_0.VOUT.t8 VDD.t341 sg13_lv_pmos ad=55.5f pd=0.74u as=0.1005p ps=1.34u w=0.15u l=0.13u
X723 VSS.t1228 6to4_0.buff_PI_d32_2.buff_PI_d16$1_0.inv_PI_d8$1_0.VOUT.t36 6to4_0.buff_PI_d32_2.inv_PI_d16$1_0.VIN.t8 VSS.t1227 sg13_lv_nmos ad=0.1005p pd=1.34u as=55.5f ps=0.74u w=0.15u l=0.13u
X724 VSS.t79 6ph_rosc_0.buff_d8$1_5.inv_d8$1_0.VIN 6ph_rosc_0.PH0.t0 VSS.t78 sg13_lv_nmos ad=0.1005p pd=1.34u as=55.5f ps=0.74u w=0.15u l=0.13u
X725 PH180.t18 6to4_0.buff_PI_d32_3.inv_PI_d32_0.VIN VSS.t1099 VSS.t1098 sg13_lv_nmos ad=55.5f pd=0.74u as=0.1005p ps=1.34u w=0.15u l=0.13u
X726 VSS.t1658 6ph_rosc_0.PH5.t10 6to4_0.PI_clk_1.inv_PI_d2$1_0.VOUT VSS.t1657 sg13_lv_nmos ad=0.1005p pd=1.34u as=55.5f ps=0.74u w=0.15u l=0.13u
X727 VDD.t1031 6to4_0.buff_PI_d32_3.buff_PI_d16$1_0.inv_PI_d4$1_0.VOUT.t13 6to4_0.buff_PI_d32_3.buff_PI_d16$1_0.inv_PI_d8$1_0.VOUT.t9 VDD.t679 sg13_lv_pmos ad=55.5f pd=0.74u as=55.5f ps=0.74u w=0.15u l=0.13u
X728 VDD.t392 6to4_0.buff_PI_d32_0.inv_PI_d32_0.VIN PH90.t87 VDD.t341 sg13_lv_pmos ad=55.5f pd=0.74u as=0.1005p ps=1.34u w=0.15u l=0.13u
X729 6to4_0.buff_PI_d32_2.buff_PI_d16$1_0.inv_PI_d8$1_0.VOUT.t4 6to4_0.buff_PI_d32_2.buff_PI_d16$1_0.inv_PI_d4$1_0.VOUT.t18 VSS.t1560 VSS.t1559 sg13_lv_nmos ad=55.5f pd=0.74u as=0.1005p ps=1.34u w=0.15u l=0.13u
X730 PH270.t84 6to4_0.buff_PI_d32_2.inv_PI_d32_0.VIN.t69 VDD.t264 VDD.t198 sg13_lv_pmos ad=0.1005p pd=1.34u as=55.5f ps=0.74u w=0.15u l=0.13u
X731 6to4_0.buff_PI_d32_0.inv_PI_d32_0.VIN 6to4_0.buff_PI_d32_0.inv_PI_d16$1_0.VIN.t60 VSS.t1424 VSS.t1423 sg13_lv_nmos ad=55.5f pd=0.74u as=0.1005p ps=1.34u w=0.15u l=0.13u
X732 VSS.t616 6to4_0.buff_PI_d32_0.inv_PI_d32_0.VIN PH90.t12 VSS.t615 sg13_lv_nmos ad=0.1005p pd=1.34u as=55.5f ps=0.74u w=0.15u l=0.13u
X733 VSS.t376 6to4_0.buff_PI_d32_2.inv_PI_d32_0.VIN.t59 PH270.t30 VSS.t375 sg13_lv_nmos ad=0.1005p pd=1.34u as=55.5f ps=0.74u w=0.15u l=0.13u
X734 6to4_0.buff_PI_d32_1.inv_PI_d32_0.VIN 6to4_0.buff_PI_d32_1.inv_PI_d16$1_0.VIN VSS.t1909 VSS.t1908 sg13_lv_nmos ad=55.5f pd=0.74u as=0.1005p ps=1.34u w=0.15u l=0.13u
X735 6to4_0.buff_PI_d32_0.buff_PI_d16$1_0.inv_PI_d8$1_0.VOUT.t12 6to4_0.buff_PI_d32_0.buff_PI_d16$1_0.inv_PI_d4$1_0.VOUT.t16 VSS.t1274 VSS.t1273 sg13_lv_nmos ad=55.5f pd=0.74u as=0.1005p ps=1.34u w=0.15u l=0.13u
X736 VDD.t32 6ph_rosc_0.psdiff_2.buff_d8$1_1.inv_d4$1_0.VIN 6ph_rosc_0.psdiff_2.buff_d8$1_1.inv_d8$1_0.VIN VDD.t0 sg13_lv_pmos ad=0.1005p pd=1.34u as=55.5f ps=0.74u w=0.15u l=0.13u
X737 6to4_0.buff_PI_d32_3.inv_PI_d32_0.VIN 6to4_0.buff_PI_d32_3.inv_PI_d16$1_0.VIN.t56 VSS.t1332 VSS.t1331 sg13_lv_nmos ad=55.5f pd=0.74u as=0.1005p ps=1.34u w=0.15u l=0.13u
X738 6to4_0.buff_PI_d32_2.inv_PI_d32_0.VIN.t23 6to4_0.buff_PI_d32_2.inv_PI_d16$1_0.VIN.t55 VDD.t991 VDD.t198 sg13_lv_pmos ad=55.5f pd=0.74u as=0.1005p ps=1.34u w=0.15u l=0.13u
X739 VDD.t817 6to4_0.buff_PI_d32_2.buff_PI_d16$1_0.inv_PI_d8$1_0.VOUT.t37 6to4_0.buff_PI_d32_2.inv_PI_d16$1_0.VIN.t36 VDD.t126 sg13_lv_pmos ad=0.1005p pd=1.34u as=55.5f ps=0.74u w=0.15u l=0.13u
X740 VDD.t942 6to4_0.buff_PI_d32_0.inv_PI_d16$1_0.VIN.t55 6to4_0.buff_PI_d32_0.inv_PI_d32_0.VIN VDD.t5 sg13_lv_pmos ad=55.5f pd=0.74u as=55.5f ps=0.74u w=0.15u l=0.13u
X741 VSS.t1955 6ph_rosc_0.psdiff_1.VOUTDN 6ph_rosc_0.buff_d8$1_2.inv_d2$1_0.VIN VSS.t1954 sg13_lv_nmos ad=0.1005p pd=1.34u as=0.1005p ps=1.34u w=0.15u l=0.13u
X742 CTRL 6ph_rosc_0.PH1.t10 CTRL VDD.t80 sg13_lv_pmos ad=0.19p pd=1.38u as=0 ps=0 w=1u l=0.13u
X743 VDD.t706 6to4_0.buff_PI_d32_3.inv_PI_d32_0.VIN PH180.t89 VDD.t679 sg13_lv_pmos ad=55.5f pd=0.74u as=0.1005p ps=1.34u w=0.15u l=0.13u
X744 VSS.t1538 6to4_0.buff_PI_d32_2.buff_PI_d16$1_0.inv_PI_d4$1_0.VOUT.t13 6to4_0.buff_PI_d32_2.buff_PI_d16$1_0.inv_PI_d8$1_0.VOUT.t7 VSS.t1537 sg13_lv_nmos ad=0.1005p pd=1.34u as=55.5f ps=0.74u w=0.15u l=0.13u
X745 PH0.t78 6to4_0.buff_PI_d32_1.inv_PI_d32_0.VIN VDD.t568 VDD.t173 sg13_lv_pmos ad=55.5f pd=0.74u as=55.5f ps=0.74u w=0.15u l=0.13u
X746 6to4_0.buff_PI_d32_3.inv_PI_d32_0.VIN 6to4_0.buff_PI_d32_3.inv_PI_d16$1_0.VIN.t60 VDD.t899 VDD.t99 sg13_lv_pmos ad=55.5f pd=0.74u as=55.5f ps=0.74u w=0.15u l=0.13u
X747 VSS.t1690 6ph_rosc_0.psdiff_2.CLKP.t8 6ph_rosc_0.psdiff_2.buff_d8$1_1.VIN.t2 VSS.t1696 sg13_lv_nmos ad=55.5f pd=0.74u as=55.5f ps=0.74u w=0.15u l=0.13u
X748 VDD.t285 6to4_0.buff_PI_d32_2.inv_PI_d32_0.VIN.t76 PH270.t83 VDD.t126 sg13_lv_pmos ad=55.5f pd=0.74u as=0.1005p ps=1.34u w=0.15u l=0.13u
X749 CTRL 6ph_rosc_0.PH0.t10 CTRL VDD.t51 sg13_lv_pmos ad=0.19p pd=1.38u as=0 ps=0 w=1u l=0.13u
X750 VDD.t885 6to4_0.buff_PI_d32_3.inv_PI_d16$1_0.VIN.t55 6to4_0.buff_PI_d32_3.inv_PI_d32_0.VIN VDD.t99 sg13_lv_pmos ad=55.5f pd=0.74u as=55.5f ps=0.74u w=0.15u l=0.13u
X751 6to4_0.buff_PI_d32_3.buff_PI_d16$1_0.inv_PI_d8$1_0.VOUT.t3 6to4_0.buff_PI_d32_3.buff_PI_d16$1_0.inv_PI_d4$1_0.VOUT.t15 VSS.t1532 VSS.t1531 sg13_lv_nmos ad=55.5f pd=0.74u as=0.1005p ps=1.34u w=0.15u l=0.13u
X752 6to4_0.buff_PI_d32_3.buff_PI_d16$1_0.inv_PI_d8$1_0.VOUT.t14 6to4_0.buff_PI_d32_3.buff_PI_d16$1_0.inv_PI_d4$1_0.VOUT.t17 VDD.t1020 VDD.t679 sg13_lv_pmos ad=55.5f pd=0.74u as=55.5f ps=0.74u w=0.15u l=0.13u
X753 VSS.t1260 6to4_0.buff_PI_d32_0.buff_PI_d16$1_0.inv_PI_d4$1_0.VOUT.t13 6to4_0.buff_PI_d32_0.buff_PI_d16$1_0.inv_PI_d8$1_0.VOUT.t3 VSS.t1259 sg13_lv_nmos ad=0.1005p pd=1.34u as=55.5f ps=0.74u w=0.15u l=0.13u
X754 6to4_0.buff_PI_d32_2.VIN 6to4_0.PI_clk_1.inv_PI_d2$1_0.VOUT VDD.t96 VDD.t92 sg13_lv_pmos ad=55.5f pd=0.74u as=0.1005p ps=1.34u w=0.15u l=0.13u
X755 VDD.t978 6to4_0.buff_PI_d32_2.inv_PI_d16$1_0.VIN.t51 6to4_0.buff_PI_d32_2.inv_PI_d32_0.VIN.t11 VDD.t198 sg13_lv_pmos ad=0.1005p pd=1.34u as=55.5f ps=0.74u w=0.15u l=0.13u
X756 PH180.t31 6to4_0.buff_PI_d32_3.inv_PI_d32_0.VIN VSS.t1097 VSS.t1096 sg13_lv_nmos ad=55.5f pd=0.74u as=0.1005p ps=1.34u w=0.15u l=0.13u
X757 VSS.t1504 6to4_0.buff_PI_d32_3.buff_PI_d16$1_0.inv_PI_d4$1_0.VOUT.t16 6to4_0.buff_PI_d32_3.buff_PI_d16$1_0.inv_PI_d8$1_0.VOUT.t1 VSS.t1503 sg13_lv_nmos ad=0.1005p pd=1.34u as=55.5f ps=0.74u w=0.15u l=0.13u
X758 6to4_0.buff_PI_d32_2.VIN 6to4_0.PI_clk_1.inv_PI_d2$1_0.VOUT VSS.t135 VSS.t134 sg13_lv_nmos ad=55.5f pd=0.74u as=0.1005p ps=1.34u w=0.15u l=0.13u
X759 VDD.t161 6ph_rosc_0.psdiff_1.buff_d8$1_1.inv_d8$1_0.VIN 6ph_rosc_0.psdiff_1.VOUTDN VDD.t0 sg13_lv_pmos ad=0.1005p pd=1.34u as=55.5f ps=0.74u w=0.15u l=0.13u
X760 6ph_rosc_0.PH4.t0 6ph_rosc_0.PH1.t14 VSS.t1372 VSS.t1371 sg13_lv_nmos ad=55.5f pd=0.74u as=0.1005p ps=1.34u w=0.15u l=0.13u
X761 VSS.t1694 6ph_rosc_0.psdiff_2.CLKP.t8 6ph_rosc_0.psdiff_2.buff_d8$1_1.VIN.t9 VSS.t1691 sg13_lv_nmos ad=55.5f pd=0.74u as=55.5f ps=0.74u w=0.15u l=0.13u
X762 CTRL 6ph_rosc_0.PH2.t10 CTRL VDD.t440 sg13_lv_pmos ad=0.19p pd=1.38u as=0 ps=0 w=1u l=0.13u
X763 VDD.t1145 6ph_rosc_0.PH2.t13 6ph_rosc_0.PH5.t9 VDD.t1135 sg13_lv_pmos ad=0.1005p pd=1.34u as=55.5f ps=0.74u w=0.15u l=0.13u
X764 VSS.t1907 6to4_0.buff_PI_d32_1.inv_PI_d16$1_0.VIN 6to4_0.buff_PI_d32_1.inv_PI_d32_0.VIN VSS.t1906 sg13_lv_nmos ad=0.1005p pd=1.34u as=55.5f ps=0.74u w=0.15u l=0.13u
X765 VSS.t1590 6ph_rosc_0.psdiff_0.buff_d8$1_0.inv_d8$1_0.VIN 6ph_rosc_0.psdiff_2.CLKN VSS.t1589 sg13_lv_nmos ad=0.1005p pd=1.34u as=55.5f ps=0.74u w=0.15u l=0.13u
X766 6to4_0.buff_PI_d32_1.inv_PI_d32_0.VIN 6to4_0.buff_PI_d32_1.inv_PI_d16$1_0.VIN VDD.t1264 VDD.t17 sg13_lv_pmos ad=0.1005p pd=1.34u as=55.5f ps=0.74u w=0.15u l=0.13u
X767 PH270.t26 6to4_0.buff_PI_d32_2.inv_PI_d32_0.VIN.t63 VSS.t394 VSS.t393 sg13_lv_nmos ad=55.5f pd=0.74u as=0.1005p ps=1.34u w=0.15u l=0.13u
X768 VDD.t1213 6to4_0.buff_PI_d32_3.buff_PI_d16$1_0.inv_PI_d8$1_0.VOUT.t29 6to4_0.buff_PI_d32_3.inv_PI_d16$1_0.VIN.t17 VDD.t679 sg13_lv_pmos ad=55.5f pd=0.74u as=55.5f ps=0.74u w=0.15u l=0.13u
X769 PH90.t54 6to4_0.buff_PI_d32_0.inv_PI_d32_0.VIN VDD.t412 VDD.t341 sg13_lv_pmos ad=55.5f pd=0.74u as=0.1005p ps=1.34u w=0.15u l=0.13u
X770 CTRL 6ph_rosc_0.PH0.t10 CTRL VDD.t51 sg13_lv_pmos ad=0.19p pd=1.38u as=0 ps=0 w=1u l=0.13u
X771 6ph_rosc_0.PH0.t6 6ph_rosc_0.buff_d8$1_5.inv_d8$1_0.VIN VDD.t55 VDD.t51 sg13_lv_pmos ad=55.5f pd=0.74u as=0.1005p ps=1.34u w=0.15u l=0.13u
X772 PH180.t16 6to4_0.buff_PI_d32_3.inv_PI_d32_0.VIN VSS.t1095 VSS.t1094 sg13_lv_nmos ad=55.5f pd=0.74u as=0.1005p ps=1.34u w=0.15u l=0.13u
X773 6to4_0.buff_PI_d32_1.inv_PI_d32_0.VIN 6to4_0.buff_PI_d32_1.inv_PI_d16$1_0.VIN VSS.t1905 VSS.t1904 sg13_lv_nmos ad=55.5f pd=0.74u as=0.1005p ps=1.34u w=0.15u l=0.13u
X774 CTRL 6ph_rosc_0.PH2.t10 CTRL VDD.t440 sg13_lv_pmos ad=0.19p pd=1.38u as=0 ps=0 w=1u l=0.13u
X775 PH180.t61 6to4_0.buff_PI_d32_3.inv_PI_d32_0.VIN VDD.t746 VDD.t679 sg13_lv_pmos ad=55.5f pd=0.74u as=0.1005p ps=1.34u w=0.15u l=0.13u
X776 VDD.t1107 6to4_0.buff_PI_d32_0.buff_PI_d16$1_0.inv_PI_d8$1_0.VOUT.t33 6to4_0.buff_PI_d32_0.inv_PI_d16$1_0.VIN.t29 VDD.t5 sg13_lv_pmos ad=55.5f pd=0.74u as=0.1005p ps=1.34u w=0.15u l=0.13u
X777 VDD.t172 6ph_rosc_0.psdiff_2.buff_d8$1_0.VIN.t32 6ph_rosc_0.psdiff_2.buff_d8$1_0.inv_d2$1_0.VIN VDD.t34 sg13_lv_pmos ad=0.1005p pd=1.34u as=0.1005p ps=1.34u w=0.15u l=0.13u
X778 6to4_0.buff_PI_d32_2.inv_PI_d16$1_0.VIN.t43 6to4_0.buff_PI_d32_2.buff_PI_d16$1_0.inv_PI_d8$1_0.VOUT.t28 VDD.t789 VDD.t126 sg13_lv_pmos ad=0.1005p pd=1.34u as=55.5f ps=0.74u w=0.15u l=0.13u
X779 6to4_0.buff_PI_d32_1.buff_PI_d16$1_0.inv_PI_d8$1_0.VOUT.t23 6to4_0.buff_PI_d32_1.buff_PI_d16$1_0.inv_PI_d4$1_0.VOUT.t19 VSS.t330 VSS.t329 sg13_lv_nmos ad=55.5f pd=0.74u as=0.1005p ps=1.34u w=0.15u l=0.13u
X780 6ph_rosc_0.buff_d8$1_3.inv_d8$1_0.VIN 6ph_rosc_0.buff_d8$1_3.inv_d4$1_0.VIN VSS.t292 VSS.t291 sg13_lv_nmos ad=55.5f pd=0.74u as=0.1005p ps=1.34u w=0.15u l=0.13u
X781 VDD.t167 6ph_rosc_0.buff_d8$1_3.inv_d4$1_0.VIN 6ph_rosc_0.buff_d8$1_3.inv_d8$1_0.VIN VDD.t75 sg13_lv_pmos ad=0.1005p pd=1.34u as=55.5f ps=0.74u w=0.15u l=0.13u
X782 6ph_rosc_0.psdiff_1.VOUTDN 6ph_rosc_0.psdiff_1.buff_d8$1_1.inv_d8$1_0.VIN VSS.t274 VSS.t273 sg13_lv_nmos ad=55.5f pd=0.74u as=0.1005p ps=1.34u w=0.15u l=0.13u
X783 6ph_rosc_0.psdiff_1.buff_d8$1_0.VIN.t15 VSS.t1967 VDD.t1388 VDD.t301 sg13_lv_pmos ad=55.5f pd=0.74u as=55.5f ps=0.74u w=0.15u l=0.13u
X784 6ph_rosc_0.psdiff_2.buff_d8$1_0.inv_d8$1_0.VIN 6ph_rosc_0.psdiff_2.buff_d8$1_0.inv_d4$1_0.VIN VDD.t115 VDD.t34 sg13_lv_pmos ad=55.5f pd=0.74u as=0.1005p ps=1.34u w=0.15u l=0.13u
X785 6ph_rosc_0.psdiff_0.buff_d8$1_1.inv_d2$1_0.VIN 6ph_rosc_0.psdiff_0.buff_d8$1_1.VIN.t32 VDD.t775 VDD.t0 sg13_lv_pmos ad=0.1005p pd=1.34u as=0.1005p ps=1.34u w=0.15u l=0.13u
X786 VDD.t963 6to4_0.buff_PI_d32_0.inv_PI_d16$1_0.VIN.t62 6to4_0.buff_PI_d32_0.inv_PI_d32_0.VIN VDD.t5 sg13_lv_pmos ad=55.5f pd=0.74u as=0.1005p ps=1.34u w=0.15u l=0.13u
X787 VDD.t411 6to4_0.buff_PI_d32_0.inv_PI_d32_0.VIN PH90.t86 VDD.t341 sg13_lv_pmos ad=0.1005p pd=1.34u as=55.5f ps=0.74u w=0.15u l=0.13u
X788 VDD.t575 6to4_0.buff_PI_d32_1.inv_PI_d32_0.VIN PH0.t85 VDD.t173 sg13_lv_pmos ad=55.5f pd=0.74u as=55.5f ps=0.74u w=0.15u l=0.13u
X789 6ph_rosc_0.buff_d8$1_5.inv_d8$1_0.VIN 6ph_rosc_0.buff_d8$1_5.inv_d4$1_0.VIN VDD.t466 VDD.t464 sg13_lv_pmos ad=55.5f pd=0.74u as=0.1005p ps=1.34u w=0.15u l=0.13u
X790 6ph_rosc_0.PH1.t6 6ph_rosc_0.buff_d8$1_3.inv_d8$1_0.VIN VDD.t153 VDD.t75 sg13_lv_pmos ad=55.5f pd=0.74u as=0.1005p ps=1.34u w=0.15u l=0.13u
X791 VDD.t745 6to4_0.buff_PI_d32_3.inv_PI_d32_0.VIN PH180.t45 VDD.t99 sg13_lv_pmos ad=55.5f pd=0.74u as=55.5f ps=0.74u w=0.15u l=0.13u
X792 VDD.t368 6to4_0.buff_PI_d32_0.inv_PI_d32_0.VIN PH90.t48 VDD.t343 sg13_lv_pmos ad=55.5f pd=0.74u as=55.5f ps=0.74u w=0.15u l=0.13u
X793 CTRL 6ph_rosc_0.PH2.t10 CTRL VDD.t89 sg13_lv_pmos ad=0.19p pd=1.38u as=0 ps=0 w=1u l=0.13u
X794 6to4_0.buff_PI_d32_0.buff_PI_d16$1_0.inv_PI_d4$1_0.VOUT.t10 6to4_0.buff_PI_d32_0.buff_PI_d16$1_0.inv_PI_d4$1_0.VIN VDD.t60 VDD.t5 sg13_lv_pmos ad=0.1005p pd=1.34u as=55.5f ps=0.74u w=0.15u l=0.13u
X795 6to4_0.buff_PI_d32_1.inv_PI_d16$1_0.VIN 6to4_0.buff_PI_d32_1.buff_PI_d16$1_0.inv_PI_d8$1_0.VOUT.t37 VDD.t1184 VDD.t173 sg13_lv_pmos ad=55.5f pd=0.74u as=0.1005p ps=1.34u w=0.15u l=0.13u
X796 6to4_0.buff_PI_d32_1.buff_PI_d16$1_0.inv_PI_d4$1_0.VOUT.t7 6to4_0.buff_PI_d32_1.buff_PI_d16$1_0.inv_PI_d4$1_0.VIN VDD.t19 VDD.t17 sg13_lv_pmos ad=55.5f pd=0.74u as=55.5f ps=0.74u w=0.15u l=0.13u
X797 PH0.t15 6to4_0.buff_PI_d32_1.inv_PI_d32_0.VIN VSS.t941 VSS.t940 sg13_lv_nmos ad=55.5f pd=0.74u as=0.1005p ps=1.34u w=0.15u l=0.13u
X798 VSS.t1390 6to4_0.buff_PI_d32_0.inv_PI_d16$1_0.VIN.t52 6to4_0.buff_PI_d32_0.inv_PI_d32_0.VIN VSS.t1389 sg13_lv_nmos ad=0.1005p pd=1.34u as=55.5f ps=0.74u w=0.15u l=0.13u
X799 VSS.t312 6to4_0.buff_PI_d32_1.buff_PI_d16$1_0.inv_PI_d4$1_0.VOUT.t15 6to4_0.buff_PI_d32_1.buff_PI_d16$1_0.inv_PI_d8$1_0.VOUT.t11 VSS.t311 sg13_lv_nmos ad=0.1005p pd=1.34u as=55.5f ps=0.74u w=0.15u l=0.13u
X800 CTRL 6ph_rosc_0.PH1.t10 CTRL VDD.t82 sg13_lv_pmos ad=0.19p pd=1.38u as=0 ps=0 w=1u l=0.13u
X801 6to4_0.buff_PI_d32_2.buff_PI_d16$1_0.inv_PI_d4$1_0.VOUT.t1 6to4_0.buff_PI_d32_2.buff_PI_d16$1_0.inv_PI_d4$1_0.VIN VSS.t187 VSS.t186 sg13_lv_nmos ad=55.5f pd=0.74u as=0.1005p ps=1.34u w=0.15u l=0.13u
X802 VDD.t703 6to4_0.buff_PI_d32_3.inv_PI_d32_0.VIN PH180.t88 VDD.t99 sg13_lv_pmos ad=55.5f pd=0.74u as=0.1005p ps=1.34u w=0.15u l=0.13u
X803 6to4_0.buff_PI_d32_1.inv_PI_d16$1_0.VIN 6to4_0.buff_PI_d32_1.buff_PI_d16$1_0.inv_PI_d8$1_0.VOUT.t35 VDD.t1160 VDD.t17 sg13_lv_pmos ad=55.5f pd=0.74u as=55.5f ps=0.74u w=0.15u l=0.13u
X804 6ph_rosc_0.psdiff_2.CLKN 6ph_rosc_0.psdiff_0.buff_d8$1_0.inv_d8$1_0.VIN VDD.t1076 VDD.t34 sg13_lv_pmos ad=55.5f pd=0.74u as=0.1005p ps=1.34u w=0.15u l=0.13u
X805 6to4_0.buff_PI_d32_3.inv_PI_d16$1_0.VIN.t31 6to4_0.buff_PI_d32_3.buff_PI_d16$1_0.inv_PI_d8$1_0.VOUT.t34 VDD.t1229 VDD.t679 sg13_lv_pmos ad=55.5f pd=0.74u as=0.1005p ps=1.34u w=0.15u l=0.13u
X806 VDD.t1022 6to4_0.buff_PI_d32_3.buff_PI_d16$1_0.inv_PI_d4$1_0.VOUT.t18 6to4_0.buff_PI_d32_3.buff_PI_d16$1_0.inv_PI_d8$1_0.VOUT.t22 VDD.t679 sg13_lv_pmos ad=55.5f pd=0.74u as=0.1005p ps=1.34u w=0.15u l=0.13u
X807 6to4_0.buff_PI_d32_0.buff_PI_d16$1_0.inv_PI_d4$1_0.VOUT.t1 6to4_0.buff_PI_d32_0.buff_PI_d16$1_0.inv_PI_d4$1_0.VIN VSS.t95 VSS.t94 sg13_lv_nmos ad=55.5f pd=0.74u as=0.1005p ps=1.34u w=0.15u l=0.13u
X808 VDD.t819 6to4_0.buff_PI_d32_2.buff_PI_d16$1_0.inv_PI_d8$1_0.VOUT.t38 6to4_0.buff_PI_d32_2.inv_PI_d16$1_0.VIN.t24 VDD.t198 sg13_lv_pmos ad=55.5f pd=0.74u as=55.5f ps=0.74u w=0.15u l=0.13u
X809 PH0.t60 6to4_0.buff_PI_d32_1.inv_PI_d32_0.VIN VDD.t590 VDD.t552 sg13_lv_pmos ad=55.5f pd=0.74u as=55.5f ps=0.74u w=0.15u l=0.13u
X810 6to4_0.buff_PI_d32_2.VIN 6to4_0.flywheel_clk_0.PH0 VSS.t17 VSS.t16 sg13_lv_nmos ad=55.5f pd=0.74u as=0.1005p ps=1.34u w=0.15u l=0.13u
X811 VSS.t739 6ph_rosc_0.buff_d8$1_5.inv_d4$1_0.VIN 6ph_rosc_0.buff_d8$1_5.inv_d8$1_0.VIN VSS.t738 sg13_lv_nmos ad=0.1005p pd=1.34u as=55.5f ps=0.74u w=0.15u l=0.13u
X812 CTRL 6ph_rosc_0.PH1.t10 CTRL VDD.t78 sg13_lv_pmos ad=0.19p pd=1.38u as=0 ps=0 w=1u l=0.13u
X813 6ph_rosc_0.psdiff_0.buff_d8$1_1.VIN.t6 VSS.t1965 VDD.t1312 VDD.t503 sg13_lv_pmos ad=55.5f pd=0.74u as=55.5f ps=0.74u w=0.15u l=0.13u
X814 PH270.t72 6to4_0.buff_PI_d32_2.inv_PI_d32_0.VIN.t77 VDD.t290 VDD.t215 sg13_lv_pmos ad=55.5f pd=0.74u as=0.1005p ps=1.34u w=0.15u l=0.13u
X815 6to4_0.buff_PI_d32_0.inv_PI_d32_0.VIN 6to4_0.buff_PI_d32_0.inv_PI_d16$1_0.VIN.t61 VDD.t960 VDD.t5 sg13_lv_pmos ad=55.5f pd=0.74u as=0.1005p ps=1.34u w=0.15u l=0.13u
X816 VSS.t1149 6ph_rosc_0.psdiff_2.VOUTDN 6ph_rosc_0.psdiff_1.buff_d8$1_1.VIN.t23 VSS.t1137 sg13_lv_nmos ad=55.5f pd=0.74u as=55.5f ps=0.74u w=0.15u l=0.13u
X817 6to4_0.buff_PI_d32_3.buff_PI_d16$1_0.inv_PI_d4$1_0.VOUT.t10 6to4_0.buff_PI_d32_3.buff_PI_d16$1_0.inv_PI_d4$1_0.VIN VDD.t102 VDD.t99 sg13_lv_pmos ad=55.5f pd=0.74u as=55.5f ps=0.74u w=0.15u l=0.13u
X818 6ph_rosc_0.psdiff_2.buff_d8$1_1.VIN.t26 CTRL a_4999_2194# VSS.t498 sg13_lv_nmos ad=0.1005p pd=1.34u as=55.5f ps=0.74u w=0.15u l=0.13u
X819 VDD.t1287 6to4_0.buff_PI_d32_1.inv_PI_d16$1_0.VIN 6to4_0.buff_PI_d32_1.inv_PI_d32_0.VIN VDD.t173 sg13_lv_pmos ad=55.5f pd=0.74u as=0.1005p ps=1.34u w=0.15u l=0.13u
X820 CTRL 6ph_rosc_0.PH1.t10 CTRL VDD.t80 sg13_lv_pmos ad=0.19p pd=1.38u as=0 ps=0 w=1u l=0.13u
X821 VDD.t286 6to4_0.buff_PI_d32_2.inv_PI_d32_0.VIN.t76 PH270.t46 VDD.t126 sg13_lv_pmos ad=0.1005p pd=1.34u as=55.5f ps=0.74u w=0.15u l=0.13u
X822 6ph_rosc_0.psdiff_0.buff_d8$1_1.VIN.t16 a_12104_2338# VDD.t506 VDD.t503 sg13_lv_pmos ad=55.5f pd=0.74u as=55.5f ps=0.74u w=0.15u l=0.13u
X823 6to4_0.buff_PI_d32_0.inv_PI_d32_0.VIN 6to4_0.buff_PI_d32_0.inv_PI_d16$1_0.VIN.t63 VDD.t965 VDD.t341 sg13_lv_pmos ad=0.1005p pd=1.34u as=55.5f ps=0.74u w=0.15u l=0.13u
X824 6to4_0.buff_PI_d32_2.VIN 6to4_0.PI_clk_1.inv_PI_d2$1_0.VOUT VDD.t95 VDD.t92 sg13_lv_pmos ad=0.1005p pd=1.34u as=55.5f ps=0.74u w=0.15u l=0.13u
X825 VDD.t409 6to4_0.buff_PI_d32_0.inv_PI_d32_0.VIN PH90.t85 VDD.t343 sg13_lv_pmos ad=55.5f pd=0.74u as=0.1005p ps=1.34u w=0.15u l=0.13u
X826 6to4_0.buff_PI_d32_3.buff_PI_d16$1_0.inv_PI_d4$1_0.VIN 6to4_0.inv_PI_d2$1_2.VOUT VDD.t338 VDD.t99 sg13_lv_pmos ad=55.5f pd=0.74u as=0.1005p ps=1.34u w=0.15u l=0.13u
X827 VSS.t1466 6to4_0.buff_PI_d32_2.inv_PI_d16$1_0.VIN.t55 6to4_0.buff_PI_d32_2.inv_PI_d32_0.VIN.t21 VSS.t1465 sg13_lv_nmos ad=0.1005p pd=1.34u as=55.5f ps=0.74u w=0.15u l=0.13u
X828 6to4_0.buff_PI_d32_1.buff_PI_d16$1_0.inv_PI_d4$1_0.VOUT.t4 6to4_0.buff_PI_d32_1.buff_PI_d16$1_0.inv_PI_d4$1_0.VIN VDD.t26 VDD.t17 sg13_lv_pmos ad=55.5f pd=0.74u as=0.1005p ps=1.34u w=0.15u l=0.13u
X829 VSS.t664 6ph_rosc_0.buff_d8$1_0.inv_d8$1_0.VIN 6ph_rosc_0.PH2.t0 VSS.t663 sg13_lv_nmos ad=0.1005p pd=1.34u as=55.5f ps=0.74u w=0.15u l=0.13u
X830 VSS.t939 6to4_0.buff_PI_d32_1.inv_PI_d32_0.VIN PH0.t26 VSS.t938 sg13_lv_nmos ad=0.1005p pd=1.34u as=55.5f ps=0.74u w=0.15u l=0.13u
X831 6to4_0.buff_PI_d32_0.inv_PI_d16$1_0.VIN.t36 6to4_0.buff_PI_d32_0.buff_PI_d16$1_0.inv_PI_d8$1_0.VOUT.t36 VSS.t1644 VSS.t1643 sg13_lv_nmos ad=55.5f pd=0.74u as=0.1005p ps=1.34u w=0.15u l=0.13u
X832 VDD.t1156 6to4_0.buff_PI_d32_1.buff_PI_d16$1_0.inv_PI_d8$1_0.VOUT.t30 6to4_0.buff_PI_d32_1.inv_PI_d16$1_0.VIN VDD.t17 sg13_lv_pmos ad=55.5f pd=0.74u as=55.5f ps=0.74u w=0.15u l=0.13u
X833 VSS.t1382 6to4_0.buff_PI_d32_0.inv_PI_d16$1_0.VIN.t50 6to4_0.buff_PI_d32_0.inv_PI_d32_0.VIN VSS.t1381 sg13_lv_nmos ad=0.1005p pd=1.34u as=55.5f ps=0.74u w=0.15u l=0.13u
X834 6to4_0.buff_PI_d32_2.buff_PI_d16$1_0.inv_PI_d8$1_0.VOUT.t3 6to4_0.buff_PI_d32_2.buff_PI_d16$1_0.inv_PI_d4$1_0.VOUT.t19 VSS.t1564 VSS.t1563 sg13_lv_nmos ad=55.5f pd=0.74u as=0.1005p ps=1.34u w=0.15u l=0.13u
X835 VSS.t1769 6to4_0.buff_PI_d32_1.buff_PI_d16$1_0.inv_PI_d8$1_0.VOUT.t31 6to4_0.buff_PI_d32_1.inv_PI_d16$1_0.VIN VSS.t1768 sg13_lv_nmos ad=0.1005p pd=1.34u as=55.5f ps=0.74u w=0.15u l=0.13u
X836 VSS.t837 6ph_rosc_0.psdiff_1.VOUTDP 6ph_rosc_0.psdiff_0.buff_d8$1_0.VIN.t20 VSS.t812 sg13_lv_nmos ad=55.5f pd=0.74u as=55.5f ps=0.74u w=0.15u l=0.13u
X837 CTRL 6ph_rosc_0.PH3.t11 CTRL VDD.t330 sg13_lv_pmos ad=0.19p pd=1.38u as=0 ps=0 w=1u l=0.13u
X838 VSS.t402 6to4_0.buff_PI_d32_2.inv_PI_d32_0.VIN.t65 PH270.t9 VSS.t401 sg13_lv_nmos ad=0.1005p pd=1.34u as=55.5f ps=0.74u w=0.15u l=0.13u
X839 VDD.t518 a_10947_2194# 6ph_rosc_0.psdiff_0.buff_d8$1_0.VIN.t15 VDD.t503 sg13_lv_pmos ad=55.5f pd=0.74u as=55.5f ps=0.74u w=0.15u l=0.13u
X840 VSS.t157 6ph_rosc_0.psdiff_2.buff_d8$1_0.inv_d4$1_0.VIN 6ph_rosc_0.psdiff_2.buff_d8$1_0.inv_d8$1_0.VIN VSS.t156 sg13_lv_nmos ad=0.1005p pd=1.34u as=55.5f ps=0.74u w=0.15u l=0.13u
X841 6to4_0.buff_PI_d32_2.inv_PI_d32_0.VIN.t25 6to4_0.buff_PI_d32_2.inv_PI_d16$1_0.VIN.t56 VDD.t993 VDD.t198 sg13_lv_pmos ad=55.5f pd=0.74u as=55.5f ps=0.74u w=0.15u l=0.13u
X842 6to4_0.buff_PI_d32_2.inv_PI_d32_0.VIN.t38 6to4_0.buff_PI_d32_2.inv_PI_d16$1_0.VIN.t60 VDD.t1004 VDD.t126 sg13_lv_pmos ad=0.1005p pd=1.34u as=55.5f ps=0.74u w=0.15u l=0.13u
X843 PH90.t7 6to4_0.buff_PI_d32_0.inv_PI_d32_0.VIN VSS.t614 VSS.t613 sg13_lv_nmos ad=55.5f pd=0.74u as=0.1005p ps=1.34u w=0.15u l=0.13u
X844 VSS.t1408 6to4_0.buff_PI_d32_0.inv_PI_d16$1_0.VIN.t56 6to4_0.buff_PI_d32_0.inv_PI_d32_0.VIN VSS.t1407 sg13_lv_nmos ad=0.1005p pd=1.34u as=55.5f ps=0.74u w=0.15u l=0.13u
X845 CTRL 6ph_rosc_0.PH2.t10 CTRL VDD.t80 sg13_lv_pmos ad=0.34p pd=2.68u as=0 ps=0 w=1u l=0.13u
X846 6to4_0.buff_PI_d32_2.VIN 6to4_0.flywheel_clk_0.PH0 VDD.t15 VDD.t9 sg13_lv_pmos ad=55.5f pd=0.74u as=0.1005p ps=1.34u w=0.15u l=0.13u
X847 PH270.t70 6to4_0.buff_PI_d32_2.inv_PI_d32_0.VIN.t50 VDD.t207 VDD.t202 sg13_lv_pmos ad=55.5f pd=0.74u as=0.1005p ps=1.34u w=0.15u l=0.13u
X848 6ph_rosc_0.psdiff_1.buff_d8$1_1.VIN.t31 6ph_rosc_0.psdiff_2.VOUTDN VSS.t1138 VSS.t1148 sg13_lv_nmos ad=55.5f pd=0.74u as=55.5f ps=0.74u w=0.15u l=0.13u
X849 6ph_rosc_0.psdiff_0.buff_d8$1_1.VIN.t31 6ph_rosc_0.psdiff_1.VOUTDN VSS.t1934 VSS.t1928 sg13_lv_nmos ad=55.5f pd=0.74u as=55.5f ps=0.74u w=0.15u l=0.13u
X850 PH0.t84 6to4_0.buff_PI_d32_1.inv_PI_d32_0.VIN VDD.t615 VDD.t547 sg13_lv_pmos ad=55.5f pd=0.74u as=55.5f ps=0.74u w=0.15u l=0.13u
X851 6to4_0.buff_PI_d32_0.buff_PI_d16$1_0.inv_PI_d8$1_0.VOUT.t20 6to4_0.buff_PI_d32_0.buff_PI_d16$1_0.inv_PI_d4$1_0.VOUT.t18 VDD.t852 VDD.t341 sg13_lv_pmos ad=55.5f pd=0.74u as=55.5f ps=0.74u w=0.15u l=0.13u
X852 VDD.t1069 6ph_rosc_0.PH4.t14 6to4_0.PI_clk_1.inv_PI_d2$1_0.VOUT VDD.t126 sg13_lv_pmos ad=55.5f pd=0.74u as=55.5f ps=0.74u w=0.15u l=0.13u
X853 CTRL 6ph_rosc_0.PH3.t11 CTRL VDD.t464 sg13_lv_pmos ad=0.19p pd=1.38u as=0 ps=0 w=1u l=0.13u
X854 VSS.t937 6to4_0.buff_PI_d32_1.inv_PI_d32_0.VIN PH0.t3 VSS.t936 sg13_lv_nmos ad=0.1005p pd=1.34u as=55.5f ps=0.74u w=0.15u l=0.13u
X855 VSS.t836 6ph_rosc_0.psdiff_1.VOUTDP 6ph_rosc_0.psdiff_0.buff_d8$1_0.VIN.t21 VSS.t810 sg13_lv_nmos ad=55.5f pd=0.74u as=55.5f ps=0.74u w=0.15u l=0.13u
X856 VDD.t660 6ph_rosc_0.psdiff_1.buff_d8$1_0.inv_d8$1_0.VIN 6ph_rosc_0.psdiff_1.VOUTDP VDD.t34 sg13_lv_pmos ad=0.1005p pd=1.34u as=55.5f ps=0.74u w=0.15u l=0.13u
X857 6to4_0.buff_PI_d32_0.inv_PI_d16$1_0.VIN.t43 6to4_0.buff_PI_d32_0.buff_PI_d16$1_0.inv_PI_d8$1_0.VOUT.t38 VDD.t1123 VDD.t341 sg13_lv_pmos ad=55.5f pd=0.74u as=55.5f ps=0.74u w=0.15u l=0.13u
X858 6to4_0.buff_PI_d32_1.inv_PI_d16$1_0.VIN 6to4_0.buff_PI_d32_1.buff_PI_d16$1_0.inv_PI_d8$1_0.VOUT.t26 VDD.t1181 VDD.t173 sg13_lv_pmos ad=55.5f pd=0.74u as=0.1005p ps=1.34u w=0.15u l=0.13u
X859 6to4_0.buff_PI_d32_3.inv_PI_d16$1_0.VIN.t28 6to4_0.buff_PI_d32_3.buff_PI_d16$1_0.inv_PI_d8$1_0.VOUT.t33 VDD.t1227 VDD.t99 sg13_lv_pmos ad=55.5f pd=0.74u as=0.1005p ps=1.34u w=0.15u l=0.13u
X860 6ph_rosc_0.buff_d8$1_3.inv_d2$1_0.VIN 6ph_rosc_0.psdiff_1.VOUTDP VSS.t835 VSS.t834 sg13_lv_nmos ad=0.1005p pd=1.34u as=0.1005p ps=1.34u w=0.15u l=0.13u
X861 PH180.t87 6to4_0.buff_PI_d32_3.inv_PI_d32_0.VIN VDD.t685 VDD.t677 sg13_lv_pmos ad=55.5f pd=0.74u as=55.5f ps=0.74u w=0.15u l=0.13u
X862 VSS.t1614 6to4_0.buff_PI_d32_0.buff_PI_d16$1_0.inv_PI_d8$1_0.VOUT.t29 6to4_0.buff_PI_d32_0.inv_PI_d16$1_0.VIN.t15 VSS.t1613 sg13_lv_nmos ad=0.1005p pd=1.34u as=55.5f ps=0.74u w=0.15u l=0.13u
X863 VDD.t1199 6to4_0.buff_PI_d32_3.buff_PI_d16$1_0.inv_PI_d8$1_0.VOUT.t24 6to4_0.buff_PI_d32_3.inv_PI_d16$1_0.VIN.t2 VDD.t99 sg13_lv_pmos ad=55.5f pd=0.74u as=0.1005p ps=1.34u w=0.15u l=0.13u
X864 VDD.t1394 VSS.t1967 6ph_rosc_0.psdiff_1.buff_d8$1_1.VIN.t0 VDD.t301 sg13_lv_pmos ad=55.5f pd=0.74u as=55.5f ps=0.74u w=0.15u l=0.13u
X865 VDD.t772 6ph_rosc_0.psdiff_2.VOUTDN 6ph_rosc_0.buff_d8$1_5.inv_d2$1_0.VIN VDD.t330 sg13_lv_pmos ad=0.1005p pd=1.34u as=0.1005p ps=1.34u w=0.15u l=0.13u
X866 6ph_rosc_0.PH3.t1 6ph_rosc_0.PH0.t13 VDD.t829 VDD.t824 sg13_lv_pmos ad=55.5f pd=0.74u as=0.1005p ps=1.34u w=0.15u l=0.13u
X867 6ph_rosc_0.psdiff_2.CLKN 6ph_rosc_0.psdiff_0.buff_d8$1_0.inv_d8$1_0.VIN VSS.t1588 VSS.t1587 sg13_lv_nmos ad=55.5f pd=0.74u as=0.1005p ps=1.34u w=0.15u l=0.13u
X868 CTRL 6ph_rosc_0.PH1.t10 CTRL VDD.t82 sg13_lv_pmos ad=0.19p pd=1.38u as=0 ps=0 w=1u l=0.13u
X869 PH0.t54 6to4_0.buff_PI_d32_1.inv_PI_d32_0.VIN VDD.t614 VDD.t173 sg13_lv_pmos ad=55.5f pd=0.74u as=0.1005p ps=1.34u w=0.15u l=0.13u
X870 VDD.t74 6ph_rosc_0.psdiff_1.buff_d8$1_0.inv_d4$1_0.VIN 6ph_rosc_0.psdiff_1.buff_d8$1_0.inv_d8$1_0.VIN VDD.t34 sg13_lv_pmos ad=0.1005p pd=1.34u as=55.5f ps=0.74u w=0.15u l=0.13u
X871 PH90.t84 6to4_0.buff_PI_d32_0.inv_PI_d32_0.VIN VDD.t355 VDD.t5 sg13_lv_pmos ad=0.1005p pd=1.34u as=55.5f ps=0.74u w=0.15u l=0.13u
X872 6to4_0.buff_PI_d32_1.inv_PI_d16$1_0.VIN 6to4_0.buff_PI_d32_1.buff_PI_d16$1_0.inv_PI_d8$1_0.VOUT.t36 VSS.t1767 VSS.t1766 sg13_lv_nmos ad=55.5f pd=0.74u as=0.1005p ps=1.34u w=0.15u l=0.13u
X873 VDD.t194 6to4_0.buff_PI_d32_1.buff_PI_d16$1_0.inv_PI_d4$1_0.VOUT.t18 6to4_0.buff_PI_d32_1.buff_PI_d16$1_0.inv_PI_d8$1_0.VOUT.t18 VDD.t173 sg13_lv_pmos ad=0.1005p pd=1.34u as=55.5f ps=0.74u w=0.15u l=0.13u
X874 PH90.t69 6to4_0.buff_PI_d32_0.inv_PI_d32_0.VIN VDD.t354 VDD.t347 sg13_lv_pmos ad=55.5f pd=0.74u as=55.5f ps=0.74u w=0.15u l=0.13u
X875 VSS.t1903 6to4_0.buff_PI_d32_1.inv_PI_d16$1_0.VIN 6to4_0.buff_PI_d32_1.inv_PI_d32_0.VIN VSS.t1902 sg13_lv_nmos ad=0.1005p pd=1.34u as=55.5f ps=0.74u w=0.15u l=0.13u
X876 6to4_0.buff_PI_d32_2.inv_PI_d16$1_0.VIN.t26 6to4_0.buff_PI_d32_2.buff_PI_d16$1_0.inv_PI_d8$1_0.VOUT.t26 VDD.t783 VDD.t198 sg13_lv_pmos ad=55.5f pd=0.74u as=0.1005p ps=1.34u w=0.15u l=0.13u
X877 6to4_0.buff_PI_d32_3.inv_PI_d16$1_0.VIN.t35 6to4_0.buff_PI_d32_3.buff_PI_d16$1_0.inv_PI_d8$1_0.VOUT.t35 VDD.t1231 VDD.t679 sg13_lv_pmos ad=0.1005p pd=1.34u as=55.5f ps=0.74u w=0.15u l=0.13u
X878 6to4_0.buff_PI_d32_3.inv_PI_d32_0.VIN 6to4_0.buff_PI_d32_3.inv_PI_d16$1_0.VIN.t50 VSS.t1306 VSS.t1305 sg13_lv_nmos ad=55.5f pd=0.74u as=0.1005p ps=1.34u w=0.15u l=0.13u
X879 PH270.t13 6to4_0.buff_PI_d32_2.inv_PI_d32_0.VIN.t78 VSS.t454 VSS.t453 sg13_lv_nmos ad=55.5f pd=0.74u as=0.1005p ps=1.34u w=0.15u l=0.13u
X880 6ph_rosc_0.psdiff_0.buff_d8$1_0.VIN.t9 VSS.t1965 VDD.t1306 VDD.t503 sg13_lv_pmos ad=55.5f pd=0.74u as=55.5f ps=0.74u w=0.15u l=0.13u
X881 VDD.t1126 6to4_0.buff_PI_d32_0.buff_PI_d16$1_0.inv_PI_d8$1_0.VOUT.t39 6to4_0.buff_PI_d32_0.inv_PI_d16$1_0.VIN.t46 VDD.t5 sg13_lv_pmos ad=55.5f pd=0.74u as=55.5f ps=0.74u w=0.15u l=0.13u
X882 VDD.t1169 6to4_0.buff_PI_d32_1.buff_PI_d16$1_0.inv_PI_d8$1_0.VOUT.t39 6to4_0.buff_PI_d32_1.inv_PI_d16$1_0.VIN VDD.t17 sg13_lv_pmos ad=55.5f pd=0.74u as=0.1005p ps=1.34u w=0.15u l=0.13u
X883 VDD.t1393 VSS.t1967 6ph_rosc_0.psdiff_1.buff_d8$1_1.VIN.t1 VDD.t301 sg13_lv_pmos ad=55.5f pd=0.74u as=55.5f ps=0.74u w=0.15u l=0.13u
X884 CTRL 6ph_rosc_0.PH1.t10 CTRL VDD.t78 sg13_lv_pmos ad=0.19p pd=1.38u as=0 ps=0 w=1u l=0.13u
X885 PH90.t13 6to4_0.buff_PI_d32_0.inv_PI_d32_0.VIN VSS.t612 VSS.t611 sg13_lv_nmos ad=55.5f pd=0.74u as=0.1005p ps=1.34u w=0.15u l=0.13u
X886 6to4_0.buff_PI_d32_2.inv_PI_d16$1_0.VIN.t19 6to4_0.buff_PI_d32_2.buff_PI_d16$1_0.inv_PI_d8$1_0.VOUT.t39 VDD.t821 VDD.t126 sg13_lv_pmos ad=55.5f pd=0.74u as=55.5f ps=0.74u w=0.15u l=0.13u
X887 VSS.t935 6to4_0.buff_PI_d32_1.inv_PI_d32_0.VIN PH0.t7 VSS.t934 sg13_lv_nmos ad=0.1005p pd=1.34u as=55.5f ps=0.74u w=0.15u l=0.13u
X888 VSS.t1484 6to4_0.buff_PI_d32_2.inv_PI_d16$1_0.VIN.t59 6to4_0.buff_PI_d32_2.inv_PI_d32_0.VIN.t33 VSS.t1483 sg13_lv_nmos ad=0.1005p pd=1.34u as=55.5f ps=0.74u w=0.15u l=0.13u
X889 6ph_rosc_0.psdiff_1.buff_d8$1_1.inv_d4$1_0.VIN 6ph_rosc_0.psdiff_1.buff_d8$1_1.inv_d2$1_0.VIN VSS.t785 VSS.t784 sg13_lv_nmos ad=55.5f pd=0.74u as=0.1005p ps=1.34u w=0.15u l=0.13u
X890 6ph_rosc_0.psdiff_0.buff_d8$1_0.VIN.t25 6ph_rosc_0.psdiff_1.VOUTDP VSS.t833 VSS.t822 sg13_lv_nmos ad=55.5f pd=0.74u as=55.5f ps=0.74u w=0.15u l=0.13u
X891 6to4_0.PI_clk_1.inv_PI_d2$1_0.VOUT 6ph_rosc_0.PH4.t11 VDD.t1065 VDD.t126 sg13_lv_pmos ad=55.5f pd=0.74u as=55.5f ps=0.74u w=0.15u l=0.13u
X892 VDD.t699 6to4_0.buff_PI_d32_3.inv_PI_d32_0.VIN PH180.t68 VDD.t677 sg13_lv_pmos ad=55.5f pd=0.74u as=55.5f ps=0.74u w=0.15u l=0.13u
X893 6ph_rosc_0.psdiff_1.buff_d8$1_0.VIN.t18 VSS.t1967 VDD.t1410 VDD.t301 sg13_lv_pmos ad=55.5f pd=0.74u as=0.1005p ps=1.34u w=0.15u l=0.13u
X894 6to4_0.buff_PI_d32_3.inv_PI_d32_0.VIN 6to4_0.buff_PI_d32_3.inv_PI_d16$1_0.VIN.t54 VSS.t1324 VSS.t1323 sg13_lv_nmos ad=55.5f pd=0.74u as=0.1005p ps=1.34u w=0.15u l=0.13u
X895 6to4_0.buff_PI_d32_0.buff_PI_d16$1_0.inv_PI_d8$1_0.VOUT.t22 6to4_0.buff_PI_d32_0.buff_PI_d16$1_0.inv_PI_d4$1_0.VOUT.t19 VDD.t857 VDD.t341 sg13_lv_pmos ad=55.5f pd=0.74u as=0.1005p ps=1.34u w=0.15u l=0.13u
X896 PH270.t50 6to4_0.buff_PI_d32_2.inv_PI_d32_0.VIN.t64 VDD.t250 VDD.t126 sg13_lv_pmos ad=55.5f pd=0.74u as=55.5f ps=0.74u w=0.15u l=0.13u
X897 6ph_rosc_0.PH2.t6 6ph_rosc_0.buff_d8$1_0.inv_d8$1_0.VIN VDD.t446 VDD.t80 sg13_lv_pmos ad=55.5f pd=0.74u as=0.1005p ps=1.34u w=0.15u l=0.13u
X898 VDD.t1101 6to4_0.buff_PI_d32_0.buff_PI_d16$1_0.inv_PI_d8$1_0.VOUT.t31 6to4_0.buff_PI_d32_0.inv_PI_d16$1_0.VIN.t23 VDD.t341 sg13_lv_pmos ad=55.5f pd=0.74u as=55.5f ps=0.74u w=0.15u l=0.13u
X899 6ph_rosc_0.psdiff_1.VOUTDP 6ph_rosc_0.psdiff_1.buff_d8$1_0.inv_d8$1_0.VIN VDD.t659 VDD.t34 sg13_lv_pmos ad=55.5f pd=0.74u as=0.1005p ps=1.34u w=0.15u l=0.13u
X900 VDD.t406 6to4_0.buff_PI_d32_0.inv_PI_d32_0.VIN PH90.t83 VDD.t343 sg13_lv_pmos ad=0.1005p pd=1.34u as=55.5f ps=0.74u w=0.15u l=0.13u
X901 VDD.t1165 6to4_0.buff_PI_d32_1.buff_PI_d16$1_0.inv_PI_d8$1_0.VOUT.t29 6to4_0.buff_PI_d32_1.inv_PI_d16$1_0.VIN VDD.t173 sg13_lv_pmos ad=55.5f pd=0.74u as=0.1005p ps=1.34u w=0.15u l=0.13u
X902 VDD.t152 6ph_rosc_0.buff_d8$1_3.inv_d8$1_0.VIN 6ph_rosc_0.PH1.t7 VDD.t75 sg13_lv_pmos ad=0.1005p pd=1.34u as=55.5f ps=0.74u w=0.15u l=0.13u
X903 6to4_0.buff_PI_d32_1.buff_PI_d16$1_0.inv_PI_d4$1_0.VOUT.t11 6to4_0.buff_PI_d32_1.buff_PI_d16$1_0.inv_PI_d4$1_0.VIN VDD.t18 VDD.t17 sg13_lv_pmos ad=0.1005p pd=1.34u as=55.5f ps=0.74u w=0.15u l=0.13u
X904 6ph_rosc_0.psdiff_1.buff_d8$1_0.VIN.t8 6ph_rosc_0.psdiff_2.VOUTDP VSS.t215 VSS.t212 sg13_lv_nmos ad=55.5f pd=0.74u as=55.5f ps=0.74u w=0.15u l=0.13u
X905 VDD.t1330 VSS.t1965 6ph_rosc_0.psdiff_0.buff_d8$1_1.VIN.t9 VDD.t503 sg13_lv_pmos ad=0.1005p pd=1.34u as=55.5f ps=0.74u w=0.15u l=0.13u
X906 VSS.t450 6to4_0.buff_PI_d32_2.inv_PI_d32_0.VIN.t77 PH270.t6 VSS.t449 sg13_lv_nmos ad=0.1005p pd=1.34u as=55.5f ps=0.74u w=0.15u l=0.13u
X907 CTRL 6ph_rosc_0.PH3.t11 CTRL VDD.t57 sg13_lv_pmos ad=0.19p pd=1.38u as=0 ps=0 w=1u l=0.13u
X908 VSS.t1765 6to4_0.buff_PI_d32_1.buff_PI_d16$1_0.inv_PI_d8$1_0.VOUT.t33 6to4_0.buff_PI_d32_1.inv_PI_d16$1_0.VIN VSS.t1764 sg13_lv_nmos ad=0.1005p pd=1.34u as=55.5f ps=0.74u w=0.15u l=0.13u
X909 6ph_rosc_0.psdiff_1.buff_d8$1_0.VIN.t9 6ph_rosc_0.psdiff_2.VOUTDP VSS.t239 VSS.t210 sg13_lv_nmos ad=55.5f pd=0.74u as=55.5f ps=0.74u w=0.15u l=0.13u
X910 VDD.t362 6to4_0.buff_PI_d32_0.inv_PI_d32_0.VIN PH90.t82 VDD.t347 sg13_lv_pmos ad=55.5f pd=0.74u as=55.5f ps=0.74u w=0.15u l=0.13u
X911 6ph_rosc_0.buff_d8$1_0.inv_d8$1_0.VIN 6ph_rosc_0.buff_d8$1_0.inv_d4$1_0.VIN VDD.t90 VDD.t89 sg13_lv_pmos ad=55.5f pd=0.74u as=0.1005p ps=1.34u w=0.15u l=0.13u
X912 6to4_0.buff_PI_d32_3.inv_PI_d32_0.VIN 6to4_0.buff_PI_d32_3.inv_PI_d16$1_0.VIN.t48 VDD.t863 VDD.t679 sg13_lv_pmos ad=0.1005p pd=1.34u as=55.5f ps=0.74u w=0.15u l=0.13u
X913 VSS.t1144 6ph_rosc_0.psdiff_2.VOUTDN 6ph_rosc_0.psdiff_1.buff_d8$1_1.VIN.t18 VSS.t494 sg13_lv_nmos ad=55.5f pd=0.74u as=55.5f ps=0.74u w=0.15u l=0.13u
X914 VDD.t697 6to4_0.buff_PI_d32_3.inv_PI_d32_0.VIN PH180.t86 VDD.t677 sg13_lv_pmos ad=55.5f pd=0.74u as=0.1005p ps=1.34u w=0.15u l=0.13u
X915 PH90.t14 6to4_0.buff_PI_d32_0.inv_PI_d32_0.VIN VSS.t610 VSS.t609 sg13_lv_nmos ad=55.5f pd=0.74u as=0.1005p ps=1.34u w=0.15u l=0.13u
X916 VSS.t1356 6to4_0.buff_PI_d32_3.inv_PI_d16$1_0.VIN.t62 6to4_0.buff_PI_d32_3.inv_PI_d32_0.VIN VSS.t1355 sg13_lv_nmos ad=0.1005p pd=1.34u as=55.5f ps=0.74u w=0.15u l=0.13u
X917 6to4_0.buff_PI_d32_0.inv_PI_d16$1_0.VIN.t25 6to4_0.buff_PI_d32_0.buff_PI_d16$1_0.inv_PI_d8$1_0.VOUT.t32 VDD.t1105 VDD.t5 sg13_lv_pmos ad=55.5f pd=0.74u as=55.5f ps=0.74u w=0.15u l=0.13u
X918 CTRL 6ph_rosc_0.PH5.t12 CTRL VDD.t87 sg13_lv_pmos ad=0.19p pd=1.38u as=0 ps=0 w=1u l=0.13u
X919 6to4_0.buff_PI_d32_2.inv_PI_d32_0.VIN.t30 6to4_0.buff_PI_d32_2.inv_PI_d16$1_0.VIN.t58 VSS.t1478 VSS.t1477 sg13_lv_nmos ad=55.5f pd=0.74u as=0.1005p ps=1.34u w=0.15u l=0.13u
X920 6to4_0.buff_PI_d32_3.inv_PI_d16$1_0.VIN.t24 6to4_0.buff_PI_d32_3.buff_PI_d16$1_0.inv_PI_d8$1_0.VOUT.t32 VSS.t1821 VSS.t1820 sg13_lv_nmos ad=55.5f pd=0.74u as=0.1005p ps=1.34u w=0.15u l=0.13u
X921 VDD.t1040 6to4_0.buff_PI_d32_2.buff_PI_d16$1_0.inv_PI_d4$1_0.VOUT.t12 6to4_0.buff_PI_d32_2.buff_PI_d16$1_0.inv_PI_d8$1_0.VOUT.t22 VDD.t198 sg13_lv_pmos ad=55.5f pd=0.74u as=0.1005p ps=1.34u w=0.15u l=0.13u
X922 PH270.t12 6to4_0.buff_PI_d32_2.inv_PI_d32_0.VIN.t79 VSS.t458 VSS.t457 sg13_lv_nmos ad=55.5f pd=0.74u as=0.1005p ps=1.34u w=0.15u l=0.13u
X923 VSS.t1093 6to4_0.buff_PI_d32_3.inv_PI_d32_0.VIN PH180.t5 VSS.t1092 sg13_lv_nmos ad=0.1005p pd=1.34u as=55.5f ps=0.74u w=0.15u l=0.13u
X924 VSS.t1670 6ph_rosc_0.PH2.t11 6to4_0.PI_clk_0.inv_PI_d2$1_0.VOUT VSS.t1669 sg13_lv_nmos ad=0.1005p pd=1.34u as=55.5f ps=0.74u w=0.15u l=0.13u
X925 VSS.t1147 6ph_rosc_0.psdiff_2.VOUTDN 6ph_rosc_0.psdiff_1.buff_d8$1_1.VIN.t27 VSS.t1159 sg13_lv_nmos ad=55.5f pd=0.74u as=55.5f ps=0.74u w=0.15u l=0.13u
X926 6to4_0.buff_PI_d32_3.inv_PI_d16$1_0.VIN.t46 6to4_0.buff_PI_d32_3.buff_PI_d16$1_0.inv_PI_d8$1_0.VOUT.t39 VDD.t1244 VDD.t679 sg13_lv_pmos ad=55.5f pd=0.74u as=55.5f ps=0.74u w=0.15u l=0.13u
X927 6to4_0.inv_PI_d2$1_1.VIN 6ph_rosc_0.PH0.t14 VSS.t1252 VSS.t1251 sg13_lv_nmos ad=55.5f pd=0.74u as=0.1005p ps=1.34u w=0.15u l=0.13u
X928 CTRL 6ph_rosc_0.PH3.t11 CTRL VDD.t330 sg13_lv_pmos ad=0.19p pd=1.38u as=0 ps=0 w=1u l=0.13u
X929 VDD.t225 6to4_0.buff_PI_d32_2.inv_PI_d32_0.VIN.t56 PH270.t82 VDD.t198 sg13_lv_pmos ad=55.5f pd=0.74u as=0.1005p ps=1.34u w=0.15u l=0.13u
X930 VSS.t1843 6to4_0.buff_PI_d32_3.buff_PI_d16$1_0.inv_PI_d8$1_0.VOUT.t37 6to4_0.buff_PI_d32_3.inv_PI_d16$1_0.VIN.t39 VSS.t1842 sg13_lv_nmos ad=0.1005p pd=1.34u as=55.5f ps=0.74u w=0.15u l=0.13u
X931 PH90.t67 6to4_0.buff_PI_d32_0.inv_PI_d32_0.VIN VDD.t386 VDD.t5 sg13_lv_pmos ad=55.5f pd=0.74u as=55.5f ps=0.74u w=0.15u l=0.13u
X932 VSS.t678 6ph_rosc_0.buff_d8$1_2.inv_d8$1_0.VIN 6ph_rosc_0.PH4.t2 VSS.t677 sg13_lv_nmos ad=0.1005p pd=1.34u as=55.5f ps=0.74u w=0.15u l=0.13u
X933 CTRL 6ph_rosc_0.PH5.t12 CTRL VDD.t85 sg13_lv_pmos ad=0.19p pd=1.38u as=0 ps=0 w=1u l=0.13u
X934 VSS.t933 6to4_0.buff_PI_d32_1.inv_PI_d32_0.VIN PH0.t6 VSS.t932 sg13_lv_nmos ad=0.1005p pd=1.34u as=55.5f ps=0.74u w=0.15u l=0.13u
X935 VDD.t24 6to4_0.buff_PI_d32_1.buff_PI_d16$1_0.inv_PI_d4$1_0.VIN 6to4_0.buff_PI_d32_1.buff_PI_d16$1_0.inv_PI_d4$1_0.VOUT.t10 VDD.t17 sg13_lv_pmos ad=0.1005p pd=1.34u as=55.5f ps=0.74u w=0.15u l=0.13u
X936 PH0.t31 6to4_0.buff_PI_d32_1.inv_PI_d32_0.VIN VSS.t931 VSS.t930 sg13_lv_nmos ad=55.5f pd=0.74u as=0.1005p ps=1.34u w=0.15u l=0.13u
X937 VSS.t1594 6to4_0.buff_PI_d32_0.buff_PI_d16$1_0.inv_PI_d8$1_0.VOUT.t24 6to4_0.buff_PI_d32_0.inv_PI_d16$1_0.VIN.t0 VSS.t1593 sg13_lv_nmos ad=0.1005p pd=1.34u as=55.5f ps=0.74u w=0.15u l=0.13u
X938 VDD.t1014 6to4_0.buff_PI_d32_2.inv_PI_d16$1_0.VIN.t63 6to4_0.buff_PI_d32_2.inv_PI_d32_0.VIN.t46 VDD.t126 sg13_lv_pmos ad=55.5f pd=0.74u as=55.5f ps=0.74u w=0.15u l=0.13u
X939 CTRL 6ph_rosc_0.PH3.t11 CTRL VDD.t464 sg13_lv_pmos ad=0.19p pd=1.38u as=0 ps=0 w=1u l=0.13u
X940 VDD.t1391 VSS.t1967 6ph_rosc_0.psdiff_1.buff_d8$1_0.VIN.t17 VDD.t301 sg13_lv_pmos ad=55.5f pd=0.74u as=55.5f ps=0.74u w=0.15u l=0.13u
X941 PH180.t52 6to4_0.buff_PI_d32_3.inv_PI_d32_0.VIN VDD.t740 VDD.t677 sg13_lv_pmos ad=55.5f pd=0.74u as=0.1005p ps=1.34u w=0.15u l=0.13u
X942 6ph_rosc_0.PH0.t3 6ph_rosc_0.buff_d8$1_5.inv_d8$1_0.VIN VSS.t77 VSS.t76 sg13_lv_nmos ad=55.5f pd=0.74u as=0.1005p ps=1.34u w=0.15u l=0.13u
X943 6ph_rosc_0.psdiff_2.buff_d8$1_0.VIN.t30 a_4999_2194# VDD.t645 VDD.t470 sg13_lv_pmos ad=55.5f pd=0.74u as=55.5f ps=0.74u w=0.15u l=0.13u
X944 VDD.t1111 6to4_0.buff_PI_d32_0.buff_PI_d16$1_0.inv_PI_d8$1_0.VOUT.t34 6to4_0.buff_PI_d32_0.inv_PI_d16$1_0.VIN.t32 VDD.t341 sg13_lv_pmos ad=55.5f pd=0.74u as=0.1005p ps=1.34u w=0.15u l=0.13u
X945 VSS.t221 6ph_rosc_0.psdiff_2.VOUTDP 6ph_rosc_0.psdiff_1.buff_d8$1_0.VIN.t1 VSS.t224 sg13_lv_nmos ad=55.5f pd=0.74u as=55.5f ps=0.74u w=0.15u l=0.13u
X946 VSS.t818 6ph_rosc_0.psdiff_1.VOUTDP 6ph_rosc_0.psdiff_0.buff_d8$1_0.VIN.t17 VSS.t830 sg13_lv_nmos ad=55.5f pd=0.74u as=55.5f ps=0.74u w=0.15u l=0.13u
X947 VDD.t1392 VSS.t1967 6ph_rosc_0.psdiff_1.buff_d8$1_0.VIN.t22 VDD.t301 sg13_lv_pmos ad=55.5f pd=0.74u as=55.5f ps=0.74u w=0.15u l=0.13u
X948 PH0.t25 6to4_0.buff_PI_d32_1.inv_PI_d32_0.VIN VSS.t929 VSS.t928 sg13_lv_nmos ad=55.5f pd=0.74u as=0.1005p ps=1.34u w=0.15u l=0.13u
X949 VDD.t1286 6to4_0.buff_PI_d32_1.inv_PI_d16$1_0.VIN 6to4_0.buff_PI_d32_1.inv_PI_d32_0.VIN VDD.t17 sg13_lv_pmos ad=0.1005p pd=1.34u as=55.5f ps=0.74u w=0.15u l=0.13u
X950 VSS.t608 6to4_0.buff_PI_d32_0.inv_PI_d32_0.VIN PH90.t31 VSS.t607 sg13_lv_nmos ad=0.1005p pd=1.34u as=55.5f ps=0.74u w=0.15u l=0.13u
X951 6to4_0.flywheel_clk_0.PH0 6to4_0.PI_clk_0.inv_PI_d2$1_0.VOUT VSS.t173 VSS.t172 sg13_lv_nmos ad=55.5f pd=0.74u as=0.1005p ps=1.34u w=0.15u l=0.13u
X952 6ph_rosc_0.psdiff_2.buff_d8$1_1.inv_d8$1_0.VIN 6ph_rosc_0.psdiff_2.buff_d8$1_1.inv_d4$1_0.VIN VDD.t31 VDD.t0 sg13_lv_pmos ad=55.5f pd=0.74u as=0.1005p ps=1.34u w=0.15u l=0.13u
X953 6to4_0.buff_PI_d32_3.inv_PI_d16$1_0.VIN.t42 6to4_0.buff_PI_d32_3.buff_PI_d16$1_0.inv_PI_d8$1_0.VOUT.t38 VSS.t1847 VSS.t1846 sg13_lv_nmos ad=55.5f pd=0.74u as=0.1005p ps=1.34u w=0.15u l=0.13u
X954 PH90.t30 6to4_0.buff_PI_d32_0.inv_PI_d32_0.VIN VSS.t606 VSS.t605 sg13_lv_nmos ad=55.5f pd=0.74u as=0.1005p ps=1.34u w=0.15u l=0.13u
X955 PH0.t13 6to4_0.buff_PI_d32_1.inv_PI_d32_0.VIN VSS.t927 VSS.t926 sg13_lv_nmos ad=55.5f pd=0.74u as=0.1005p ps=1.34u w=0.15u l=0.13u
X956 6ph_rosc_0.buff_d8$1_0.inv_d8$1_0.VIN 6ph_rosc_0.buff_d8$1_0.inv_d4$1_0.VIN VSS.t125 VSS.t124 sg13_lv_nmos ad=55.5f pd=0.74u as=0.1005p ps=1.34u w=0.15u l=0.13u
X957 VDD.t255 6to4_0.buff_PI_d32_2.inv_PI_d32_0.VIN.t66 PH270.t81 VDD.t215 sg13_lv_pmos ad=55.5f pd=0.74u as=55.5f ps=0.74u w=0.15u l=0.13u
X958 6ph_rosc_0.psdiff_2.buff_d8$1_0.VIN.t29 a_4999_2194# VDD.t646 VDD.t470 sg13_lv_pmos ad=55.5f pd=0.74u as=55.5f ps=0.74u w=0.15u l=0.13u
X959 6to4_0.buff_PI_d32_0.inv_PI_d16$1_0.VIN.t42 6to4_0.buff_PI_d32_0.buff_PI_d16$1_0.inv_PI_d8$1_0.VOUT.t38 VSS.t1652 VSS.t1651 sg13_lv_nmos ad=55.5f pd=0.74u as=0.1005p ps=1.34u w=0.15u l=0.13u
X960 6to4_0.buff_PI_d32_3.inv_PI_d32_0.VIN 6to4_0.buff_PI_d32_3.inv_PI_d16$1_0.VIN.t56 VDD.t888 VDD.t679 sg13_lv_pmos ad=55.5f pd=0.74u as=55.5f ps=0.74u w=0.15u l=0.13u
X961 PH270.t47 6to4_0.buff_PI_d32_2.inv_PI_d32_0.VIN.t69 VDD.t265 VDD.t198 sg13_lv_pmos ad=55.5f pd=0.74u as=0.1005p ps=1.34u w=0.15u l=0.13u
X962 VSS.t1244 6ph_rosc_0.PH0.t12 6to4_0.inv_PI_d2$1_1.VIN VSS.t1243 sg13_lv_nmos ad=0.1005p pd=1.34u as=55.5f ps=0.74u w=0.15u l=0.13u
X963 VSS.t219 6ph_rosc_0.psdiff_2.VOUTDP 6ph_rosc_0.psdiff_1.buff_d8$1_0.VIN.t2 VSS.t222 sg13_lv_nmos ad=55.5f pd=0.74u as=55.5f ps=0.74u w=0.15u l=0.13u
X964 VDD.t879 6to4_0.buff_PI_d32_3.inv_PI_d16$1_0.VIN.t53 6to4_0.buff_PI_d32_3.inv_PI_d32_0.VIN VDD.t679 sg13_lv_pmos ad=55.5f pd=0.74u as=55.5f ps=0.74u w=0.15u l=0.13u
X965 VSS.t354 6to4_0.buff_PI_d32_2.inv_PI_d32_0.VIN.t53 PH270.t25 VSS.t353 sg13_lv_nmos ad=0.1005p pd=1.34u as=55.5f ps=0.74u w=0.15u l=0.13u
X966 VSS.t1091 6to4_0.buff_PI_d32_3.inv_PI_d32_0.VIN PH180.t2 VSS.t1090 sg13_lv_nmos ad=0.1005p pd=1.34u as=55.5f ps=0.74u w=0.15u l=0.13u
X967 VDD.t370 6to4_0.buff_PI_d32_0.inv_PI_d32_0.VIN PH90.t40 VDD.t5 sg13_lv_pmos ad=55.5f pd=0.74u as=55.5f ps=0.74u w=0.15u l=0.13u
X968 VSS.t260 6ph_rosc_0.buff_d8$1_3.inv_d8$1_0.VIN 6ph_rosc_0.PH1.t3 VSS.t259 sg13_lv_nmos ad=0.1005p pd=1.34u as=55.5f ps=0.74u w=0.15u l=0.13u
X969 CTRL 6ph_rosc_0.PH4.t10 CTRL VDD.t451 sg13_lv_pmos ad=0.19p pd=1.38u as=0 ps=0 w=1u l=0.13u
X970 6to4_0.buff_PI_d32_0.buff_PI_d16$1_0.inv_PI_d8$1_0.VOUT.t23 6to4_0.buff_PI_d32_0.buff_PI_d16$1_0.inv_PI_d4$1_0.VOUT.t19 VDD.t855 VDD.t341 sg13_lv_pmos ad=0.1005p pd=1.34u as=55.5f ps=0.74u w=0.15u l=0.13u
X971 6to4_0.buff_PI_d32_1.buff_PI_d16$1_0.inv_PI_d8$1_0.VOUT.t21 6to4_0.buff_PI_d32_1.buff_PI_d16$1_0.inv_PI_d4$1_0.VOUT.t19 VDD.t195 VDD.t173 sg13_lv_pmos ad=55.5f pd=0.74u as=55.5f ps=0.74u w=0.15u l=0.13u
X972 VSS.t985 6ph_rosc_0.psdiff_1.buff_d8$1_0.inv_d8$1_0.VIN 6ph_rosc_0.psdiff_1.VOUTDP VSS.t984 sg13_lv_nmos ad=0.1005p pd=1.34u as=55.5f ps=0.74u w=0.15u l=0.13u
X973 6ph_rosc_0.psdiff_2.VOUTDN 6ph_rosc_0.psdiff_2.buff_d8$1_1.inv_d8$1_0.VIN VDD.t532 VDD.t0 sg13_lv_pmos ad=55.5f pd=0.74u as=0.1005p ps=1.34u w=0.15u l=0.13u
X974 VSS.t1089 6to4_0.buff_PI_d32_3.inv_PI_d32_0.VIN PH180.t4 VSS.t1088 sg13_lv_nmos ad=0.1005p pd=1.34u as=55.5f ps=0.74u w=0.15u l=0.13u
X975 VDD.t815 6to4_0.buff_PI_d32_2.buff_PI_d16$1_0.inv_PI_d8$1_0.VOUT.t37 6to4_0.buff_PI_d32_2.inv_PI_d16$1_0.VIN.t42 VDD.t126 sg13_lv_pmos ad=55.5f pd=0.74u as=0.1005p ps=1.34u w=0.15u l=0.13u
X976 6ph_rosc_0.psdiff_1.buff_d8$1_1.VIN.t19 6ph_rosc_0.psdiff_2.VOUTDN VSS.t1161 VSS.t1145 sg13_lv_nmos ad=55.5f pd=0.74u as=0.1005p ps=1.34u w=0.15u l=0.13u
X977 VDD.t84 6ph_rosc_0.buff_d8$1_2.inv_d4$1_0.VIN 6ph_rosc_0.buff_d8$1_2.inv_d8$1_0.VIN VDD.t82 sg13_lv_pmos ad=0.1005p pd=1.34u as=55.5f ps=0.74u w=0.15u l=0.13u
X978 PH180.t30 6to4_0.buff_PI_d32_3.inv_PI_d32_0.VIN VSS.t1087 VSS.t1086 sg13_lv_nmos ad=55.5f pd=0.74u as=0.1005p ps=1.34u w=0.15u l=0.13u
X979 VDD.t613 6to4_0.buff_PI_d32_1.inv_PI_d32_0.VIN PH0.t67 VDD.t547 sg13_lv_pmos ad=0.1005p pd=1.34u as=55.5f ps=0.74u w=0.15u l=0.13u
X980 VSS.t1186 6to4_0.buff_PI_d32_2.buff_PI_d16$1_0.inv_PI_d8$1_0.VOUT.t26 6to4_0.buff_PI_d32_2.inv_PI_d16$1_0.VIN.t15 VSS.t1185 sg13_lv_nmos ad=0.1005p pd=1.34u as=55.5f ps=0.74u w=0.15u l=0.13u
X981 VDD.t460 6ph_rosc_0.buff_d8$1_4.inv_d4$1_0.VIN 6ph_rosc_0.buff_d8$1_4.inv_d8$1_0.VIN VDD.t75 sg13_lv_pmos ad=0.1005p pd=1.34u as=55.5f ps=0.74u w=0.15u l=0.13u
X982 VDD.t1311 VSS.t1965 6ph_rosc_0.psdiff_0.buff_d8$1_1.VIN.t1 VDD.t503 sg13_lv_pmos ad=55.5f pd=0.74u as=55.5f ps=0.74u w=0.15u l=0.13u
X983 PH180.t49 6to4_0.buff_PI_d32_3.inv_PI_d32_0.VIN VDD.t709 VDD.t673 sg13_lv_pmos ad=55.5f pd=0.74u as=55.5f ps=0.74u w=0.15u l=0.13u
X984 VSS.t1901 6to4_0.buff_PI_d32_1.inv_PI_d16$1_0.VIN 6to4_0.buff_PI_d32_1.inv_PI_d32_0.VIN VSS.t1900 sg13_lv_nmos ad=0.1005p pd=1.34u as=55.5f ps=0.74u w=0.15u l=0.13u
X985 VDD.t902 6to4_0.buff_PI_d32_3.inv_PI_d16$1_0.VIN.t61 6to4_0.buff_PI_d32_3.inv_PI_d32_0.VIN VDD.t679 sg13_lv_pmos ad=55.5f pd=0.74u as=0.1005p ps=1.34u w=0.15u l=0.13u
X986 VDD.t974 6to4_0.buff_PI_d32_2.inv_PI_d16$1_0.VIN.t50 6to4_0.buff_PI_d32_2.inv_PI_d32_0.VIN.t8 VDD.t126 sg13_lv_pmos ad=55.5f pd=0.74u as=0.1005p ps=1.34u w=0.15u l=0.13u
X987 6ph_rosc_0.psdiff_2.VOUTDP 6ph_rosc_0.psdiff_2.buff_d8$1_0.inv_d8$1_0.VIN VSS.t203 VSS.t202 sg13_lv_nmos ad=55.5f pd=0.74u as=0.1005p ps=1.34u w=0.15u l=0.13u
X988 VDD.t223 6to4_0.buff_PI_d32_2.inv_PI_d32_0.VIN.t55 PH270.t80 VDD.t198 sg13_lv_pmos ad=0.1005p pd=1.34u as=55.5f ps=0.74u w=0.15u l=0.13u
X989 VSS.t831 6ph_rosc_0.psdiff_1.VOUTDP 6ph_rosc_0.psdiff_0.buff_d8$1_0.VIN.t28 VSS.t819 sg13_lv_nmos ad=0.1005p pd=1.34u as=55.5f ps=0.74u w=0.15u l=0.13u
X990 CTRL 6ph_rosc_0.PH0.t10 CTRL VDD.t51 sg13_lv_pmos ad=0.19p pd=1.38u as=0 ps=0 w=1u l=0.13u
X991 PH180.t25 6to4_0.buff_PI_d32_3.inv_PI_d32_0.VIN VSS.t1085 VSS.t1084 sg13_lv_nmos ad=55.5f pd=0.74u as=0.1005p ps=1.34u w=0.15u l=0.13u
X992 VSS.t925 6to4_0.buff_PI_d32_1.inv_PI_d32_0.VIN PH0.t12 VSS.t924 sg13_lv_nmos ad=0.1005p pd=1.34u as=55.5f ps=0.74u w=0.15u l=0.13u
X993 6ph_rosc_0.psdiff_1.buff_d8$1_0.inv_d8$1_0.VIN 6ph_rosc_0.psdiff_1.buff_d8$1_0.inv_d4$1_0.VIN VDD.t73 VDD.t34 sg13_lv_pmos ad=55.5f pd=0.74u as=0.1005p ps=1.34u w=0.15u l=0.13u
X994 PH0.t83 6to4_0.buff_PI_d32_1.inv_PI_d32_0.VIN VDD.t562 VDD.t17 sg13_lv_pmos ad=0.1005p pd=1.34u as=55.5f ps=0.74u w=0.15u l=0.13u
X995 VSS.t348 6to4_0.buff_PI_d32_2.inv_PI_d32_0.VIN.t52 PH270.t29 VSS.t347 sg13_lv_nmos ad=0.1005p pd=1.34u as=55.5f ps=0.74u w=0.15u l=0.13u
X996 VSS.t171 6to4_0.PI_clk_0.inv_PI_d2$1_0.VOUT 6to4_0.flywheel_clk_0.PH0 VSS.t170 sg13_lv_nmos ad=0.1005p pd=1.34u as=55.5f ps=0.74u w=0.15u l=0.13u
X997 VDD.t280 6to4_0.buff_PI_d32_2.inv_PI_d32_0.VIN.t74 PH270.t40 VDD.t202 sg13_lv_pmos ad=55.5f pd=0.74u as=55.5f ps=0.74u w=0.15u l=0.13u
X998 PH180.t12 6to4_0.buff_PI_d32_3.inv_PI_d32_0.VIN VSS.t1083 VSS.t1082 sg13_lv_nmos ad=55.5f pd=0.74u as=0.1005p ps=1.34u w=0.15u l=0.13u
X999 6to4_0.buff_PI_d32_2.buff_PI_d16$1_0.inv_PI_d4$1_0.VOUT.t9 6to4_0.buff_PI_d32_2.buff_PI_d16$1_0.inv_PI_d4$1_0.VIN VDD.t127 VDD.t126 sg13_lv_pmos ad=0.1005p pd=1.34u as=55.5f ps=0.74u w=0.15u l=0.13u
X1000 6to4_0.buff_PI_d32_3.inv_PI_d32_0.VIN 6to4_0.buff_PI_d32_3.inv_PI_d16$1_0.VIN.t54 VDD.t881 VDD.t99 sg13_lv_pmos ad=55.5f pd=0.74u as=55.5f ps=0.74u w=0.15u l=0.13u
X1001 VDD.t1028 6to4_0.buff_PI_d32_3.buff_PI_d16$1_0.inv_PI_d4$1_0.VOUT.t12 6to4_0.buff_PI_d32_3.buff_PI_d16$1_0.inv_PI_d8$1_0.VOUT.t21 VDD.t679 sg13_lv_pmos ad=55.5f pd=0.74u as=55.5f ps=0.74u w=0.15u l=0.13u
X1002 VSS.t604 6to4_0.buff_PI_d32_0.inv_PI_d32_0.VIN PH90.t29 VSS.t603 sg13_lv_nmos ad=0.1005p pd=1.34u as=55.5f ps=0.74u w=0.15u l=0.13u
X1003 6ph_rosc_0.psdiff_0.buff_d8$1_0.inv_d8$1_0.VIN 6ph_rosc_0.psdiff_0.buff_d8$1_0.inv_d4$1_0.VIN VSS.t1292 VSS.t1291 sg13_lv_nmos ad=55.5f pd=0.74u as=0.1005p ps=1.34u w=0.15u l=0.13u
X1004 6ph_rosc_0.psdiff_2.buff_d8$1_1.VIN.t24 VSS.t1966 VDD.t1356 VDD.t470 sg13_lv_pmos ad=55.5f pd=0.74u as=55.5f ps=0.74u w=0.15u l=0.13u
X1005 CTRL 6ph_rosc_0.PH0.t10 CTRL VDD.t51 sg13_lv_pmos ad=0.19p pd=1.38u as=0 ps=0 w=1u l=0.13u
X1006 VSS.t1081 6to4_0.buff_PI_d32_3.inv_PI_d32_0.VIN PH180.t29 VSS.t1080 sg13_lv_nmos ad=0.1005p pd=1.34u as=55.5f ps=0.74u w=0.15u l=0.13u
X1007 6to4_0.buff_PI_d32_3.buff_PI_d16$1_0.inv_PI_d8$1_0.VOUT.t7 6to4_0.buff_PI_d32_3.buff_PI_d16$1_0.inv_PI_d4$1_0.VOUT.t13 VSS.t1522 VSS.t1521 sg13_lv_nmos ad=55.5f pd=0.74u as=0.1005p ps=1.34u w=0.15u l=0.13u
X1008 PH0.t30 6to4_0.buff_PI_d32_1.inv_PI_d32_0.VIN VSS.t923 VSS.t922 sg13_lv_nmos ad=55.5f pd=0.74u as=0.1005p ps=1.34u w=0.15u l=0.13u
X1009 6ph_rosc_0.PH4.t6 6ph_rosc_0.buff_d8$1_2.inv_d8$1_0.VIN VDD.t454 VDD.t451 sg13_lv_pmos ad=55.5f pd=0.74u as=0.1005p ps=1.34u w=0.15u l=0.13u
X1010 6to4_0.buff_PI_d32_2.inv_PI_d16$1_0.VIN.t11 6to4_0.buff_PI_d32_2.buff_PI_d16$1_0.inv_PI_d8$1_0.VOUT.t39 VSS.t1240 VSS.t1239 sg13_lv_nmos ad=55.5f pd=0.74u as=0.1005p ps=1.34u w=0.15u l=0.13u
X1011 PH270.t18 6to4_0.buff_PI_d32_2.inv_PI_d32_0.VIN.t54 VSS.t358 VSS.t357 sg13_lv_nmos ad=55.5f pd=0.74u as=0.1005p ps=1.34u w=0.15u l=0.13u
X1012 6to4_0.buff_PI_d32_1.inv_PI_d16$1_0.VIN 6to4_0.buff_PI_d32_1.buff_PI_d16$1_0.inv_PI_d8$1_0.VOUT.t24 VSS.t1763 VSS.t1762 sg13_lv_nmos ad=55.5f pd=0.74u as=0.1005p ps=1.34u w=0.15u l=0.13u
X1013 6to4_0.buff_PI_d32_3.inv_PI_d32_0.VIN 6to4_0.buff_PI_d32_3.inv_PI_d16$1_0.VIN.t62 VDD.t906 VDD.t679 sg13_lv_pmos ad=55.5f pd=0.74u as=0.1005p ps=1.34u w=0.15u l=0.13u
X1014 VDD.t847 6to4_0.buff_PI_d32_0.buff_PI_d16$1_0.inv_PI_d4$1_0.VOUT.t16 6to4_0.buff_PI_d32_0.buff_PI_d16$1_0.inv_PI_d8$1_0.VOUT.t14 VDD.t341 sg13_lv_pmos ad=0.1005p pd=1.34u as=55.5f ps=0.74u w=0.15u l=0.13u
X1015 PH90.t45 6to4_0.buff_PI_d32_0.inv_PI_d32_0.VIN VDD.t402 VDD.t347 sg13_lv_pmos ad=55.5f pd=0.74u as=0.1005p ps=1.34u w=0.15u l=0.13u
X1016 VSS.t1079 6to4_0.buff_PI_d32_3.inv_PI_d32_0.VIN PH180.t22 VSS.t1078 sg13_lv_nmos ad=0.1005p pd=1.34u as=55.5f ps=0.74u w=0.15u l=0.13u
X1017 VDD.t356 6to4_0.buff_PI_d32_0.inv_PI_d32_0.VIN PH90.t81 VDD.t5 sg13_lv_pmos ad=55.5f pd=0.74u as=0.1005p ps=1.34u w=0.15u l=0.13u
X1018 6to4_0.buff_PI_d32_1.buff_PI_d16$1_0.inv_PI_d8$1_0.VOUT.t6 6to4_0.buff_PI_d32_1.buff_PI_d16$1_0.inv_PI_d4$1_0.VOUT.t14 VDD.t181 VDD.t173 sg13_lv_pmos ad=55.5f pd=0.74u as=0.1005p ps=1.34u w=0.15u l=0.13u
X1019 6to4_0.buff_PI_d32_1.inv_PI_d32_0.VIN 6to4_0.buff_PI_d32_1.inv_PI_d16$1_0.VIN VSS.t1899 VSS.t1898 sg13_lv_nmos ad=55.5f pd=0.74u as=0.1005p ps=1.34u w=0.15u l=0.13u
X1020 VDD.t738 6to4_0.buff_PI_d32_3.inv_PI_d32_0.VIN PH180.t85 VDD.t679 sg13_lv_pmos ad=55.5f pd=0.74u as=0.1005p ps=1.34u w=0.15u l=0.13u
X1021 6to4_0.buff_PI_d32_2.inv_PI_d32_0.VIN.t37 6to4_0.buff_PI_d32_2.inv_PI_d16$1_0.VIN.t60 VDD.t1005 VDD.t126 sg13_lv_pmos ad=55.5f pd=0.74u as=0.1005p ps=1.34u w=0.15u l=0.13u
X1022 CTRL 6ph_rosc_0.PH5.t12 CTRL VDD.t85 sg13_lv_pmos ad=0.19p pd=1.38u as=0 ps=0 w=1u l=0.13u
X1023 PH180.t10 6to4_0.buff_PI_d32_3.inv_PI_d32_0.VIN VSS.t1077 VSS.t1076 sg13_lv_nmos ad=55.5f pd=0.74u as=0.1005p ps=1.34u w=0.15u l=0.13u
X1024 VDD.t936 6to4_0.buff_PI_d32_0.inv_PI_d16$1_0.VIN.t53 6to4_0.buff_PI_d32_0.inv_PI_d32_0.VIN VDD.t341 sg13_lv_pmos ad=0.1005p pd=1.34u as=55.5f ps=0.74u w=0.15u l=0.13u
X1025 VSS.t15 6to4_0.flywheel_clk_0.PH0 6to4_0.buff_PI_d32_2.VIN VSS.t14 sg13_lv_nmos ad=0.1005p pd=1.34u as=55.5f ps=0.74u w=0.15u l=0.13u
X1026 VDD.t893 6to4_0.buff_PI_d32_3.inv_PI_d16$1_0.VIN.t58 6to4_0.buff_PI_d32_3.inv_PI_d32_0.VIN VDD.t99 sg13_lv_pmos ad=55.5f pd=0.74u as=55.5f ps=0.74u w=0.15u l=0.13u
X1027 CTRL 6ph_rosc_0.PH2.t10 CTRL VDD.t89 sg13_lv_pmos ad=0.19p pd=1.38u as=0 ps=0 w=1u l=0.13u
X1028 VSS.t1508 6to4_0.buff_PI_d32_3.buff_PI_d16$1_0.inv_PI_d4$1_0.VOUT.t17 6to4_0.buff_PI_d32_3.buff_PI_d16$1_0.inv_PI_d8$1_0.VOUT.t4 VSS.t1507 sg13_lv_nmos ad=0.1005p pd=1.34u as=55.5f ps=0.74u w=0.15u l=0.13u
X1029 PH270.t79 6to4_0.buff_PI_d32_2.inv_PI_d32_0.VIN.t54 VDD.t220 VDD.t215 sg13_lv_pmos ad=0.1005p pd=1.34u as=55.5f ps=0.74u w=0.15u l=0.13u
X1030 6to4_0.buff_PI_d32_2.inv_PI_d32_0.VIN.t41 6to4_0.buff_PI_d32_2.inv_PI_d16$1_0.VIN.t61 VDD.t1007 VDD.t198 sg13_lv_pmos ad=0.1005p pd=1.34u as=55.5f ps=0.74u w=0.15u l=0.13u
X1031 6to4_0.buff_PI_d32_1.inv_PI_d32_0.VIN 6to4_0.buff_PI_d32_1.inv_PI_d16$1_0.VIN VDD.t1285 VDD.t17 sg13_lv_pmos ad=55.5f pd=0.74u as=55.5f ps=0.74u w=0.15u l=0.13u
X1032 PH180.t84 6to4_0.buff_PI_d32_3.inv_PI_d32_0.VIN VDD.t737 VDD.t99 sg13_lv_pmos ad=55.5f pd=0.74u as=55.5f ps=0.74u w=0.15u l=0.13u
X1033 VDD.t274 6to4_0.buff_PI_d32_2.inv_PI_d32_0.VIN.t72 PH270.t78 VDD.t202 sg13_lv_pmos ad=55.5f pd=0.74u as=0.1005p ps=1.34u w=0.15u l=0.13u
X1034 6to4_0.buff_PI_d32_3.inv_PI_d16$1_0.VIN.t15 6to4_0.buff_PI_d32_3.buff_PI_d16$1_0.inv_PI_d8$1_0.VOUT.t29 VSS.t1809 VSS.t1808 sg13_lv_nmos ad=55.5f pd=0.74u as=0.1005p ps=1.34u w=0.15u l=0.13u
X1035 VDD.t76 6ph_rosc_0.buff_d8$1_3.inv_d2$1_0.VIN 6ph_rosc_0.buff_d8$1_3.inv_d4$1_0.VIN VDD.t75 sg13_lv_pmos ad=0.1005p pd=1.34u as=55.5f ps=0.74u w=0.15u l=0.13u
X1036 VDD.t611 6to4_0.buff_PI_d32_1.inv_PI_d32_0.VIN PH0.t38 VDD.t552 sg13_lv_pmos ad=0.1005p pd=1.34u as=55.5f ps=0.74u w=0.15u l=0.13u
X1037 CTRL 6ph_rosc_0.PH4.t10 CTRL VDD.t78 sg13_lv_pmos ad=0.19p pd=1.38u as=0 ps=0 w=1u l=0.13u
X1038 PH180.t48 6to4_0.buff_PI_d32_3.inv_PI_d32_0.VIN VDD.t736 VDD.t679 sg13_lv_pmos ad=55.5f pd=0.74u as=0.1005p ps=1.34u w=0.15u l=0.13u
X1039 PH270.t8 6to4_0.buff_PI_d32_2.inv_PI_d32_0.VIN.t57 VSS.t370 VSS.t369 sg13_lv_nmos ad=55.5f pd=0.74u as=0.1005p ps=1.34u w=0.15u l=0.13u
X1040 VDD.t472 a_6156_2338# 6ph_rosc_0.psdiff_2.buff_d8$1_1.VIN.t31 VDD.t470 sg13_lv_pmos ad=55.5f pd=0.74u as=55.5f ps=0.74u w=0.15u l=0.13u
X1041 VSS.t145 6to4_0.buff_PI_d32_3.buff_PI_d16$1_0.inv_PI_d4$1_0.VIN 6to4_0.buff_PI_d32_3.buff_PI_d16$1_0.inv_PI_d4$1_0.VOUT.t0 VSS.t144 sg13_lv_nmos ad=0.1005p pd=1.34u as=55.5f ps=0.74u w=0.15u l=0.13u
X1042 VDD.t192 6to4_0.buff_PI_d32_1.buff_PI_d16$1_0.inv_PI_d4$1_0.VOUT.t18 6to4_0.buff_PI_d32_1.buff_PI_d16$1_0.inv_PI_d8$1_0.VOUT.t19 VDD.t173 sg13_lv_pmos ad=55.5f pd=0.74u as=0.1005p ps=1.34u w=0.15u l=0.13u
X1043 VSS.t1666 6ph_rosc_0.PH5.t13 6ph_rosc_0.PH2.t8 VSS.t1665 sg13_lv_nmos ad=0.1005p pd=1.34u as=55.5f ps=0.74u w=0.15u l=0.13u
X1044 6to4_0.buff_PI_d32_3.buff_PI_d16$1_0.inv_PI_d8$1_0.VOUT.t20 6to4_0.buff_PI_d32_3.buff_PI_d16$1_0.inv_PI_d4$1_0.VOUT.t14 VDD.t1035 VDD.t679 sg13_lv_pmos ad=55.5f pd=0.74u as=0.1005p ps=1.34u w=0.15u l=0.13u
X1045 VSS.t1721 6ph_rosc_0.psdiff_2.CLKP.t9 6ph_rosc_0.buff_d8$1_0.inv_d2$1_0.VIN VSS.t1720 sg13_lv_nmos ad=0.1005p pd=1.34u as=0.1005p ps=1.34u w=0.15u l=0.13u
X1046 6ph_rosc_0.PH5.t8 6ph_rosc_0.PH2.t14 VSS.t1680 VSS.t1679 sg13_lv_nmos ad=55.5f pd=0.74u as=0.1005p ps=1.34u w=0.15u l=0.13u
X1047 6ph_rosc_0.psdiff_2.buff_d8$1_0.VIN.t26 6ph_rosc_0.psdiff_2.CLKN VSS.t722 VSS.t717 sg13_lv_nmos ad=55.5f pd=0.74u as=55.5f ps=0.74u w=0.15u l=0.13u
X1048 6to4_0.buff_PI_d32_0.inv_PI_d32_0.VIN 6to4_0.buff_PI_d32_0.inv_PI_d16$1_0.VIN.t51 VDD.t930 VDD.t5 sg13_lv_pmos ad=55.5f pd=0.74u as=0.1005p ps=1.34u w=0.15u l=0.13u
X1049 CTRL 6ph_rosc_0.PH4.t10 CTRL VDD.t451 sg13_lv_pmos ad=0.19p pd=1.38u as=0 ps=0 w=1u l=0.13u
X1050 PH90.t80 6to4_0.buff_PI_d32_0.inv_PI_d32_0.VIN VDD.t351 VDD.t341 sg13_lv_pmos ad=0.1005p pd=1.34u as=55.5f ps=0.74u w=0.15u l=0.13u
X1051 VDD.t1131 6ph_rosc_0.PH5.t10 6to4_0.PI_clk_1.inv_PI_d2$1_0.VOUT VDD.t1128 sg13_lv_pmos ad=0.1005p pd=1.34u as=55.5f ps=0.74u w=0.15u l=0.13u
X1052 VSS.t1624 6to4_0.buff_PI_d32_0.buff_PI_d16$1_0.inv_PI_d8$1_0.VOUT.t31 6to4_0.buff_PI_d32_0.inv_PI_d16$1_0.VIN.t21 VSS.t1623 sg13_lv_nmos ad=0.1005p pd=1.34u as=55.5f ps=0.74u w=0.15u l=0.13u
X1053 VSS.t107 6ph_rosc_0.psdiff_1.buff_d8$1_0.inv_d4$1_0.VIN 6ph_rosc_0.psdiff_1.buff_d8$1_0.inv_d8$1_0.VIN VSS.t106 sg13_lv_nmos ad=0.1005p pd=1.34u as=55.5f ps=0.74u w=0.15u l=0.13u
X1054 VDD.t1273 6to4_0.buff_PI_d32_1.inv_PI_d16$1_0.VIN 6to4_0.buff_PI_d32_1.inv_PI_d32_0.VIN VDD.t173 sg13_lv_pmos ad=55.5f pd=0.74u as=0.1005p ps=1.34u w=0.15u l=0.13u
X1055 6to4_0.buff_PI_d32_2.buff_PI_d16$1_0.inv_PI_d8$1_0.VOUT.t12 6to4_0.buff_PI_d32_2.buff_PI_d16$1_0.inv_PI_d4$1_0.VOUT.t18 VDD.t1058 VDD.t198 sg13_lv_pmos ad=55.5f pd=0.74u as=55.5f ps=0.74u w=0.15u l=0.13u
X1056 VDD.t236 6to4_0.buff_PI_d32_2.inv_PI_d32_0.VIN.t59 PH270.t37 VDD.t215 sg13_lv_pmos ad=0.1005p pd=1.34u as=55.5f ps=0.74u w=0.15u l=0.13u
X1057 CTRL 6ph_rosc_0.PH0.t10 CTRL VDD.t51 sg13_lv_pmos ad=0.19p pd=1.38u as=0 ps=0 w=1u l=0.13u
X1058 a_10947_2194# CTRL 6ph_rosc_0.psdiff_0.buff_d8$1_1.VIN.t11 VSS.t497 sg13_lv_nmos ad=55.5f pd=0.74u as=0.1005p ps=1.34u w=0.15u l=0.13u
X1059 6ph_rosc_0.psdiff_2.buff_d8$1_0.VIN.t15 6ph_rosc_0.psdiff_2.CLKN VSS.t696 VSS.t715 sg13_lv_nmos ad=55.5f pd=0.74u as=55.5f ps=0.74u w=0.15u l=0.13u
X1060 VDD.t1328 VSS.t1965 6ph_rosc_0.psdiff_0.buff_d8$1_0.VIN.t8 VDD.t503 sg13_lv_pmos ad=55.5f pd=0.74u as=55.5f ps=0.74u w=0.15u l=0.13u
X1061 CTRL 6ph_rosc_0.PH4.t10 CTRL VDD.t451 sg13_lv_pmos ad=0.34p pd=2.68u as=0 ps=0 w=1u l=0.13u
X1062 6to4_0.buff_PI_d32_2.inv_PI_d16$1_0.VIN.t22 6to4_0.buff_PI_d32_2.buff_PI_d16$1_0.inv_PI_d8$1_0.VOUT.t34 VDD.t807 VDD.t198 sg13_lv_pmos ad=55.5f pd=0.74u as=55.5f ps=0.74u w=0.15u l=0.13u
X1063 VSS.t185 6to4_0.buff_PI_d32_2.buff_PI_d16$1_0.inv_PI_d4$1_0.VIN 6to4_0.buff_PI_d32_2.buff_PI_d16$1_0.inv_PI_d4$1_0.VOUT.t0 VSS.t184 sg13_lv_nmos ad=0.1005p pd=1.34u as=55.5f ps=0.74u w=0.15u l=0.13u
X1064 6to4_0.buff_PI_d32_3.inv_PI_d32_0.VIN 6to4_0.buff_PI_d32_3.inv_PI_d16$1_0.VIN.t59 VDD.t898 VDD.t99 sg13_lv_pmos ad=55.5f pd=0.74u as=0.1005p ps=1.34u w=0.15u l=0.13u
X1065 VSS.t1432 6to4_0.buff_PI_d32_0.inv_PI_d16$1_0.VIN.t62 6to4_0.buff_PI_d32_0.inv_PI_d32_0.VIN VSS.t1431 sg13_lv_nmos ad=0.1005p pd=1.34u as=55.5f ps=0.74u w=0.15u l=0.13u
X1066 VDD.t1025 6to4_0.buff_PI_d32_3.buff_PI_d16$1_0.inv_PI_d4$1_0.VOUT.t19 6to4_0.buff_PI_d32_3.buff_PI_d16$1_0.inv_PI_d8$1_0.VOUT.t19 VDD.t679 sg13_lv_pmos ad=55.5f pd=0.74u as=0.1005p ps=1.34u w=0.15u l=0.13u
X1067 CTRL 6ph_rosc_0.PH0.t10 CTRL VDD.t51 sg13_lv_pmos ad=0.19p pd=1.38u as=0 ps=0 w=1u l=0.13u
X1068 6ph_rosc_0.psdiff_2.buff_d8$1_0.VIN.t25 6ph_rosc_0.psdiff_2.CLKN VSS.t706 VSS.t700 sg13_lv_nmos ad=55.5f pd=0.74u as=55.5f ps=0.74u w=0.15u l=0.13u
X1069 6to4_0.buff_PI_d32_3.buff_PI_d16$1_0.inv_PI_d8$1_0.VOUT.t2 6to4_0.buff_PI_d32_3.buff_PI_d16$1_0.inv_PI_d4$1_0.VOUT.t18 VSS.t1512 VSS.t1511 sg13_lv_nmos ad=55.5f pd=0.74u as=0.1005p ps=1.34u w=0.15u l=0.13u
X1070 PH270.t77 6to4_0.buff_PI_d32_2.inv_PI_d32_0.VIN.t78 VDD.t291 VDD.t126 sg13_lv_pmos ad=0.1005p pd=1.34u as=55.5f ps=0.74u w=0.15u l=0.13u
X1071 6ph_rosc_0.psdiff_2.buff_d8$1_1.VIN.t23 VSS.t1966 VDD.t1345 VDD.t470 sg13_lv_pmos ad=55.5f pd=0.74u as=55.5f ps=0.74u w=0.15u l=0.13u
X1072 VDD.t565 6to4_0.buff_PI_d32_1.inv_PI_d32_0.VIN PH0.t63 VDD.t552 sg13_lv_pmos ad=55.5f pd=0.74u as=55.5f ps=0.74u w=0.15u l=0.13u
X1073 VDD.t508 a_12104_2338# 6ph_rosc_0.psdiff_0.buff_d8$1_1.VIN.t12 VDD.t503 sg13_lv_pmos ad=55.5f pd=0.74u as=55.5f ps=0.74u w=0.15u l=0.13u
X1074 VSS.t921 6to4_0.buff_PI_d32_1.inv_PI_d32_0.VIN PH0.t21 VSS.t920 sg13_lv_nmos ad=0.1005p pd=1.34u as=55.5f ps=0.74u w=0.15u l=0.13u
X1075 VSS.t602 6to4_0.buff_PI_d32_0.inv_PI_d32_0.VIN PH90.t10 VSS.t601 sg13_lv_nmos ad=0.1005p pd=1.34u as=55.5f ps=0.74u w=0.15u l=0.13u
X1076 VSS.t1761 6to4_0.buff_PI_d32_1.buff_PI_d16$1_0.inv_PI_d8$1_0.VOUT.t25 6to4_0.buff_PI_d32_1.inv_PI_d16$1_0.VIN VSS.t1760 sg13_lv_nmos ad=0.1005p pd=1.34u as=55.5f ps=0.74u w=0.15u l=0.13u
X1077 6ph_rosc_0.psdiff_2.VOUTDN 6ph_rosc_0.psdiff_2.buff_d8$1_1.inv_d8$1_0.VIN VDD.t531 VDD.t0 sg13_lv_pmos ad=55.5f pd=0.74u as=0.1005p ps=1.34u w=0.15u l=0.13u
X1078 VDD.t813 6to4_0.buff_PI_d32_2.buff_PI_d16$1_0.inv_PI_d8$1_0.VOUT.t36 6to4_0.buff_PI_d32_2.inv_PI_d16$1_0.VIN.t18 VDD.t126 sg13_lv_pmos ad=55.5f pd=0.74u as=55.5f ps=0.74u w=0.15u l=0.13u
X1079 6ph_rosc_0.psdiff_1.buff_d8$1_0.VIN.t4 6ph_rosc_0.psdiff_2.VOUTDP VSS.t232 VSS.t234 sg13_lv_nmos ad=55.5f pd=0.74u as=55.5f ps=0.74u w=0.15u l=0.13u
X1080 VSS.t1288 6ph_rosc_0.psdiff_0.buff_d8$1_0.VIN.t32 6ph_rosc_0.psdiff_0.buff_d8$1_0.inv_d2$1_0.VIN VSS.t1287 sg13_lv_nmos ad=0.1005p pd=1.34u as=0.1005p ps=1.34u w=0.15u l=0.13u
X1081 6ph_rosc_0.buff_d8$1_2.inv_d8$1_0.VIN 6ph_rosc_0.buff_d8$1_2.inv_d4$1_0.VIN VDD.t83 VDD.t82 sg13_lv_pmos ad=55.5f pd=0.74u as=0.1005p ps=1.34u w=0.15u l=0.13u
X1082 VSS.t342 6to4_0.buff_PI_d32_2.inv_PI_d32_0.VIN.t50 PH270.t4 VSS.t341 sg13_lv_nmos ad=0.1005p pd=1.34u as=55.5f ps=0.74u w=0.15u l=0.13u
X1083 PH0.t82 6to4_0.buff_PI_d32_1.inv_PI_d32_0.VIN VDD.t551 VDD.t173 sg13_lv_pmos ad=0.1005p pd=1.34u as=55.5f ps=0.74u w=0.15u l=0.13u
X1084 CTRL 6ph_rosc_0.PH2.t10 CTRL VDD.t80 sg13_lv_pmos ad=0.34p pd=2.68u as=0 ps=0 w=1u l=0.13u
X1085 6ph_rosc_0.PH2.t9 6ph_rosc_0.PH5.t14 VDD.t1137 VDD.t1135 sg13_lv_pmos ad=55.5f pd=0.74u as=0.1005p ps=1.34u w=0.15u l=0.13u
X1086 PH90.t9 6to4_0.buff_PI_d32_0.inv_PI_d32_0.VIN VSS.t600 VSS.t599 sg13_lv_nmos ad=55.5f pd=0.74u as=0.1005p ps=1.34u w=0.15u l=0.13u
X1087 6ph_rosc_0.psdiff_2.buff_d8$1_1.VIN.t17 VSS.t1966 VDD.t1346 VDD.t470 sg13_lv_pmos ad=55.5f pd=0.74u as=55.5f ps=0.74u w=0.15u l=0.13u
X1088 6to4_0.buff_PI_d32_0.inv_PI_d32_0.VIN 6to4_0.buff_PI_d32_0.inv_PI_d16$1_0.VIN.t58 VDD.t951 VDD.t341 sg13_lv_pmos ad=55.5f pd=0.74u as=55.5f ps=0.74u w=0.15u l=0.13u
X1089 6to4_0.buff_PI_d32_1.inv_PI_d32_0.VIN 6to4_0.buff_PI_d32_1.inv_PI_d16$1_0.VIN VDD.t1283 VDD.t173 sg13_lv_pmos ad=55.5f pd=0.74u as=0.1005p ps=1.34u w=0.15u l=0.13u
X1090 VDD.t1178 6to4_0.buff_PI_d32_1.buff_PI_d16$1_0.inv_PI_d8$1_0.VOUT.t32 6to4_0.buff_PI_d32_1.inv_PI_d16$1_0.VIN VDD.t17 sg13_lv_pmos ad=0.1005p pd=1.34u as=55.5f ps=0.74u w=0.15u l=0.13u
X1091 VSS.t1759 6to4_0.buff_PI_d32_1.buff_PI_d16$1_0.inv_PI_d8$1_0.VOUT.t26 6to4_0.buff_PI_d32_1.inv_PI_d16$1_0.VIN VSS.t1758 sg13_lv_nmos ad=0.1005p pd=1.34u as=55.5f ps=0.74u w=0.15u l=0.13u
X1092 6ph_rosc_0.psdiff_0.buff_d8$1_1.VIN.t30 6ph_rosc_0.psdiff_1.VOUTDN VSS.t1931 VSS.t1928 sg13_lv_nmos ad=55.5f pd=0.74u as=55.5f ps=0.74u w=0.15u l=0.13u
X1093 6to4_0.buff_PI_d32_2.buff_PI_d16$1_0.inv_PI_d8$1_0.VOUT.t8 6to4_0.buff_PI_d32_2.buff_PI_d16$1_0.inv_PI_d4$1_0.VOUT.t19 VDD.t1063 VDD.t198 sg13_lv_pmos ad=55.5f pd=0.74u as=0.1005p ps=1.34u w=0.15u l=0.13u
X1094 PH90.t64 6to4_0.buff_PI_d32_0.inv_PI_d32_0.VIN VDD.t399 VDD.t343 sg13_lv_pmos ad=55.5f pd=0.74u as=0.1005p ps=1.34u w=0.15u l=0.13u
X1095 6ph_rosc_0.psdiff_0.buff_d8$1_0.VIN.t16 a_10947_2194# VDD.t521 VDD.t503 sg13_lv_pmos ad=55.5f pd=0.74u as=0.1005p ps=1.34u w=0.15u l=0.13u
X1096 CTRL 6ph_rosc_0.PH2.t10 CTRL VDD.t89 sg13_lv_pmos ad=0.19p pd=1.38u as=0 ps=0 w=1u l=0.13u
X1097 VDD.t803 6to4_0.buff_PI_d32_2.buff_PI_d16$1_0.inv_PI_d8$1_0.VOUT.t33 6to4_0.buff_PI_d32_2.inv_PI_d16$1_0.VIN.t41 VDD.t198 sg13_lv_pmos ad=55.5f pd=0.74u as=55.5f ps=0.74u w=0.15u l=0.13u
X1098 VDD.t1250 6ph_rosc_0.PH3.t12 6to4_0.inv_PI_d2$1_3.VOUT VDD.t99 sg13_lv_pmos ad=55.5f pd=0.74u as=0.1005p ps=1.34u w=0.15u l=0.13u
X1099 VDD.t12 6to4_0.flywheel_clk_0.PH0 6to4_0.buff_PI_d32_0.buff_PI_d16$1_0.inv_PI_d4$1_0.VIN VDD.t5 sg13_lv_pmos ad=55.5f pd=0.74u as=55.5f ps=0.74u w=0.15u l=0.13u
X1100 VDD.t273 6to4_0.buff_PI_d32_2.inv_PI_d32_0.VIN.t72 PH270.t76 VDD.t202 sg13_lv_pmos ad=0.1005p pd=1.34u as=55.5f ps=0.74u w=0.15u l=0.13u
X1101 6to4_0.buff_PI_d32_0.inv_PI_d32_0.VIN 6to4_0.buff_PI_d32_0.inv_PI_d16$1_0.VIN.t61 VSS.t1428 VSS.t1427 sg13_lv_nmos ad=55.5f pd=0.74u as=0.1005p ps=1.34u w=0.15u l=0.13u
X1102 VSS.t1452 6to4_0.buff_PI_d32_2.inv_PI_d16$1_0.VIN.t51 6to4_0.buff_PI_d32_2.inv_PI_d32_0.VIN.t9 VSS.t1451 sg13_lv_nmos ad=0.1005p pd=1.34u as=55.5f ps=0.74u w=0.15u l=0.13u
X1103 6ph_rosc_0.psdiff_0.buff_d8$1_1.inv_d4$1_0.VIN 6ph_rosc_0.psdiff_0.buff_d8$1_1.inv_d2$1_0.VIN VDD.t171 VDD.t0 sg13_lv_pmos ad=55.5f pd=0.74u as=0.1005p ps=1.34u w=0.15u l=0.13u
X1104 VSS.t919 6to4_0.buff_PI_d32_1.inv_PI_d32_0.VIN PH0.t2 VSS.t918 sg13_lv_nmos ad=0.1005p pd=1.34u as=55.5f ps=0.74u w=0.15u l=0.13u
X1105 VDD.t550 6to4_0.buff_PI_d32_1.inv_PI_d32_0.VIN PH0.t81 VDD.t17 sg13_lv_pmos ad=55.5f pd=0.74u as=0.1005p ps=1.34u w=0.15u l=0.13u
X1106 6ph_rosc_0.psdiff_1.buff_d8$1_1.VIN.t2 VSS.t1967 VDD.t1399 VDD.t301 sg13_lv_pmos ad=55.5f pd=0.74u as=55.5f ps=0.74u w=0.15u l=0.13u
X1107 VDD.t1282 6to4_0.buff_PI_d32_1.inv_PI_d16$1_0.VIN 6to4_0.buff_PI_d32_1.inv_PI_d32_0.VIN VDD.t173 sg13_lv_pmos ad=0.1005p pd=1.34u as=55.5f ps=0.74u w=0.15u l=0.13u
X1108 VSS.t382 6to4_0.buff_PI_d32_2.inv_PI_d32_0.VIN.t60 PH270.t7 VSS.t381 sg13_lv_nmos ad=0.1005p pd=1.34u as=55.5f ps=0.74u w=0.15u l=0.13u
X1109 VSS.t1791 6to4_0.buff_PI_d32_3.buff_PI_d16$1_0.inv_PI_d8$1_0.VOUT.t24 6to4_0.buff_PI_d32_3.inv_PI_d16$1_0.VIN.t0 VSS.t1790 sg13_lv_nmos ad=0.1005p pd=1.34u as=55.5f ps=0.74u w=0.15u l=0.13u
X1110 6to4_0.buff_PI_d32_2.inv_PI_d16$1_0.VIN.t28 6to4_0.buff_PI_d32_2.buff_PI_d16$1_0.inv_PI_d8$1_0.VOUT.t35 VDD.t810 VDD.t126 sg13_lv_pmos ad=55.5f pd=0.74u as=55.5f ps=0.74u w=0.15u l=0.13u
X1111 VDD.t1209 6to4_0.buff_PI_d32_3.buff_PI_d16$1_0.inv_PI_d8$1_0.VOUT.t27 6to4_0.buff_PI_d32_3.inv_PI_d16$1_0.VIN.t11 VDD.t679 sg13_lv_pmos ad=0.1005p pd=1.34u as=55.5f ps=0.74u w=0.15u l=0.13u
X1112 6to4_0.inv_PI_d2$1_1.VIN 6ph_rosc_0.PH0.t14 VDD.t830 VDD.t17 sg13_lv_pmos ad=0.1005p pd=1.34u as=55.5f ps=0.74u w=0.15u l=0.13u
X1113 6ph_rosc_0.psdiff_1.buff_d8$1_0.VIN.t24 VSS.t1967 VDD.t1383 VDD.t301 sg13_lv_pmos ad=55.5f pd=0.74u as=55.5f ps=0.74u w=0.15u l=0.13u
X1114 6ph_rosc_0.buff_d8$1_4.inv_d8$1_0.VIN 6ph_rosc_0.buff_d8$1_4.inv_d4$1_0.VIN VDD.t459 VDD.t75 sg13_lv_pmos ad=55.5f pd=0.74u as=0.1005p ps=1.34u w=0.15u l=0.13u
X1115 6ph_rosc_0.PH3.t4 6ph_rosc_0.buff_d8$1_4.inv_d8$1_0.VIN VSS.t757 VSS.t756 sg13_lv_nmos ad=55.5f pd=0.74u as=0.1005p ps=1.34u w=0.15u l=0.13u
X1116 PH90.t28 6to4_0.buff_PI_d32_0.inv_PI_d32_0.VIN VSS.t598 VSS.t597 sg13_lv_nmos ad=55.5f pd=0.74u as=0.1005p ps=1.34u w=0.15u l=0.13u
X1117 6to4_0.buff_PI_d32_1.inv_PI_d16$1_0.VIN 6to4_0.buff_PI_d32_1.buff_PI_d16$1_0.inv_PI_d8$1_0.VOUT.t38 VDD.t1177 VDD.t17 sg13_lv_pmos ad=0.1005p pd=1.34u as=55.5f ps=0.74u w=0.15u l=0.13u
X1118 PH270.t60 6to4_0.buff_PI_d32_2.inv_PI_d32_0.VIN.t51 VDD.t210 VDD.t126 sg13_lv_pmos ad=55.5f pd=0.74u as=55.5f ps=0.74u w=0.15u l=0.13u
X1119 VSS.t807 6ph_rosc_0.psdiff_2.buff_d8$1_1.inv_d8$1_0.VIN 6ph_rosc_0.psdiff_2.VOUTDN VSS.t806 sg13_lv_nmos ad=0.1005p pd=1.34u as=55.5f ps=0.74u w=0.15u l=0.13u
X1120 6ph_rosc_0.PH0.t8 6ph_rosc_0.PH3.t14 VSS.t1863 VSS.t1862 sg13_lv_nmos ad=55.5f pd=0.74u as=0.1005p ps=1.34u w=0.15u l=0.13u
X1121 6to4_0.buff_PI_d32_0.buff_PI_d16$1_0.inv_PI_d4$1_0.VIN 6to4_0.flywheel_clk_0.PH0 VDD.t6 VDD.t5 sg13_lv_pmos ad=55.5f pd=0.74u as=55.5f ps=0.74u w=0.15u l=0.13u
X1122 VDD.t1220 6to4_0.buff_PI_d32_3.buff_PI_d16$1_0.inv_PI_d8$1_0.VOUT.t31 6to4_0.buff_PI_d32_3.inv_PI_d16$1_0.VIN.t23 VDD.t99 sg13_lv_pmos ad=55.5f pd=0.74u as=0.1005p ps=1.34u w=0.15u l=0.13u
X1123 6ph_rosc_0.buff_d8$1_1.inv_d8$1_0.VIN 6ph_rosc_0.buff_d8$1_1.inv_d4$1_0.VIN VDD.t315 VDD.t75 sg13_lv_pmos ad=55.5f pd=0.74u as=0.1005p ps=1.34u w=0.15u l=0.13u
X1124 6ph_rosc_0.psdiff_1.buff_d8$1_1.VIN.t16 a_9130_2338# VDD.t537 VDD.t301 sg13_lv_pmos ad=55.5f pd=0.74u as=55.5f ps=0.74u w=0.15u l=0.13u
X1125 6ph_rosc_0.psdiff_1.buff_d8$1_0.VIN.t23 VSS.t1967 VDD.t1384 VDD.t301 sg13_lv_pmos ad=55.5f pd=0.74u as=55.5f ps=0.74u w=0.15u l=0.13u
X1126 6to4_0.buff_PI_d32_2.inv_PI_d32_0.VIN.t12 6to4_0.buff_PI_d32_2.inv_PI_d16$1_0.VIN.t52 VSS.t1456 VSS.t1455 sg13_lv_nmos ad=55.5f pd=0.74u as=0.1005p ps=1.34u w=0.15u l=0.13u
X1127 6to4_0.buff_PI_d32_2.buff_PI_d16$1_0.inv_PI_d4$1_0.VIN 6to4_0.buff_PI_d32_2.VIN VSS.t999 VSS.t998 sg13_lv_nmos ad=55.5f pd=0.74u as=0.1005p ps=1.34u w=0.15u l=0.13u
X1128 VSS.t719 6ph_rosc_0.psdiff_2.CLKN 6ph_rosc_0.psdiff_2.buff_d8$1_0.VIN.t18 VSS.t712 sg13_lv_nmos ad=0.1005p pd=1.34u as=55.5f ps=0.74u w=0.15u l=0.13u
X1129 VSS.t1951 6ph_rosc_0.psdiff_1.VOUTDN 6ph_rosc_0.psdiff_0.buff_d8$1_1.VIN.t29 VSS.t1936 sg13_lv_nmos ad=55.5f pd=0.74u as=55.5f ps=0.74u w=0.15u l=0.13u
X1130 6ph_rosc_0.PH3.t8 6ph_rosc_0.buff_d8$1_4.inv_d8$1_0.VIN VDD.t485 VDD.t75 sg13_lv_pmos ad=55.5f pd=0.74u as=0.1005p ps=1.34u w=0.15u l=0.13u
X1131 CTRL 6ph_rosc_0.PH1.t10 CTRL VDD.t82 sg13_lv_pmos ad=0.19p pd=1.38u as=0 ps=0 w=1u l=0.13u
X1132 VDD.t735 6to4_0.buff_PI_d32_3.inv_PI_d32_0.VIN PH180.t59 VDD.t99 sg13_lv_pmos ad=0.1005p pd=1.34u as=55.5f ps=0.74u w=0.15u l=0.13u
X1133 6to4_0.buff_PI_d32_0.inv_PI_d32_0.VIN 6to4_0.buff_PI_d32_0.inv_PI_d16$1_0.VIN.t63 VSS.t1436 VSS.t1435 sg13_lv_nmos ad=55.5f pd=0.74u as=0.1005p ps=1.34u w=0.15u l=0.13u
X1134 VDD.t776 6to4_0.buff_PI_d32_2.buff_PI_d16$1_0.inv_PI_d8$1_0.VOUT.t24 6to4_0.buff_PI_d32_2.inv_PI_d16$1_0.VIN.t40 VDD.t198 sg13_lv_pmos ad=55.5f pd=0.74u as=0.1005p ps=1.34u w=0.15u l=0.13u
X1135 6ph_rosc_0.psdiff_0.buff_d8$1_1.VIN.t2 VSS.t1965 VDD.t1303 VDD.t503 sg13_lv_pmos ad=55.5f pd=0.74u as=55.5f ps=0.74u w=0.15u l=0.13u
X1136 VSS.t1835 6to4_0.buff_PI_d32_3.buff_PI_d16$1_0.inv_PI_d8$1_0.VOUT.t35 6to4_0.buff_PI_d32_3.inv_PI_d16$1_0.VIN.t33 VSS.t1834 sg13_lv_nmos ad=0.1005p pd=1.34u as=55.5f ps=0.74u w=0.15u l=0.13u
X1137 6ph_rosc_0.psdiff_1.buff_d8$1_1.VIN.t14 a_9130_2338# VDD.t536 VDD.t301 sg13_lv_pmos ad=55.5f pd=0.74u as=55.5f ps=0.74u w=0.15u l=0.13u
X1138 PH270.t41 6to4_0.buff_PI_d32_2.inv_PI_d32_0.VIN.t75 VDD.t283 VDD.t215 sg13_lv_pmos ad=55.5f pd=0.74u as=55.5f ps=0.74u w=0.15u l=0.13u
X1139 6ph_rosc_0.psdiff_2.VOUTDN 6ph_rosc_0.psdiff_2.buff_d8$1_1.inv_d8$1_0.VIN VSS.t805 VSS.t804 sg13_lv_nmos ad=55.5f pd=0.74u as=0.1005p ps=1.34u w=0.15u l=0.13u
X1140 6to4_0.buff_PI_d32_1.buff_PI_d16$1_0.inv_PI_d4$1_0.VOUT.t0 6to4_0.buff_PI_d32_1.buff_PI_d16$1_0.inv_PI_d4$1_0.VIN VSS.t33 VSS.t32 sg13_lv_nmos ad=55.5f pd=0.74u as=0.1005p ps=1.34u w=0.15u l=0.13u
X1141 6to4_0.buff_PI_d32_2.inv_PI_d32_0.VIN.t0 6to4_0.buff_PI_d32_2.inv_PI_d16$1_0.VIN.t48 VSS.t1440 VSS.t1439 sg13_lv_nmos ad=55.5f pd=0.74u as=0.1005p ps=1.34u w=0.15u l=0.13u
X1142 VDD.t828 6ph_rosc_0.PH0.t12 6to4_0.inv_PI_d2$1_1.VIN VDD.t17 sg13_lv_pmos ad=0.1005p pd=1.34u as=55.5f ps=0.74u w=0.15u l=0.13u
X1143 VSS.t1139 6ph_rosc_0.psdiff_2.VOUTDN 6ph_rosc_0.psdiff_1.buff_d8$1_1.VIN.t17 VSS.t494 sg13_lv_nmos ad=55.5f pd=0.74u as=55.5f ps=0.74u w=0.15u l=0.13u
X1144 6ph_rosc_0.psdiff_0.buff_d8$1_1.VIN.t3 VSS.t1965 VDD.t1315 VDD.t503 sg13_lv_pmos ad=55.5f pd=0.74u as=55.5f ps=0.74u w=0.15u l=0.13u
X1145 CTRL 6ph_rosc_0.PH1.t10 CTRL VDD.t82 sg13_lv_pmos ad=0.19p pd=1.38u as=0 ps=0 w=1u l=0.13u
X1146 VDD.t1097 6to4_0.buff_PI_d32_0.buff_PI_d16$1_0.inv_PI_d8$1_0.VOUT.t29 6to4_0.buff_PI_d32_0.inv_PI_d16$1_0.VIN.t16 VDD.t341 sg13_lv_pmos ad=0.1005p pd=1.34u as=55.5f ps=0.74u w=0.15u l=0.13u
X1147 CTRL 6ph_rosc_0.PH3.t11 CTRL VDD.t330 sg13_lv_pmos ad=0.19p pd=1.38u as=0 ps=0 w=1u l=0.13u
X1148 VDD.t1166 6to4_0.buff_PI_d32_1.buff_PI_d16$1_0.inv_PI_d8$1_0.VOUT.t28 6to4_0.buff_PI_d32_1.inv_PI_d16$1_0.VIN VDD.t173 sg13_lv_pmos ad=55.5f pd=0.74u as=55.5f ps=0.74u w=0.15u l=0.13u
X1149 VDD.t160 6ph_rosc_0.psdiff_1.buff_d8$1_1.inv_d8$1_0.VIN 6ph_rosc_0.psdiff_1.VOUTDN VDD.t0 sg13_lv_pmos ad=0.1005p pd=1.34u as=55.5f ps=0.74u w=0.15u l=0.13u
X1150 VSS.t1141 6ph_rosc_0.psdiff_2.VOUTDN 6ph_rosc_0.psdiff_1.buff_d8$1_1.VIN.t25 VSS.t1159 sg13_lv_nmos ad=55.5f pd=0.74u as=55.5f ps=0.74u w=0.15u l=0.13u
X1151 CTRL 6ph_rosc_0.PH2.t10 CTRL VDD.t80 sg13_lv_pmos ad=0.34p pd=2.68u as=0 ps=0 w=1u l=0.13u
X1152 VDD.t515 6ph_rosc_0.psdiff_1.buff_d8$1_1.inv_d2$1_0.VIN 6ph_rosc_0.psdiff_1.buff_d8$1_1.inv_d4$1_0.VIN VDD.t0 sg13_lv_pmos ad=0.1005p pd=1.34u as=55.5f ps=0.74u w=0.15u l=0.13u
X1153 VDD.t268 6to4_0.buff_PI_d32_2.inv_PI_d32_0.VIN.t70 PH270.t34 VDD.t126 sg13_lv_pmos ad=55.5f pd=0.74u as=55.5f ps=0.74u w=0.15u l=0.13u
X1154 VSS.t755 6ph_rosc_0.buff_d8$1_4.inv_d8$1_0.VIN 6ph_rosc_0.PH3.t5 VSS.t754 sg13_lv_nmos ad=0.1005p pd=1.34u as=55.5f ps=0.74u w=0.15u l=0.13u
X1155 6to4_0.buff_PI_d32_2.buff_PI_d16$1_0.inv_PI_d8$1_0.VOUT.t21 6to4_0.buff_PI_d32_2.buff_PI_d16$1_0.inv_PI_d4$1_0.VOUT.t19 VDD.t1061 VDD.t198 sg13_lv_pmos ad=0.1005p pd=1.34u as=55.5f ps=0.74u w=0.15u l=0.13u
X1156 VDD.t1366 VSS.t1966 6ph_rosc_0.psdiff_2.buff_d8$1_1.VIN.t18 VDD.t470 sg13_lv_pmos ad=0.1005p pd=1.34u as=55.5f ps=0.74u w=0.15u l=0.13u
X1157 VDD.t342 6to4_0.buff_PI_d32_0.inv_PI_d32_0.VIN PH90.t79 VDD.t341 sg13_lv_pmos ad=55.5f pd=0.74u as=0.1005p ps=1.34u w=0.15u l=0.13u
X1158 VSS.t1656 6to4_0.buff_PI_d32_0.buff_PI_d16$1_0.inv_PI_d8$1_0.VOUT.t39 6to4_0.buff_PI_d32_0.inv_PI_d16$1_0.VIN.t45 VSS.t1655 sg13_lv_nmos ad=0.1005p pd=1.34u as=55.5f ps=0.74u w=0.15u l=0.13u
X1159 CTRL 6ph_rosc_0.PH3.t11 CTRL VDD.t464 sg13_lv_pmos ad=0.19p pd=1.38u as=0 ps=0 w=1u l=0.13u
X1160 VSS.t596 6to4_0.buff_PI_d32_0.inv_PI_d32_0.VIN PH90.t2 VSS.t595 sg13_lv_nmos ad=0.1005p pd=1.34u as=55.5f ps=0.74u w=0.15u l=0.13u
X1161 6to4_0.PI_clk_0.inv_PI_d2$1_0.VOUT 6ph_rosc_0.PH1.t12 VDD.t915 VDD.t5 sg13_lv_pmos ad=55.5f pd=0.74u as=0.1005p ps=1.34u w=0.15u l=0.13u
X1162 VSS.t294 6ph_rosc_0.psdiff_0.buff_d8$1_1.inv_d2$1_0.VIN 6ph_rosc_0.psdiff_0.buff_d8$1_1.inv_d4$1_0.VIN VSS.t293 sg13_lv_nmos ad=0.1005p pd=1.34u as=55.5f ps=0.74u w=0.15u l=0.13u
X1163 6to4_0.buff_PI_d32_3.buff_PI_d16$1_0.inv_PI_d4$1_0.VIN 6to4_0.inv_PI_d2$1_2.VOUT VDD.t333 VDD.t99 sg13_lv_pmos ad=0.1005p pd=1.34u as=55.5f ps=0.74u w=0.15u l=0.13u
X1164 6to4_0.buff_PI_d32_0.buff_PI_d16$1_0.inv_PI_d8$1_0.VOUT.t18 6to4_0.buff_PI_d32_0.buff_PI_d16$1_0.inv_PI_d4$1_0.VOUT.t18 VSS.t1282 VSS.t1281 sg13_lv_nmos ad=55.5f pd=0.74u as=0.1005p ps=1.34u w=0.15u l=0.13u
X1165 VDD.t607 6to4_0.buff_PI_d32_1.inv_PI_d32_0.VIN PH0.t34 VDD.t17 sg13_lv_pmos ad=0.1005p pd=1.34u as=55.5f ps=0.74u w=0.15u l=0.13u
X1166 VDD.t734 6to4_0.buff_PI_d32_3.inv_PI_d32_0.VIN PH180.t83 VDD.t677 sg13_lv_pmos ad=55.5f pd=0.74u as=0.1005p ps=1.34u w=0.15u l=0.13u
X1167 VDD.t933 6to4_0.buff_PI_d32_0.inv_PI_d16$1_0.VIN.t52 6to4_0.buff_PI_d32_0.inv_PI_d32_0.VIN VDD.t5 sg13_lv_pmos ad=55.5f pd=0.74u as=55.5f ps=0.74u w=0.15u l=0.13u
X1168 VSS.t374 6to4_0.buff_PI_d32_2.inv_PI_d32_0.VIN.t58 PH270.t0 VSS.t373 sg13_lv_nmos ad=0.1005p pd=1.34u as=55.5f ps=0.74u w=0.15u l=0.13u
X1169 VSS.t1298 6to4_0.buff_PI_d32_3.inv_PI_d16$1_0.VIN.t48 6to4_0.buff_PI_d32_3.inv_PI_d32_0.VIN VSS.t1297 sg13_lv_nmos ad=0.1005p pd=1.34u as=55.5f ps=0.74u w=0.15u l=0.13u
X1170 6to4_0.buff_PI_d32_1.inv_PI_d32_0.VIN 6to4_0.buff_PI_d32_1.inv_PI_d16$1_0.VIN VSS.t1897 VSS.t1896 sg13_lv_nmos ad=55.5f pd=0.74u as=0.1005p ps=1.34u w=0.15u l=0.13u
X1171 6ph_rosc_0.psdiff_1.buff_d8$1_1.inv_d8$1_0.VIN 6ph_rosc_0.psdiff_1.buff_d8$1_1.inv_d4$1_0.VIN VDD.t3 VDD.t0 sg13_lv_pmos ad=55.5f pd=0.74u as=0.1005p ps=1.34u w=0.15u l=0.13u
X1172 VSS.t816 6ph_rosc_0.psdiff_1.VOUTDP 6ph_rosc_0.psdiff_0.buff_d8$1_0.VIN.t31 VSS.t830 sg13_lv_nmos ad=55.5f pd=0.74u as=55.5f ps=0.74u w=0.15u l=0.13u
X1173 VDD.t504 a_10947_2194# 6ph_rosc_0.psdiff_0.buff_d8$1_0.VIN.t14 VDD.t503 sg13_lv_pmos ad=55.5f pd=0.74u as=55.5f ps=0.74u w=0.15u l=0.13u
X1174 6to4_0.buff_PI_d32_0.inv_PI_d16$1_0.VIN.t8 6to4_0.buff_PI_d32_0.buff_PI_d16$1_0.inv_PI_d8$1_0.VOUT.t26 VDD.t1087 VDD.t341 sg13_lv_pmos ad=0.1005p pd=1.34u as=55.5f ps=0.74u w=0.15u l=0.13u
X1175 VSS.t1851 6to4_0.buff_PI_d32_3.buff_PI_d16$1_0.inv_PI_d8$1_0.VOUT.t39 6to4_0.buff_PI_d32_3.inv_PI_d16$1_0.VIN.t45 VSS.t1850 sg13_lv_nmos ad=0.1005p pd=1.34u as=55.5f ps=0.74u w=0.15u l=0.13u
X1176 VSS.t1276 6to4_0.buff_PI_d32_0.buff_PI_d16$1_0.inv_PI_d4$1_0.VOUT.t17 6to4_0.buff_PI_d32_0.buff_PI_d16$1_0.inv_PI_d8$1_0.VOUT.t15 VSS.t1275 sg13_lv_nmos ad=0.1005p pd=1.34u as=55.5f ps=0.74u w=0.15u l=0.13u
X1177 6ph_rosc_0.buff_d8$1_1.inv_d8$1_0.VIN 6ph_rosc_0.buff_d8$1_1.inv_d4$1_0.VIN VSS.t470 VSS.t469 sg13_lv_nmos ad=55.5f pd=0.74u as=0.1005p ps=1.34u w=0.15u l=0.13u
X1178 6ph_rosc_0.psdiff_1.buff_d8$1_1.VIN.t30 6ph_rosc_0.psdiff_2.VOUTDN VSS.t1158 VSS.t1140 sg13_lv_nmos ad=55.5f pd=0.74u as=55.5f ps=0.74u w=0.15u l=0.13u
X1179 6ph_rosc_0.psdiff_0.buff_d8$1_1.VIN.t28 6ph_rosc_0.psdiff_1.VOUTDN VSS.t1950 VSS.t493 sg13_lv_nmos ad=55.5f pd=0.74u as=55.5f ps=0.74u w=0.15u l=0.13u
X1180 VSS.t917 6to4_0.buff_PI_d32_1.inv_PI_d32_0.VIN PH0.t1 VSS.t916 sg13_lv_nmos ad=0.1005p pd=1.34u as=55.5f ps=0.74u w=0.15u l=0.13u
X1181 VDD.t1050 6to4_0.buff_PI_d32_2.buff_PI_d16$1_0.inv_PI_d4$1_0.VOUT.t15 6to4_0.buff_PI_d32_2.buff_PI_d16$1_0.inv_PI_d8$1_0.VOUT.t20 VDD.t198 sg13_lv_pmos ad=0.1005p pd=1.34u as=55.5f ps=0.74u w=0.15u l=0.13u
X1182 6to4_0.buff_PI_d32_1.inv_PI_d32_0.VIN 6to4_0.buff_PI_d32_1.inv_PI_d16$1_0.VIN VDD.t1258 VDD.t173 sg13_lv_pmos ad=55.5f pd=0.74u as=55.5f ps=0.74u w=0.15u l=0.13u
X1183 PH0.t29 6to4_0.buff_PI_d32_1.inv_PI_d32_0.VIN VSS.t915 VSS.t914 sg13_lv_nmos ad=55.5f pd=0.74u as=0.1005p ps=1.34u w=0.15u l=0.13u
X1184 6to4_0.buff_PI_d32_1.inv_PI_d32_0.VIN 6to4_0.buff_PI_d32_1.inv_PI_d16$1_0.VIN VDD.t1254 VDD.t17 sg13_lv_pmos ad=0.1005p pd=1.34u as=55.5f ps=0.74u w=0.15u l=0.13u
X1185 VDD.t252 6to4_0.buff_PI_d32_2.inv_PI_d32_0.VIN.t65 PH270.t75 VDD.t126 sg13_lv_pmos ad=55.5f pd=0.74u as=0.1005p ps=1.34u w=0.15u l=0.13u
X1186 PH270.t28 6to4_0.buff_PI_d32_2.inv_PI_d32_0.VIN.t49 VSS.t336 VSS.t335 sg13_lv_nmos ad=55.5f pd=0.74u as=0.1005p ps=1.34u w=0.15u l=0.13u
X1187 VDD.t733 6to4_0.buff_PI_d32_3.inv_PI_d32_0.VIN PH180.t82 VDD.t673 sg13_lv_pmos ad=0.1005p pd=1.34u as=55.5f ps=0.74u w=0.15u l=0.13u
X1188 6ph_rosc_0.PH3.t3 6ph_rosc_0.buff_d8$1_4.inv_d8$1_0.VIN VSS.t753 VSS.t752 sg13_lv_nmos ad=55.5f pd=0.74u as=0.1005p ps=1.34u w=0.15u l=0.13u
X1189 PH180.t43 6to4_0.buff_PI_d32_3.inv_PI_d32_0.VIN VDD.t732 VDD.t677 sg13_lv_pmos ad=55.5f pd=0.74u as=0.1005p ps=1.34u w=0.15u l=0.13u
X1190 VSS.t1204 6to4_0.buff_PI_d32_2.buff_PI_d16$1_0.inv_PI_d8$1_0.VOUT.t30 6to4_0.buff_PI_d32_2.inv_PI_d16$1_0.VIN.t1 VSS.t1203 sg13_lv_nmos ad=0.1005p pd=1.34u as=55.5f ps=0.74u w=0.15u l=0.13u
X1191 6ph_rosc_0.psdiff_0.buff_d8$1_1.VIN.t20 6ph_rosc_0.psdiff_1.VOUTDN VSS.t1941 VSS.t1947 sg13_lv_nmos ad=55.5f pd=0.74u as=55.5f ps=0.74u w=0.15u l=0.13u
X1192 VDD.t490 6to4_0.inv_PI_d2$1_1.VIN 6to4_0.flywheel_clk_1.PH0 VDD.t17 sg13_lv_pmos ad=55.5f pd=0.74u as=55.5f ps=0.74u w=0.15u l=0.13u
X1193 6to4_0.buff_PI_d32_3.inv_PI_d16$1_0.VIN.t29 6to4_0.buff_PI_d32_3.buff_PI_d16$1_0.inv_PI_d8$1_0.VOUT.t33 VDD.t1225 VDD.t99 sg13_lv_pmos ad=0.1005p pd=1.34u as=55.5f ps=0.74u w=0.15u l=0.13u
X1194 PH90.t78 6to4_0.buff_PI_d32_0.inv_PI_d32_0.VIN VDD.t397 VDD.t347 sg13_lv_pmos ad=0.1005p pd=1.34u as=55.5f ps=0.74u w=0.15u l=0.13u
X1195 VDD.t151 6ph_rosc_0.buff_d8$1_3.inv_d8$1_0.VIN 6ph_rosc_0.PH1.t6 VDD.t75 sg13_lv_pmos ad=0.1005p pd=1.34u as=55.5f ps=0.74u w=0.15u l=0.13u
X1196 VDD.t1002 6to4_0.buff_PI_d32_2.inv_PI_d16$1_0.VIN.t59 6to4_0.buff_PI_d32_2.inv_PI_d32_0.VIN.t34 VDD.t198 sg13_lv_pmos ad=0.1005p pd=1.34u as=55.5f ps=0.74u w=0.15u l=0.13u
X1197 6ph_rosc_0.psdiff_1.buff_d8$1_1.VIN.t29 6ph_rosc_0.psdiff_2.VOUTDN VSS.t1157 VSS.t500 sg13_lv_nmos ad=55.5f pd=0.74u as=55.5f ps=0.74u w=0.15u l=0.13u
X1198 PH0.t8 6to4_0.buff_PI_d32_1.inv_PI_d32_0.VIN VSS.t913 VSS.t912 sg13_lv_nmos ad=55.5f pd=0.74u as=0.1005p ps=1.34u w=0.15u l=0.13u
X1199 VDD.t1387 VSS.t1967 6ph_rosc_0.psdiff_1.buff_d8$1_1.VIN.t5 VDD.t301 sg13_lv_pmos ad=55.5f pd=0.74u as=55.5f ps=0.74u w=0.15u l=0.13u
X1200 6to4_0.buff_PI_d32_1.buff_PI_d16$1_0.inv_PI_d8$1_0.VOUT.t5 6to4_0.buff_PI_d32_1.buff_PI_d16$1_0.inv_PI_d4$1_0.VOUT.t13 VSS.t306 VSS.t305 sg13_lv_nmos ad=55.5f pd=0.74u as=0.1005p ps=1.34u w=0.15u l=0.13u
X1201 VDD.t924 6to4_0.buff_PI_d32_0.inv_PI_d16$1_0.VIN.t49 6to4_0.buff_PI_d32_0.inv_PI_d32_0.VIN VDD.t5 sg13_lv_pmos ad=55.5f pd=0.74u as=0.1005p ps=1.34u w=0.15u l=0.13u
X1202 CTRL 6ph_rosc_0.PH1.t10 CTRL VDD.t82 sg13_lv_pmos ad=0.19p pd=1.38u as=0 ps=0 w=1u l=0.13u
X1203 VDD.t59 6to4_0.buff_PI_d32_0.buff_PI_d16$1_0.inv_PI_d4$1_0.VIN 6to4_0.buff_PI_d32_0.buff_PI_d16$1_0.inv_PI_d4$1_0.VOUT.t9 VDD.t5 sg13_lv_pmos ad=55.5f pd=0.74u as=0.1005p ps=1.34u w=0.15u l=0.13u
X1204 6ph_rosc_0.psdiff_0.buff_d8$1_0.VIN.t18 6ph_rosc_0.psdiff_1.VOUTDP VSS.t829 VSS.t815 sg13_lv_nmos ad=55.5f pd=0.74u as=55.5f ps=0.74u w=0.15u l=0.13u
X1205 6ph_rosc_0.psdiff_0.buff_d8$1_0.VIN.t7 VSS.t1965 VDD.t1325 VDD.t503 sg13_lv_pmos ad=55.5f pd=0.74u as=55.5f ps=0.74u w=0.15u l=0.13u
X1206 VSS.t594 6to4_0.buff_PI_d32_0.inv_PI_d32_0.VIN PH90.t19 VSS.t593 sg13_lv_nmos ad=0.1005p pd=1.34u as=55.5f ps=0.74u w=0.15u l=0.13u
X1207 6to4_0.inv_PI_d2$1_2.VOUT 6to4_0.inv_PI_d2$1_3.VOUT VSS.t504 VSS.t503 sg13_lv_nmos ad=55.5f pd=0.74u as=0.1005p ps=1.34u w=0.15u l=0.13u
X1208 VSS.t1330 6to4_0.buff_PI_d32_3.inv_PI_d16$1_0.VIN.t56 6to4_0.buff_PI_d32_3.inv_PI_d32_0.VIN VSS.t1329 sg13_lv_nmos ad=0.1005p pd=1.34u as=55.5f ps=0.74u w=0.15u l=0.13u
X1209 VDD.t872 6to4_0.buff_PI_d32_3.inv_PI_d16$1_0.VIN.t51 6to4_0.buff_PI_d32_3.inv_PI_d32_0.VIN VDD.t679 sg13_lv_pmos ad=55.5f pd=0.74u as=55.5f ps=0.74u w=0.15u l=0.13u
X1210 6to4_0.buff_PI_d32_1.inv_PI_d16$1_0.VIN 6to4_0.buff_PI_d32_1.buff_PI_d16$1_0.inv_PI_d8$1_0.VOUT.t36 VDD.t1175 VDD.t173 sg13_lv_pmos ad=55.5f pd=0.74u as=0.1005p ps=1.34u w=0.15u l=0.13u
X1211 6to4_0.buff_PI_d32_3.inv_PI_d32_0.VIN 6to4_0.buff_PI_d32_3.inv_PI_d16$1_0.VIN.t53 VSS.t1318 VSS.t1317 sg13_lv_nmos ad=55.5f pd=0.74u as=0.1005p ps=1.34u w=0.15u l=0.13u
X1212 6ph_rosc_0.psdiff_0.buff_d8$1_0.VIN.t19 6ph_rosc_0.psdiff_1.VOUTDP VSS.t821 VSS.t499 sg13_lv_nmos ad=55.5f pd=0.74u as=55.5f ps=0.74u w=0.15u l=0.13u
X1213 6ph_rosc_0.psdiff_0.buff_d8$1_0.VIN.t1 VSS.t1965 VDD.t1313 VDD.t503 sg13_lv_pmos ad=55.5f pd=0.74u as=55.5f ps=0.74u w=0.15u l=0.13u
X1214 CTRL 6ph_rosc_0.PH3.t11 CTRL VDD.t330 sg13_lv_pmos ad=0.19p pd=1.38u as=0 ps=0 w=1u l=0.13u
X1215 PH0.t5 6to4_0.buff_PI_d32_1.inv_PI_d32_0.VIN VSS.t911 VSS.t910 sg13_lv_nmos ad=55.5f pd=0.74u as=0.1005p ps=1.34u w=0.15u l=0.13u
X1216 VSS.t308 6to4_0.buff_PI_d32_1.buff_PI_d16$1_0.inv_PI_d4$1_0.VOUT.t14 6to4_0.buff_PI_d32_1.buff_PI_d16$1_0.inv_PI_d8$1_0.VOUT.t8 VSS.t307 sg13_lv_nmos ad=0.1005p pd=1.34u as=55.5f ps=0.74u w=0.15u l=0.13u
X1217 VSS.t803 6ph_rosc_0.psdiff_2.buff_d8$1_1.inv_d8$1_0.VIN 6ph_rosc_0.psdiff_2.VOUTDN VSS.t802 sg13_lv_nmos ad=0.1005p pd=1.34u as=55.5f ps=0.74u w=0.15u l=0.13u
X1218 CTRL 6ph_rosc_0.PH1.t10 CTRL VDD.t78 sg13_lv_pmos ad=0.19p pd=1.38u as=0 ps=0 w=1u l=0.13u
X1219 PH180.t28 6to4_0.buff_PI_d32_3.inv_PI_d32_0.VIN VSS.t1075 VSS.t1074 sg13_lv_nmos ad=55.5f pd=0.74u as=0.1005p ps=1.34u w=0.15u l=0.13u
X1220 VDD.t396 6to4_0.buff_PI_d32_0.inv_PI_d32_0.VIN PH90.t32 VDD.t341 sg13_lv_pmos ad=0.1005p pd=1.34u as=55.5f ps=0.74u w=0.15u l=0.13u
X1221 VDD.t908 6to4_0.buff_PI_d32_3.inv_PI_d16$1_0.VIN.t63 6to4_0.buff_PI_d32_3.inv_PI_d32_0.VIN VDD.t679 sg13_lv_pmos ad=55.5f pd=0.74u as=0.1005p ps=1.34u w=0.15u l=0.13u
X1222 6to4_0.buff_PI_d32_1.inv_PI_d16$1_0.VIN 6to4_0.buff_PI_d32_1.buff_PI_d16$1_0.inv_PI_d8$1_0.VOUT.t27 VDD.t1174 VDD.t17 sg13_lv_pmos ad=55.5f pd=0.74u as=55.5f ps=0.74u w=0.15u l=0.13u
X1223 VDD.t350 6to4_0.buff_PI_d32_0.inv_PI_d32_0.VIN PH90.t77 VDD.t343 sg13_lv_pmos ad=55.5f pd=0.74u as=55.5f ps=0.74u w=0.15u l=0.13u
X1224 VDD.t683 6to4_0.buff_PI_d32_3.inv_PI_d32_0.VIN PH180.t54 VDD.t673 sg13_lv_pmos ad=55.5f pd=0.74u as=55.5f ps=0.74u w=0.15u l=0.13u
X1225 6to4_0.PI_clk_0.inv_PI_d2$1_0.VOUT 6ph_rosc_0.PH1.t12 VDD.t914 VDD.t5 sg13_lv_pmos ad=0.1005p pd=1.34u as=55.5f ps=0.74u w=0.15u l=0.13u
X1226 6to4_0.buff_PI_d32_3.inv_PI_d32_0.VIN 6to4_0.buff_PI_d32_3.inv_PI_d16$1_0.VIN.t61 VSS.t1352 VSS.t1351 sg13_lv_nmos ad=55.5f pd=0.74u as=0.1005p ps=1.34u w=0.15u l=0.13u
X1227 6to4_0.buff_PI_d32_0.buff_PI_d16$1_0.inv_PI_d4$1_0.VOUT.t0 6to4_0.buff_PI_d32_0.buff_PI_d16$1_0.inv_PI_d4$1_0.VIN VSS.t93 VSS.t92 sg13_lv_nmos ad=55.5f pd=0.74u as=0.1005p ps=1.34u w=0.15u l=0.13u
X1228 6to4_0.flywheel_clk_1.PH0 6to4_0.inv_PI_d2$1_1.VIN VDD.t492 VDD.t17 sg13_lv_pmos ad=55.5f pd=0.74u as=55.5f ps=0.74u w=0.15u l=0.13u
X1229 CTRL 6ph_rosc_0.PH5.t12 CTRL VDD.t85 sg13_lv_pmos ad=0.19p pd=1.38u as=0 ps=0 w=1u l=0.13u
X1230 6to4_0.buff_PI_d32_2.inv_PI_d32_0.VIN.t16 6to4_0.buff_PI_d32_2.inv_PI_d16$1_0.VIN.t53 VDD.t984 VDD.t126 sg13_lv_pmos ad=55.5f pd=0.74u as=0.1005p ps=1.34u w=0.15u l=0.13u
X1231 CTRL 6ph_rosc_0.PH3.t11 CTRL VDD.t464 sg13_lv_pmos ad=0.19p pd=1.38u as=0 ps=0 w=1u l=0.13u
X1232 VSS.t1073 6to4_0.buff_PI_d32_3.inv_PI_d32_0.VIN PH180.t20 VSS.t1072 sg13_lv_nmos ad=0.1005p pd=1.34u as=55.5f ps=0.74u w=0.15u l=0.13u
X1233 PH270.t74 6to4_0.buff_PI_d32_2.inv_PI_d32_0.VIN.t79 VDD.t294 VDD.t198 sg13_lv_pmos ad=0.1005p pd=1.34u as=55.5f ps=0.74u w=0.15u l=0.13u
X1234 PH180.t6 6to4_0.buff_PI_d32_3.inv_PI_d32_0.VIN VSS.t1071 VSS.t1070 sg13_lv_nmos ad=55.5f pd=0.74u as=0.1005p ps=1.34u w=0.15u l=0.13u
X1235 PH0.t39 6to4_0.buff_PI_d32_1.inv_PI_d32_0.VIN VDD.t606 VDD.t17 sg13_lv_pmos ad=55.5f pd=0.74u as=55.5f ps=0.74u w=0.15u l=0.13u
X1236 a_6156_2338# CTRL 6ph_rosc_0.psdiff_2.buff_d8$1_0.VIN.t11 VSS.t496 sg13_lv_nmos ad=55.5f pd=0.74u as=0.1005p ps=1.34u w=0.15u l=0.13u
X1237 VSS.t3 6ph_rosc_0.psdiff_1.buff_d8$1_1.inv_d4$1_0.VIN 6ph_rosc_0.psdiff_1.buff_d8$1_1.inv_d8$1_0.VIN VSS.t2 sg13_lv_nmos ad=0.1005p pd=1.34u as=55.5f ps=0.74u w=0.15u l=0.13u
X1238 VDD.t143 6ph_rosc_0.psdiff_2.buff_d8$1_0.inv_d8$1_0.VIN 6ph_rosc_0.psdiff_2.VOUTDP VDD.t34 sg13_lv_pmos ad=0.1005p pd=1.34u as=55.5f ps=0.74u w=0.15u l=0.13u
X1239 6to4_0.buff_PI_d32_2.inv_PI_d16$1_0.VIN.t12 6to4_0.buff_PI_d32_2.buff_PI_d16$1_0.inv_PI_d8$1_0.VOUT.t28 VSS.t1196 VSS.t1195 sg13_lv_nmos ad=55.5f pd=0.74u as=0.1005p ps=1.34u w=0.15u l=0.13u
X1240 VDD.t1365 VSS.t1966 6ph_rosc_0.psdiff_2.buff_d8$1_1.VIN.t22 VDD.t470 sg13_lv_pmos ad=55.5f pd=0.74u as=55.5f ps=0.74u w=0.15u l=0.13u
X1241 6ph_rosc_0.psdiff_1.buff_d8$1_1.inv_d2$1_0.VIN 6ph_rosc_0.psdiff_1.buff_d8$1_1.VIN.t32 VSS.t1723 VSS.t1722 sg13_lv_nmos ad=0.1005p pd=1.34u as=0.1005p ps=1.34u w=0.15u l=0.13u
X1242 6ph_rosc_0.buff_d8$1_2.inv_d8$1_0.VIN 6ph_rosc_0.buff_d8$1_2.inv_d4$1_0.VIN VSS.t117 VSS.t116 sg13_lv_nmos ad=55.5f pd=0.74u as=0.1005p ps=1.34u w=0.15u l=0.13u
X1243 6ph_rosc_0.PH5.t5 6ph_rosc_0.buff_d8$1_1.inv_d8$1_0.VIN VDD.t318 VDD.t75 sg13_lv_pmos ad=55.5f pd=0.74u as=0.1005p ps=1.34u w=0.15u l=0.13u
X1244 6to4_0.buff_PI_d32_3.buff_PI_d16$1_0.inv_PI_d8$1_0.VOUT.t6 6to4_0.buff_PI_d32_3.buff_PI_d16$1_0.inv_PI_d4$1_0.VOUT.t12 VSS.t1518 VSS.t1517 sg13_lv_nmos ad=55.5f pd=0.74u as=0.1005p ps=1.34u w=0.15u l=0.13u
X1245 PH90.t11 6to4_0.buff_PI_d32_0.inv_PI_d32_0.VIN VSS.t592 VSS.t591 sg13_lv_nmos ad=55.5f pd=0.74u as=0.1005p ps=1.34u w=0.15u l=0.13u
X1246 6to4_0.inv_PI_d2$1_2.VOUT 6to4_0.flywheel_clk_1.PH0 VDD.t43 VDD.t37 sg13_lv_pmos ad=55.5f pd=0.74u as=0.1005p ps=1.34u w=0.15u l=0.13u
X1247 6to4_0.buff_PI_d32_0.inv_PI_d32_0.VIN 6to4_0.buff_PI_d32_0.inv_PI_d16$1_0.VIN.t48 VDD.t921 VDD.t341 sg13_lv_pmos ad=0.1005p pd=1.34u as=55.5f ps=0.74u w=0.15u l=0.13u
X1248 VSS.t1136 6ph_rosc_0.psdiff_2.VOUTDN 6ph_rosc_0.psdiff_1.buff_d8$1_1.VIN.t24 VSS.t1154 sg13_lv_nmos ad=55.5f pd=0.74u as=55.5f ps=0.74u w=0.15u l=0.13u
X1249 CTRL 6ph_rosc_0.PH4.t10 CTRL VDD.t78 sg13_lv_pmos ad=0.19p pd=1.38u as=0 ps=0 w=1u l=0.13u
X1250 VDD.t1238 6to4_0.buff_PI_d32_3.buff_PI_d16$1_0.inv_PI_d8$1_0.VOUT.t37 6to4_0.buff_PI_d32_3.inv_PI_d16$1_0.VIN.t41 VDD.t679 sg13_lv_pmos ad=55.5f pd=0.74u as=0.1005p ps=1.34u w=0.15u l=0.13u
X1251 VDD.t861 6ph_rosc_0.psdiff_0.buff_d8$1_0.inv_d4$1_0.VIN 6ph_rosc_0.psdiff_0.buff_d8$1_0.inv_d8$1_0.VIN VDD.t34 sg13_lv_pmos ad=0.1005p pd=1.34u as=55.5f ps=0.74u w=0.15u l=0.13u
X1252 6ph_rosc_0.psdiff_1.VOUTDN 6ph_rosc_0.psdiff_1.buff_d8$1_1.inv_d8$1_0.VIN VDD.t159 VDD.t0 sg13_lv_pmos ad=55.5f pd=0.74u as=0.1005p ps=1.34u w=0.15u l=0.13u
X1253 PH90.t60 6to4_0.buff_PI_d32_0.inv_PI_d32_0.VIN VDD.t394 VDD.t5 sg13_lv_pmos ad=55.5f pd=0.74u as=0.1005p ps=1.34u w=0.15u l=0.13u
X1254 6ph_rosc_0.psdiff_2.VOUTDP 6ph_rosc_0.psdiff_2.buff_d8$1_0.inv_d8$1_0.VIN VDD.t142 VDD.t34 sg13_lv_pmos ad=55.5f pd=0.74u as=0.1005p ps=1.34u w=0.15u l=0.13u
X1255 6to4_0.buff_PI_d32_1.inv_PI_d32_0.VIN 6to4_0.buff_PI_d32_1.inv_PI_d16$1_0.VIN VSS.t1895 VSS.t1894 sg13_lv_nmos ad=55.5f pd=0.74u as=0.1005p ps=1.34u w=0.15u l=0.13u
X1256 VDD.t837 6to4_0.buff_PI_d32_0.buff_PI_d16$1_0.inv_PI_d4$1_0.VOUT.t13 6to4_0.buff_PI_d32_0.buff_PI_d16$1_0.inv_PI_d8$1_0.VOUT.t5 VDD.t341 sg13_lv_pmos ad=55.5f pd=0.74u as=55.5f ps=0.74u w=0.15u l=0.13u
X1257 VDD.t186 6to4_0.buff_PI_d32_1.buff_PI_d16$1_0.inv_PI_d4$1_0.VOUT.t16 6to4_0.buff_PI_d32_1.buff_PI_d16$1_0.inv_PI_d8$1_0.VOUT.t13 VDD.t173 sg13_lv_pmos ad=55.5f pd=0.74u as=0.1005p ps=1.34u w=0.15u l=0.13u
X1258 VSS.t1069 6to4_0.buff_PI_d32_3.inv_PI_d32_0.VIN PH180.t27 VSS.t1068 sg13_lv_nmos ad=0.1005p pd=1.34u as=55.5f ps=0.74u w=0.15u l=0.13u
X1259 VSS.t258 6ph_rosc_0.buff_d8$1_3.inv_d8$1_0.VIN 6ph_rosc_0.PH1.t2 VSS.t257 sg13_lv_nmos ad=0.1005p pd=1.34u as=55.5f ps=0.74u w=0.15u l=0.13u
X1260 VSS.t1418 6to4_0.buff_PI_d32_0.inv_PI_d16$1_0.VIN.t59 6to4_0.buff_PI_d32_0.inv_PI_d32_0.VIN VSS.t1417 sg13_lv_nmos ad=0.1005p pd=1.34u as=55.5f ps=0.74u w=0.15u l=0.13u
X1261 VSS.t1662 6ph_rosc_0.PH5.t11 6to4_0.PI_clk_1.inv_PI_d2$1_0.VOUT VSS.t1661 sg13_lv_nmos ad=0.1005p pd=1.34u as=55.5f ps=0.74u w=0.15u l=0.13u
X1262 6ph_rosc_0.psdiff_1.VOUTDP 6ph_rosc_0.psdiff_1.buff_d8$1_0.inv_d8$1_0.VIN VSS.t983 VSS.t982 sg13_lv_nmos ad=55.5f pd=0.74u as=0.1005p ps=1.34u w=0.15u l=0.13u
X1263 VDD.t1403 VSS.t1967 6ph_rosc_0.psdiff_1.buff_d8$1_1.VIN.t9 VDD.t301 sg13_lv_pmos ad=0.1005p pd=1.34u as=55.5f ps=0.74u w=0.15u l=0.13u
X1264 6ph_rosc_0.psdiff_2.CLKP.t3 6ph_rosc_0.psdiff_0.buff_d8$1_1.inv_d8$1_0.VIN VSS.t777 VSS.t776 sg13_lv_nmos ad=55.5f pd=0.74u as=0.1005p ps=1.34u w=0.15u l=0.13u
X1265 CTRL 6ph_rosc_0.PH4.t10 CTRL VDD.t451 sg13_lv_pmos ad=0.19p pd=1.38u as=0 ps=0 w=1u l=0.13u
X1266 PH180.t26 6to4_0.buff_PI_d32_3.inv_PI_d32_0.VIN VSS.t1067 VSS.t1066 sg13_lv_nmos ad=55.5f pd=0.74u as=0.1005p ps=1.34u w=0.15u l=0.13u
X1267 PH180.t81 6to4_0.buff_PI_d32_3.inv_PI_d32_0.VIN VDD.t730 VDD.t679 sg13_lv_pmos ad=55.5f pd=0.74u as=0.1005p ps=1.34u w=0.15u l=0.13u
X1268 6to4_0.buff_PI_d32_2.buff_PI_d16$1_0.inv_PI_d8$1_0.VOUT.t0 6to4_0.buff_PI_d32_2.buff_PI_d16$1_0.inv_PI_d4$1_0.VOUT.t17 VSS.t1556 VSS.t1555 sg13_lv_nmos ad=55.5f pd=0.74u as=0.1005p ps=1.34u w=0.15u l=0.13u
X1269 VDD.t582 6to4_0.buff_PI_d32_1.inv_PI_d32_0.VIN PH0.t80 VDD.t173 sg13_lv_pmos ad=55.5f pd=0.74u as=0.1005p ps=1.34u w=0.15u l=0.13u
X1270 6to4_0.inv_PI_d2$1_1.VIN 6ph_rosc_0.PH0.t14 VDD.t831 VDD.t17 sg13_lv_pmos ad=55.5f pd=0.74u as=0.1005p ps=1.34u w=0.15u l=0.13u
X1271 6to4_0.buff_PI_d32_0.buff_PI_d16$1_0.inv_PI_d8$1_0.VOUT.t21 6to4_0.buff_PI_d32_0.buff_PI_d16$1_0.inv_PI_d4$1_0.VOUT.t19 VSS.t1286 VSS.t1285 sg13_lv_nmos ad=55.5f pd=0.74u as=0.1005p ps=1.34u w=0.15u l=0.13u
X1272 6ph_rosc_0.psdiff_2.buff_d8$1_0.VIN.t24 6ph_rosc_0.psdiff_2.CLKN VSS.t718 VSS.t717 sg13_lv_nmos ad=55.5f pd=0.74u as=55.5f ps=0.74u w=0.15u l=0.13u
X1273 PH0.t42 6to4_0.buff_PI_d32_1.inv_PI_d32_0.VIN VDD.t572 VDD.t547 sg13_lv_pmos ad=55.5f pd=0.74u as=55.5f ps=0.74u w=0.15u l=0.13u
X1274 6to4_0.buff_PI_d32_2.inv_PI_d32_0.VIN.t43 6to4_0.buff_PI_d32_2.inv_PI_d16$1_0.VIN.t62 VDD.t1011 VDD.t198 sg13_lv_pmos ad=55.5f pd=0.74u as=55.5f ps=0.74u w=0.15u l=0.13u
X1275 a_12104_2338# CTRL 6ph_rosc_0.psdiff_0.buff_d8$1_0.VIN.t10 VSS.t495 sg13_lv_nmos ad=55.5f pd=0.74u as=0.1005p ps=1.34u w=0.15u l=0.13u
X1276 6ph_rosc_0.psdiff_2.buff_d8$1_0.VIN.t28 a_4999_2194# VDD.t648 VDD.t470 sg13_lv_pmos ad=55.5f pd=0.74u as=55.5f ps=0.74u w=0.15u l=0.13u
X1277 VDD.t923 6to4_0.buff_PI_d32_0.inv_PI_d16$1_0.VIN.t49 6to4_0.buff_PI_d32_0.inv_PI_d32_0.VIN VDD.t5 sg13_lv_pmos ad=0.1005p pd=1.34u as=55.5f ps=0.74u w=0.15u l=0.13u
X1278 VSS.t588 6to4_0.buff_PI_d32_0.inv_PI_d32_0.VIN PH90.t27 VSS.t587 sg13_lv_nmos ad=0.1005p pd=1.34u as=55.5f ps=0.74u w=0.15u l=0.13u
X1279 VSS.t213 6ph_rosc_0.psdiff_2.VOUTDP 6ph_rosc_0.psdiff_1.buff_d8$1_0.VIN.t7 VSS.t214 sg13_lv_nmos ad=55.5f pd=0.74u as=55.5f ps=0.74u w=0.15u l=0.13u
X1280 VSS.t75 6ph_rosc_0.buff_d8$1_5.inv_d8$1_0.VIN 6ph_rosc_0.PH0.t1 VSS.t74 sg13_lv_nmos ad=0.1005p pd=1.34u as=55.5f ps=0.74u w=0.15u l=0.13u
X1281 CTRL 6ph_rosc_0.PH4.t10 CTRL VDD.t451 sg13_lv_pmos ad=0.34p pd=2.68u as=0 ps=0 w=1u l=0.13u
X1282 VDD.t1268 6to4_0.buff_PI_d32_1.inv_PI_d16$1_0.VIN 6to4_0.buff_PI_d32_1.inv_PI_d32_0.VIN VDD.t17 sg13_lv_pmos ad=55.5f pd=0.74u as=55.5f ps=0.74u w=0.15u l=0.13u
X1283 VDD.t1385 VSS.t1967 6ph_rosc_0.psdiff_1.buff_d8$1_0.VIN.t20 VDD.t301 sg13_lv_pmos ad=55.5f pd=0.74u as=55.5f ps=0.74u w=0.15u l=0.13u
X1284 6ph_rosc_0.psdiff_1.buff_d8$1_0.inv_d8$1_0.VIN 6ph_rosc_0.psdiff_1.buff_d8$1_0.inv_d4$1_0.VIN VSS.t105 VSS.t104 sg13_lv_nmos ad=55.5f pd=0.74u as=0.1005p ps=1.34u w=0.15u l=0.13u
X1285 PH270.t57 6to4_0.buff_PI_d32_2.inv_PI_d32_0.VIN.t62 VDD.t244 VDD.t202 sg13_lv_pmos ad=55.5f pd=0.74u as=0.1005p ps=1.34u w=0.15u l=0.13u
X1286 VDD.t664 6to4_0.buff_PI_d32_2.VIN 6to4_0.buff_PI_d32_2.buff_PI_d16$1_0.inv_PI_d4$1_0.VIN VDD.t126 sg13_lv_pmos ad=55.5f pd=0.74u as=55.5f ps=0.74u w=0.15u l=0.13u
X1287 VSS.t1706 6ph_rosc_0.psdiff_2.CLKP.t8 6ph_rosc_0.psdiff_2.buff_d8$1_1.VIN.t13 VSS.t1703 sg13_lv_nmos ad=55.5f pd=0.74u as=55.5f ps=0.74u w=0.15u l=0.13u
X1288 VSS.t1464 6to4_0.buff_PI_d32_2.inv_PI_d16$1_0.VIN.t54 6to4_0.buff_PI_d32_2.inv_PI_d32_0.VIN.t18 VSS.t1463 sg13_lv_nmos ad=0.1005p pd=1.34u as=55.5f ps=0.74u w=0.15u l=0.13u
X1289 6ph_rosc_0.psdiff_2.buff_d8$1_0.VIN.t14 6ph_rosc_0.psdiff_2.CLKN VSS.t716 VSS.t715 sg13_lv_nmos ad=55.5f pd=0.74u as=55.5f ps=0.74u w=0.15u l=0.13u
X1290 PH90.t4 6to4_0.buff_PI_d32_0.inv_PI_d32_0.VIN VSS.t586 VSS.t585 sg13_lv_nmos ad=55.5f pd=0.74u as=0.1005p ps=1.34u w=0.15u l=0.13u
X1291 VSS.t143 6to4_0.buff_PI_d32_3.buff_PI_d16$1_0.inv_PI_d4$1_0.VIN 6to4_0.buff_PI_d32_3.buff_PI_d16$1_0.inv_PI_d4$1_0.VOUT.t3 VSS.t142 sg13_lv_nmos ad=0.1005p pd=1.34u as=55.5f ps=0.74u w=0.15u l=0.13u
X1292 6to4_0.buff_PI_d32_0.inv_PI_d16$1_0.VIN.t10 6to4_0.buff_PI_d32_0.buff_PI_d16$1_0.inv_PI_d8$1_0.VOUT.t27 VDD.t1089 VDD.t341 sg13_lv_pmos ad=55.5f pd=0.74u as=55.5f ps=0.74u w=0.15u l=0.13u
X1293 VDD.t891 6to4_0.buff_PI_d32_3.inv_PI_d16$1_0.VIN.t57 6to4_0.buff_PI_d32_3.inv_PI_d32_0.VIN VDD.t99 sg13_lv_pmos ad=55.5f pd=0.74u as=0.1005p ps=1.34u w=0.15u l=0.13u
X1294 PH90.t76 6to4_0.buff_PI_d32_0.inv_PI_d32_0.VIN VDD.t393 VDD.t343 sg13_lv_pmos ad=0.1005p pd=1.34u as=55.5f ps=0.74u w=0.15u l=0.13u
X1295 6to4_0.buff_PI_d32_2.VIN 6to4_0.PI_clk_1.inv_PI_d2$1_0.VOUT VSS.t133 VSS.t132 sg13_lv_nmos ad=55.5f pd=0.74u as=0.1005p ps=1.34u w=0.15u l=0.13u
X1296 6to4_0.buff_PI_d32_0.buff_PI_d16$1_0.inv_PI_d8$1_0.VOUT.t7 6to4_0.buff_PI_d32_0.buff_PI_d16$1_0.inv_PI_d4$1_0.VOUT.t14 VDD.t841 VDD.t341 sg13_lv_pmos ad=55.5f pd=0.74u as=55.5f ps=0.74u w=0.15u l=0.13u
X1297 VSS.t1684 6ph_rosc_0.psdiff_2.CLKP.t8 6ph_rosc_0.psdiff_2.buff_d8$1_1.VIN.t12 VSS.t492 sg13_lv_nmos ad=55.5f pd=0.74u as=55.5f ps=0.74u w=0.15u l=0.13u
X1298 PH0.t79 6to4_0.buff_PI_d32_1.inv_PI_d32_0.VIN VDD.t603 VDD.t552 sg13_lv_pmos ad=55.5f pd=0.74u as=55.5f ps=0.74u w=0.15u l=0.13u
X1299 PH90.t35 6to4_0.buff_PI_d32_0.inv_PI_d32_0.VIN VDD.t392 VDD.t341 sg13_lv_pmos ad=55.5f pd=0.74u as=55.5f ps=0.74u w=0.15u l=0.13u
X1300 PH0.t35 6to4_0.buff_PI_d32_1.inv_PI_d32_0.VIN VDD.t602 VDD.t173 sg13_lv_pmos ad=55.5f pd=0.74u as=0.1005p ps=1.34u w=0.15u l=0.13u
X1301 VSS.t1893 6to4_0.buff_PI_d32_1.inv_PI_d16$1_0.VIN 6to4_0.buff_PI_d32_1.inv_PI_d32_0.VIN VSS.t1892 sg13_lv_nmos ad=0.1005p pd=1.34u as=55.5f ps=0.74u w=0.15u l=0.13u
X1302 6ph_rosc_0.psdiff_1.buff_d8$1_0.VIN.t0 6ph_rosc_0.psdiff_2.VOUTDP VSS.t229 VSS.t234 sg13_lv_nmos ad=55.5f pd=0.74u as=55.5f ps=0.74u w=0.15u l=0.13u
X1303 CTRL 6ph_rosc_0.PH5.t12 CTRL VDD.t85 sg13_lv_pmos ad=0.19p pd=1.38u as=0 ps=0 w=1u l=0.13u
X1304 VDD.t1080 6to4_0.buff_PI_d32_0.buff_PI_d16$1_0.inv_PI_d8$1_0.VOUT.t24 6to4_0.buff_PI_d32_0.inv_PI_d16$1_0.VIN.t2 VDD.t5 sg13_lv_pmos ad=55.5f pd=0.74u as=55.5f ps=0.74u w=0.15u l=0.13u
X1305 VDD.t1364 VSS.t1966 6ph_rosc_0.psdiff_2.buff_d8$1_0.VIN.t9 VDD.t470 sg13_lv_pmos ad=55.5f pd=0.74u as=55.5f ps=0.74u w=0.15u l=0.13u
X1306 VDD.t1163 6to4_0.buff_PI_d32_1.buff_PI_d16$1_0.inv_PI_d8$1_0.VOUT.t32 6to4_0.buff_PI_d32_1.inv_PI_d16$1_0.VIN VDD.t17 sg13_lv_pmos ad=55.5f pd=0.74u as=0.1005p ps=1.34u w=0.15u l=0.13u
X1307 6ph_rosc_0.PH5.t2 6ph_rosc_0.buff_d8$1_1.inv_d8$1_0.VIN VSS.t486 VSS.t485 sg13_lv_nmos ad=55.5f pd=0.74u as=0.1005p ps=1.34u w=0.15u l=0.13u
X1308 6to4_0.buff_PI_d32_0.inv_PI_d32_0.VIN 6to4_0.buff_PI_d32_0.inv_PI_d16$1_0.VIN.t55 VDD.t942 VDD.t5 sg13_lv_pmos ad=0.1005p pd=1.34u as=55.5f ps=0.74u w=0.15u l=0.13u
X1309 PH90.t3 6to4_0.buff_PI_d32_0.inv_PI_d32_0.VIN VSS.t584 VSS.t583 sg13_lv_nmos ad=55.5f pd=0.74u as=0.1005p ps=1.34u w=0.15u l=0.13u
X1310 6to4_0.buff_PI_d32_1.buff_PI_d16$1_0.inv_PI_d8$1_0.VOUT.t17 6to4_0.buff_PI_d32_1.buff_PI_d16$1_0.inv_PI_d4$1_0.VOUT.t17 VSS.t322 VSS.t321 sg13_lv_nmos ad=55.5f pd=0.74u as=0.1005p ps=1.34u w=0.15u l=0.13u
X1311 VSS.t201 6ph_rosc_0.psdiff_2.buff_d8$1_0.inv_d8$1_0.VIN 6ph_rosc_0.psdiff_2.VOUTDP VSS.t200 sg13_lv_nmos ad=0.1005p pd=1.34u as=55.5f ps=0.74u w=0.15u l=0.13u
X1312 VSS.t360 6to4_0.buff_PI_d32_2.inv_PI_d32_0.VIN.t55 PH270.t27 VSS.t359 sg13_lv_nmos ad=0.1005p pd=1.34u as=55.5f ps=0.74u w=0.15u l=0.13u
X1313 VSS.t662 6ph_rosc_0.buff_d8$1_0.inv_d8$1_0.VIN 6ph_rosc_0.PH2.t3 VSS.t661 sg13_lv_nmos ad=0.1005p pd=1.34u as=55.5f ps=0.74u w=0.15u l=0.13u
X1314 VSS.t165 6ph_rosc_0.buff_d8$1_2.inv_d2$1_0.VIN 6ph_rosc_0.buff_d8$1_2.inv_d4$1_0.VIN VSS.t164 sg13_lv_nmos ad=0.1005p pd=1.34u as=55.5f ps=0.74u w=0.15u l=0.13u
X1315 6to4_0.buff_PI_d32_3.inv_PI_d32_0.VIN 6to4_0.buff_PI_d32_3.inv_PI_d16$1_0.VIN.t50 VDD.t871 VDD.t99 sg13_lv_pmos ad=55.5f pd=0.74u as=0.1005p ps=1.34u w=0.15u l=0.13u
X1316 VDD.t1255 6to4_0.buff_PI_d32_1.inv_PI_d16$1_0.VIN 6to4_0.buff_PI_d32_1.inv_PI_d32_0.VIN VDD.t17 sg13_lv_pmos ad=55.5f pd=0.74u as=0.1005p ps=1.34u w=0.15u l=0.13u
X1317 6to4_0.buff_PI_d32_2.buff_PI_d16$1_0.inv_PI_d4$1_0.VIN 6to4_0.buff_PI_d32_2.VIN VDD.t665 VDD.t126 sg13_lv_pmos ad=55.5f pd=0.74u as=55.5f ps=0.74u w=0.15u l=0.13u
X1318 VSS.t1396 6to4_0.buff_PI_d32_0.inv_PI_d16$1_0.VIN.t53 6to4_0.buff_PI_d32_0.inv_PI_d32_0.VIN VSS.t1395 sg13_lv_nmos ad=0.1005p pd=1.34u as=55.5f ps=0.74u w=0.15u l=0.13u
X1319 VDD.t601 6to4_0.buff_PI_d32_1.inv_PI_d32_0.VIN PH0.t78 VDD.t173 sg13_lv_pmos ad=0.1005p pd=1.34u as=55.5f ps=0.74u w=0.15u l=0.13u
X1320 VDD.t121 6to4_0.PI_clk_0.inv_PI_d2$1_0.VOUT 6to4_0.flywheel_clk_0.PH0 VDD.t9 sg13_lv_pmos ad=0.1005p pd=1.34u as=55.5f ps=0.74u w=0.15u l=0.13u
X1321 VSS.t714 6ph_rosc_0.psdiff_2.CLKN 6ph_rosc_0.psdiff_2.buff_d8$1_0.VIN.t23 VSS.t697 sg13_lv_nmos ad=55.5f pd=0.74u as=55.5f ps=0.74u w=0.15u l=0.13u
X1322 6to4_0.buff_PI_d32_3.buff_PI_d16$1_0.inv_PI_d8$1_0.VOUT.t0 6to4_0.buff_PI_d32_3.buff_PI_d16$1_0.inv_PI_d4$1_0.VOUT.t19 VSS.t1516 VSS.t1515 sg13_lv_nmos ad=55.5f pd=0.74u as=0.1005p ps=1.34u w=0.15u l=0.13u
X1323 VDD.t1344 VSS.t1966 6ph_rosc_0.psdiff_2.buff_d8$1_0.VIN.t8 VDD.t470 sg13_lv_pmos ad=55.5f pd=0.74u as=55.5f ps=0.74u w=0.15u l=0.13u
X1324 VSS.t272 6ph_rosc_0.psdiff_1.buff_d8$1_1.inv_d8$1_0.VIN 6ph_rosc_0.psdiff_1.VOUTDN VSS.t271 sg13_lv_nmos ad=0.1005p pd=1.34u as=55.5f ps=0.74u w=0.15u l=0.13u
X1325 VDD.t557 6to4_0.buff_PI_d32_1.inv_PI_d32_0.VIN PH0.t52 VDD.t552 sg13_lv_pmos ad=55.5f pd=0.74u as=55.5f ps=0.74u w=0.15u l=0.13u
X1326 VDD.t391 6to4_0.buff_PI_d32_0.inv_PI_d32_0.VIN PH90.t75 VDD.t343 sg13_lv_pmos ad=0.1005p pd=1.34u as=55.5f ps=0.74u w=0.15u l=0.13u
X1327 VSS.t131 6to4_0.PI_clk_1.inv_PI_d2$1_0.VOUT 6to4_0.buff_PI_d32_2.VIN VSS.t130 sg13_lv_nmos ad=0.1005p pd=1.34u as=55.5f ps=0.74u w=0.15u l=0.13u
X1328 6to4_0.buff_PI_d32_1.buff_PI_d16$1_0.inv_PI_d4$1_0.VOUT.t9 6to4_0.buff_PI_d32_1.buff_PI_d16$1_0.inv_PI_d4$1_0.VIN VDD.t23 VDD.t17 sg13_lv_pmos ad=0.1005p pd=1.34u as=55.5f ps=0.74u w=0.15u l=0.13u
X1329 CTRL 6ph_rosc_0.PH4.t10 CTRL VDD.t78 sg13_lv_pmos ad=0.19p pd=1.38u as=0 ps=0 w=1u l=0.13u
X1330 VSS.t1859 6ph_rosc_0.PH3.t12 6to4_0.inv_PI_d2$1_3.VOUT VSS.t1858 sg13_lv_nmos ad=0.1005p pd=1.34u as=55.5f ps=0.74u w=0.15u l=0.13u
X1331 VSS.t392 6to4_0.buff_PI_d32_2.inv_PI_d32_0.VIN.t63 PH270.t26 VSS.t391 sg13_lv_nmos ad=0.1005p pd=1.34u as=55.5f ps=0.74u w=0.15u l=0.13u
X1332 6ph_rosc_0.psdiff_1.buff_d8$1_0.VIN.t30 CTRL a_9130_2338# VSS.t220 sg13_lv_nmos ad=0.1005p pd=1.34u as=55.5f ps=0.74u w=0.15u l=0.13u
X1333 PH180.t80 6to4_0.buff_PI_d32_3.inv_PI_d32_0.VIN VDD.t705 VDD.t679 sg13_lv_pmos ad=0.1005p pd=1.34u as=55.5f ps=0.74u w=0.15u l=0.13u
X1334 6to4_0.buff_PI_d32_1.inv_PI_d16$1_0.VIN 6to4_0.buff_PI_d32_1.buff_PI_d16$1_0.inv_PI_d8$1_0.VOUT.t27 VSS.t1757 VSS.t1756 sg13_lv_nmos ad=55.5f pd=0.74u as=0.1005p ps=1.34u w=0.15u l=0.13u
X1335 VDD.t53 6ph_rosc_0.buff_d8$1_5.inv_d8$1_0.VIN 6ph_rosc_0.PH0.t5 VDD.t48 sg13_lv_pmos ad=0.1005p pd=1.34u as=55.5f ps=0.74u w=0.15u l=0.13u
X1336 6to4_0.buff_PI_d32_3.inv_PI_d16$1_0.VIN.t18 6to4_0.buff_PI_d32_3.buff_PI_d16$1_0.inv_PI_d8$1_0.VOUT.t30 VSS.t1813 VSS.t1812 sg13_lv_nmos ad=55.5f pd=0.74u as=0.1005p ps=1.34u w=0.15u l=0.13u
X1337 VDD.t658 6ph_rosc_0.psdiff_1.buff_d8$1_0.inv_d8$1_0.VIN 6ph_rosc_0.psdiff_1.VOUTDP VDD.t34 sg13_lv_pmos ad=0.1005p pd=1.34u as=55.5f ps=0.74u w=0.15u l=0.13u
X1338 CTRL 6ph_rosc_0.PH4.t10 CTRL VDD.t451 sg13_lv_pmos ad=0.19p pd=1.38u as=0 ps=0 w=1u l=0.13u
X1339 VDD.t728 6to4_0.buff_PI_d32_3.inv_PI_d32_0.VIN PH180.t79 VDD.t679 sg13_lv_pmos ad=0.1005p pd=1.34u as=55.5f ps=0.74u w=0.15u l=0.13u
X1340 VDD.t802 6to4_0.buff_PI_d32_2.buff_PI_d16$1_0.inv_PI_d8$1_0.VOUT.t32 6to4_0.buff_PI_d32_2.inv_PI_d16$1_0.VIN.t25 VDD.t198 sg13_lv_pmos ad=0.1005p pd=1.34u as=55.5f ps=0.74u w=0.15u l=0.13u
X1341 VSS.t233 6ph_rosc_0.psdiff_2.VOUTDP 6ph_rosc_0.psdiff_1.buff_d8$1_0.VIN.t14 VSS.t208 sg13_lv_nmos ad=0.1005p pd=1.34u as=55.5f ps=0.74u w=0.15u l=0.13u
X1342 VDD.t164 6ph_rosc_0.psdiff_2.buff_d8$1_0.inv_d2$1_0.VIN 6ph_rosc_0.psdiff_2.buff_d8$1_0.inv_d4$1_0.VIN VDD.t34 sg13_lv_pmos ad=0.1005p pd=1.34u as=55.5f ps=0.74u w=0.15u l=0.13u
X1343 VDD.t926 6to4_0.buff_PI_d32_0.inv_PI_d16$1_0.VIN.t50 6to4_0.buff_PI_d32_0.inv_PI_d32_0.VIN VDD.t341 sg13_lv_pmos ad=55.5f pd=0.74u as=55.5f ps=0.74u w=0.15u l=0.13u
X1344 6to4_0.buff_PI_d32_0.inv_PI_d16$1_0.VIN.t28 6to4_0.buff_PI_d32_0.buff_PI_d16$1_0.inv_PI_d8$1_0.VOUT.t33 VDD.t1107 VDD.t5 sg13_lv_pmos ad=55.5f pd=0.74u as=55.5f ps=0.74u w=0.15u l=0.13u
X1345 VDD.t158 6ph_rosc_0.psdiff_1.buff_d8$1_1.inv_d8$1_0.VIN 6ph_rosc_0.psdiff_1.VOUTDN VDD.t0 sg13_lv_pmos ad=0.1005p pd=1.34u as=55.5f ps=0.74u w=0.15u l=0.13u
X1346 VDD.t555 6to4_0.buff_PI_d32_1.inv_PI_d32_0.VIN PH0.t77 VDD.t552 sg13_lv_pmos ad=55.5f pd=0.74u as=0.1005p ps=1.34u w=0.15u l=0.13u
X1347 PH270.t2 6to4_0.buff_PI_d32_2.inv_PI_d32_0.VIN.t67 VSS.t410 VSS.t409 sg13_lv_nmos ad=55.5f pd=0.74u as=0.1005p ps=1.34u w=0.15u l=0.13u
X1348 PH270.t54 6to4_0.buff_PI_d32_2.inv_PI_d32_0.VIN.t57 VDD.t229 VDD.t215 sg13_lv_pmos ad=55.5f pd=0.74u as=55.5f ps=0.74u w=0.15u l=0.13u
X1349 6to4_0.buff_PI_d32_0.inv_PI_d32_0.VIN 6to4_0.buff_PI_d32_0.inv_PI_d16$1_0.VIN.t56 VSS.t1406 VSS.t1405 sg13_lv_nmos ad=55.5f pd=0.74u as=0.1005p ps=1.34u w=0.15u l=0.13u
X1350 6to4_0.buff_PI_d32_1.inv_PI_d32_0.VIN 6to4_0.buff_PI_d32_1.inv_PI_d16$1_0.VIN VDD.t1277 VDD.t17 sg13_lv_pmos ad=55.5f pd=0.74u as=0.1005p ps=1.34u w=0.15u l=0.13u
X1351 VDD.t238 6to4_0.buff_PI_d32_2.inv_PI_d32_0.VIN.t60 PH270.t73 VDD.t198 sg13_lv_pmos ad=55.5f pd=0.74u as=0.1005p ps=1.34u w=0.15u l=0.13u
X1352 VDD.t88 6ph_rosc_0.buff_d8$1_0.inv_d4$1_0.VIN 6ph_rosc_0.buff_d8$1_0.inv_d8$1_0.VIN VDD.t87 sg13_lv_pmos ad=0.1005p pd=1.34u as=55.5f ps=0.74u w=0.15u l=0.13u
X1353 CTRL 6ph_rosc_0.PH4.t10 CTRL VDD.t451 sg13_lv_pmos ad=0.34p pd=2.68u as=0 ps=0 w=1u l=0.13u
X1354 PH90.t1 6to4_0.buff_PI_d32_0.inv_PI_d32_0.VIN VSS.t582 VSS.t581 sg13_lv_nmos ad=55.5f pd=0.74u as=0.1005p ps=1.34u w=0.15u l=0.13u
X1355 VSS.t909 6to4_0.buff_PI_d32_1.inv_PI_d32_0.VIN PH0.t28 VSS.t908 sg13_lv_nmos ad=0.1005p pd=1.34u as=55.5f ps=0.74u w=0.15u l=0.13u
X1356 6to4_0.PI_clk_1.inv_PI_d2$1_0.VOUT 6ph_rosc_0.PH4.t14 VDD.t1070 VDD.t126 sg13_lv_pmos ad=55.5f pd=0.74u as=0.1005p ps=1.34u w=0.15u l=0.13u
X1357 6ph_rosc_0.PH0.t7 6ph_rosc_0.buff_d8$1_5.inv_d8$1_0.VIN VDD.t54 VDD.t51 sg13_lv_pmos ad=55.5f pd=0.74u as=0.1005p ps=1.34u w=0.15u l=0.13u
X1358 6to4_0.PI_clk_1.inv_PI_d2$1_0.VOUT 6ph_rosc_0.PH4.t11 VSS.t1568 VSS.t1567 sg13_lv_nmos ad=55.5f pd=0.74u as=0.1005p ps=1.34u w=0.15u l=0.13u
X1359 VSS.t1891 6to4_0.buff_PI_d32_1.inv_PI_d16$1_0.VIN 6to4_0.buff_PI_d32_1.inv_PI_d32_0.VIN VSS.t1890 sg13_lv_nmos ad=0.1005p pd=1.34u as=55.5f ps=0.74u w=0.15u l=0.13u
X1360 6to4_0.buff_PI_d32_1.inv_PI_d32_0.VIN 6to4_0.buff_PI_d32_1.inv_PI_d16$1_0.VIN VDD.t1276 VDD.t173 sg13_lv_pmos ad=0.1005p pd=1.34u as=55.5f ps=0.74u w=0.15u l=0.13u
X1361 CTRL 6ph_rosc_0.PH0.t10 CTRL VDD.t51 sg13_lv_pmos ad=0.19p pd=1.38u as=0 ps=0 w=1u l=0.13u
X1362 PH270.t17 6to4_0.buff_PI_d32_2.inv_PI_d32_0.VIN.t64 VSS.t398 VSS.t397 sg13_lv_nmos ad=55.5f pd=0.74u as=0.1005p ps=1.34u w=0.15u l=0.13u
X1363 VSS.t713 6ph_rosc_0.psdiff_2.CLKN 6ph_rosc_0.psdiff_2.buff_d8$1_0.VIN.t16 VSS.t712 sg13_lv_nmos ad=0.1005p pd=1.34u as=55.5f ps=0.74u w=0.15u l=0.13u
X1364 VSS.t1819 6to4_0.buff_PI_d32_3.buff_PI_d16$1_0.inv_PI_d8$1_0.VOUT.t31 6to4_0.buff_PI_d32_3.inv_PI_d16$1_0.VIN.t21 VSS.t1818 sg13_lv_nmos ad=0.1005p pd=1.34u as=55.5f ps=0.74u w=0.15u l=0.13u
X1365 VDD.t971 6to4_0.buff_PI_d32_2.inv_PI_d16$1_0.VIN.t49 6to4_0.buff_PI_d32_2.inv_PI_d32_0.VIN.t5 VDD.t126 sg13_lv_pmos ad=55.5f pd=0.74u as=55.5f ps=0.74u w=0.15u l=0.13u
X1366 6ph_rosc_0.buff_d8$1_4.inv_d4$1_0.VIN 6ph_rosc_0.buff_d8$1_4.inv_d2$1_0.VIN VDD.t527 VDD.t75 sg13_lv_pmos ad=55.5f pd=0.74u as=0.1005p ps=1.34u w=0.15u l=0.13u
X1367 6ph_rosc_0.psdiff_2.buff_d8$1_0.inv_d8$1_0.VIN 6ph_rosc_0.psdiff_2.buff_d8$1_0.inv_d4$1_0.VIN VDD.t114 VDD.t34 sg13_lv_pmos ad=55.5f pd=0.74u as=0.1005p ps=1.34u w=0.15u l=0.13u
X1368 VDD.t1023 6to4_0.buff_PI_d32_3.buff_PI_d16$1_0.inv_PI_d4$1_0.VOUT.t18 6to4_0.buff_PI_d32_3.buff_PI_d16$1_0.inv_PI_d8$1_0.VOUT.t13 VDD.t679 sg13_lv_pmos ad=0.1005p pd=1.34u as=55.5f ps=0.74u w=0.15u l=0.13u
X1369 6ph_rosc_0.psdiff_2.CLKP.t2 6ph_rosc_0.psdiff_0.buff_d8$1_1.inv_d8$1_0.VIN VSS.t775 VSS.t774 sg13_lv_nmos ad=55.5f pd=0.74u as=0.1005p ps=1.34u w=0.15u l=0.13u
X1370 6to4_0.buff_PI_d32_3.buff_PI_d16$1_0.inv_PI_d8$1_0.VOUT.t18 6to4_0.buff_PI_d32_3.buff_PI_d16$1_0.inv_PI_d4$1_0.VOUT.t14 VDD.t1034 VDD.t679 sg13_lv_pmos ad=0.1005p pd=1.34u as=55.5f ps=0.74u w=0.15u l=0.13u
X1371 PH0.t37 6to4_0.buff_PI_d32_1.inv_PI_d32_0.VIN VDD.t598 VDD.t552 sg13_lv_pmos ad=55.5f pd=0.74u as=0.1005p ps=1.34u w=0.15u l=0.13u
X1372 VDD.t1095 6to4_0.buff_PI_d32_0.buff_PI_d16$1_0.inv_PI_d8$1_0.VOUT.t29 6to4_0.buff_PI_d32_0.inv_PI_d16$1_0.VIN.t17 VDD.t341 sg13_lv_pmos ad=55.5f pd=0.74u as=0.1005p ps=1.34u w=0.15u l=0.13u
X1373 6to4_0.buff_PI_d32_2.inv_PI_d16$1_0.VIN.t39 6to4_0.buff_PI_d32_2.buff_PI_d16$1_0.inv_PI_d8$1_0.VOUT.t38 VDD.t819 VDD.t198 sg13_lv_pmos ad=0.1005p pd=1.34u as=55.5f ps=0.74u w=0.15u l=0.13u
X1374 6ph_rosc_0.psdiff_2.buff_d8$1_0.VIN.t13 6ph_rosc_0.psdiff_2.CLKN VSS.t711 VSS.t491 sg13_lv_nmos ad=55.5f pd=0.74u as=55.5f ps=0.74u w=0.15u l=0.13u
X1375 CTRL 6ph_rosc_0.PH0.t10 CTRL VDD.t51 sg13_lv_pmos ad=0.34p pd=2.68u as=0 ps=0 w=1u l=0.13u
X1376 VDD.t1323 VSS.t1965 6ph_rosc_0.psdiff_0.buff_d8$1_0.VIN.t5 VDD.t503 sg13_lv_pmos ad=55.5f pd=0.74u as=55.5f ps=0.74u w=0.15u l=0.13u
X1377 VDD.t303 a_7973_2194# 6ph_rosc_0.psdiff_1.buff_d8$1_0.VIN.t25 VDD.t301 sg13_lv_pmos ad=55.5f pd=0.74u as=55.5f ps=0.74u w=0.15u l=0.13u
X1378 6ph_rosc_0.PH2.t5 6ph_rosc_0.buff_d8$1_0.inv_d8$1_0.VIN VDD.t445 VDD.t80 sg13_lv_pmos ad=55.5f pd=0.74u as=0.1005p ps=1.34u w=0.15u l=0.13u
X1379 6ph_rosc_0.buff_d8$1_2.inv_d4$1_0.VIN 6ph_rosc_0.buff_d8$1_2.inv_d2$1_0.VIN VDD.t119 VDD.t80 sg13_lv_pmos ad=55.5f pd=0.74u as=0.1005p ps=1.34u w=0.15u l=0.13u
X1380 VDD.t938 6to4_0.buff_PI_d32_0.inv_PI_d16$1_0.VIN.t54 6to4_0.buff_PI_d32_0.inv_PI_d32_0.VIN VDD.t341 sg13_lv_pmos ad=55.5f pd=0.74u as=0.1005p ps=1.34u w=0.15u l=0.13u
X1381 VDD.t288 6to4_0.buff_PI_d32_2.inv_PI_d32_0.VIN.t77 PH270.t72 VDD.t215 sg13_lv_pmos ad=55.5f pd=0.74u as=55.5f ps=0.74u w=0.15u l=0.13u
X1382 6to4_0.buff_PI_d32_2.inv_PI_d32_0.VIN.t33 6to4_0.buff_PI_d32_2.inv_PI_d16$1_0.VIN.t59 VSS.t1482 VSS.t1481 sg13_lv_nmos ad=55.5f pd=0.74u as=0.1005p ps=1.34u w=0.15u l=0.13u
X1383 6ph_rosc_0.psdiff_2.CLKN 6ph_rosc_0.psdiff_0.buff_d8$1_0.inv_d8$1_0.VIN VDD.t1075 VDD.t34 sg13_lv_pmos ad=55.5f pd=0.74u as=0.1005p ps=1.34u w=0.15u l=0.13u
X1384 VDD.t1142 6ph_rosc_0.PH2.t12 6to4_0.PI_clk_0.inv_PI_d2$1_0.VOUT VDD.t1138 sg13_lv_pmos ad=55.5f pd=0.74u as=0.1005p ps=1.34u w=0.15u l=0.13u
X1385 6ph_rosc_0.psdiff_2.buff_d8$1_0.VIN.t12 6ph_rosc_0.psdiff_2.CLKN VSS.t699 VSS.t708 sg13_lv_nmos ad=55.5f pd=0.74u as=55.5f ps=0.74u w=0.15u l=0.13u
X1386 VDD.t1304 VSS.t1965 6ph_rosc_0.psdiff_0.buff_d8$1_0.VIN.t6 VDD.t503 sg13_lv_pmos ad=55.5f pd=0.74u as=55.5f ps=0.74u w=0.15u l=0.13u
X1387 VDD.t345 6to4_0.buff_PI_d32_0.inv_PI_d32_0.VIN PH90.t74 VDD.t5 sg13_lv_pmos ad=55.5f pd=0.74u as=55.5f ps=0.74u w=0.15u l=0.13u
X1388 6to4_0.buff_PI_d32_0.buff_PI_d16$1_0.inv_PI_d8$1_0.VOUT.t2 6to4_0.buff_PI_d32_0.buff_PI_d16$1_0.inv_PI_d4$1_0.VOUT.t12 VDD.t835 VDD.t341 sg13_lv_pmos ad=0.1005p pd=1.34u as=55.5f ps=0.74u w=0.15u l=0.13u
X1389 VDD.t367 6to4_0.buff_PI_d32_0.inv_PI_d32_0.VIN PH90.t73 VDD.t347 sg13_lv_pmos ad=55.5f pd=0.74u as=0.1005p ps=1.34u w=0.15u l=0.13u
X1390 6to4_0.buff_PI_d32_1.buff_PI_d16$1_0.inv_PI_d8$1_0.VOUT.t3 6to4_0.buff_PI_d32_1.buff_PI_d16$1_0.inv_PI_d4$1_0.VOUT.t13 VDD.t178 VDD.t173 sg13_lv_pmos ad=55.5f pd=0.74u as=55.5f ps=0.74u w=0.15u l=0.13u
X1391 PH0.t0 6to4_0.buff_PI_d32_1.inv_PI_d32_0.VIN VSS.t907 VSS.t906 sg13_lv_nmos ad=55.5f pd=0.74u as=0.1005p ps=1.34u w=0.15u l=0.13u
X1392 CTRL 6ph_rosc_0.PH0.t10 CTRL VDD.t57 sg13_lv_pmos ad=0.19p pd=1.38u as=0 ps=0 w=1u l=0.13u
X1393 6to4_0.buff_PI_d32_3.inv_PI_d32_0.VIN 6to4_0.buff_PI_d32_3.inv_PI_d16$1_0.VIN.t59 VDD.t896 VDD.t99 sg13_lv_pmos ad=0.1005p pd=1.34u as=55.5f ps=0.74u w=0.15u l=0.13u
X1394 VDD.t1026 6to4_0.buff_PI_d32_3.buff_PI_d16$1_0.inv_PI_d4$1_0.VOUT.t19 6to4_0.buff_PI_d32_3.buff_PI_d16$1_0.inv_PI_d8$1_0.VOUT.t10 VDD.t679 sg13_lv_pmos ad=0.1005p pd=1.34u as=55.5f ps=0.74u w=0.15u l=0.13u
X1395 VSS.t737 6ph_rosc_0.buff_d8$1_5.inv_d4$1_0.VIN 6ph_rosc_0.buff_d8$1_5.inv_d8$1_0.VIN VSS.t736 sg13_lv_nmos ad=0.1005p pd=1.34u as=55.5f ps=0.74u w=0.15u l=0.13u
X1396 6to4_0.buff_PI_d32_0.inv_PI_d16$1_0.VIN.t34 6to4_0.buff_PI_d32_0.buff_PI_d16$1_0.inv_PI_d8$1_0.VOUT.t35 VDD.t1114 VDD.t5 sg13_lv_pmos ad=55.5f pd=0.74u as=0.1005p ps=1.34u w=0.15u l=0.13u
X1397 VSS.t905 6to4_0.buff_PI_d32_1.inv_PI_d32_0.VIN PH0.t27 VSS.t904 sg13_lv_nmos ad=0.1005p pd=1.34u as=55.5f ps=0.74u w=0.15u l=0.13u
X1398 6to4_0.buff_PI_d32_1.inv_PI_d16$1_0.VIN 6to4_0.buff_PI_d32_1.buff_PI_d16$1_0.inv_PI_d8$1_0.VOUT.t24 VDD.t1150 VDD.t173 sg13_lv_pmos ad=55.5f pd=0.74u as=55.5f ps=0.74u w=0.15u l=0.13u
X1399 6ph_rosc_0.psdiff_2.buff_d8$1_1.VIN.t16 VSS.t1966 VDD.t1362 VDD.t470 sg13_lv_pmos ad=55.5f pd=0.74u as=55.5f ps=0.74u w=0.15u l=0.13u
X1400 CTRL 6ph_rosc_0.PH2.t10 CTRL VDD.t440 sg13_lv_pmos ad=0.19p pd=1.38u as=0 ps=0 w=1u l=0.13u
X1401 VDD.t987 6to4_0.buff_PI_d32_2.inv_PI_d16$1_0.VIN.t54 6to4_0.buff_PI_d32_2.inv_PI_d32_0.VIN.t20 VDD.t126 sg13_lv_pmos ad=55.5f pd=0.74u as=0.1005p ps=1.34u w=0.15u l=0.13u
X1402 VSS.t31 6to4_0.buff_PI_d32_1.buff_PI_d16$1_0.inv_PI_d4$1_0.VIN 6to4_0.buff_PI_d32_1.buff_PI_d16$1_0.inv_PI_d4$1_0.VOUT.t3 VSS.t30 sg13_lv_nmos ad=0.1005p pd=1.34u as=55.5f ps=0.74u w=0.15u l=0.13u
X1403 VDD.t507 a_12104_2338# 6ph_rosc_0.psdiff_0.buff_d8$1_1.VIN.t15 VDD.t503 sg13_lv_pmos ad=55.5f pd=0.74u as=55.5f ps=0.74u w=0.15u l=0.13u
X1404 PH0.t26 6to4_0.buff_PI_d32_1.inv_PI_d32_0.VIN VSS.t903 VSS.t902 sg13_lv_nmos ad=55.5f pd=0.74u as=0.1005p ps=1.34u w=0.15u l=0.13u
X1405 VSS.t1642 6to4_0.buff_PI_d32_0.buff_PI_d16$1_0.inv_PI_d8$1_0.VOUT.t36 6to4_0.buff_PI_d32_0.inv_PI_d16$1_0.VIN.t36 VSS.t1641 sg13_lv_nmos ad=0.1005p pd=1.34u as=55.5f ps=0.74u w=0.15u l=0.13u
X1406 VDD.t132 6to4_0.buff_PI_d32_2.buff_PI_d16$1_0.inv_PI_d4$1_0.VIN 6to4_0.buff_PI_d32_2.buff_PI_d16$1_0.inv_PI_d4$1_0.VOUT.t8 VDD.t126 sg13_lv_pmos ad=55.5f pd=0.74u as=0.1005p ps=1.34u w=0.15u l=0.13u
X1407 VSS.t1065 6to4_0.buff_PI_d32_3.inv_PI_d32_0.VIN PH180.t7 VSS.t1064 sg13_lv_nmos ad=0.1005p pd=1.34u as=55.5f ps=0.74u w=0.15u l=0.13u
X1408 PH0.t76 6to4_0.buff_PI_d32_1.inv_PI_d32_0.VIN VDD.t597 VDD.t17 sg13_lv_pmos ad=0.1005p pd=1.34u as=55.5f ps=0.74u w=0.15u l=0.13u
X1409 CTRL 6ph_rosc_0.PH2.t10 CTRL VDD.t440 sg13_lv_pmos ad=0.19p pd=1.38u as=0 ps=0 w=1u l=0.13u
X1410 6to4_0.buff_PI_d32_0.inv_PI_d32_0.VIN 6to4_0.buff_PI_d32_0.inv_PI_d16$1_0.VIN.t48 VDD.t920 VDD.t341 sg13_lv_pmos ad=55.5f pd=0.74u as=0.1005p ps=1.34u w=0.15u l=0.13u
X1411 6ph_rosc_0.psdiff_2.buff_d8$1_1.VIN.t15 VSS.t1966 VDD.t1348 VDD.t470 sg13_lv_pmos ad=55.5f pd=0.74u as=55.5f ps=0.74u w=0.15u l=0.13u
X1412 PH0.t16 6to4_0.buff_PI_d32_1.inv_PI_d32_0.VIN VSS.t901 VSS.t900 sg13_lv_nmos ad=55.5f pd=0.74u as=0.1005p ps=1.34u w=0.15u l=0.13u
X1413 VSS.t580 6to4_0.buff_PI_d32_0.inv_PI_d32_0.VIN PH90.t26 VSS.t579 sg13_lv_nmos ad=0.1005p pd=1.34u as=55.5f ps=0.74u w=0.15u l=0.13u
X1414 PH90.t72 6to4_0.buff_PI_d32_0.inv_PI_d32_0.VIN VDD.t344 VDD.t343 sg13_lv_pmos ad=55.5f pd=0.74u as=55.5f ps=0.74u w=0.15u l=0.13u
X1415 VDD.t506 a_12104_2338# 6ph_rosc_0.psdiff_0.buff_d8$1_1.VIN.t14 VDD.t503 sg13_lv_pmos ad=55.5f pd=0.74u as=55.5f ps=0.74u w=0.15u l=0.13u
X1416 VDD.t64 6to4_0.buff_PI_d32_0.buff_PI_d16$1_0.inv_PI_d4$1_0.VIN 6to4_0.buff_PI_d32_0.buff_PI_d16$1_0.inv_PI_d4$1_0.VOUT.t8 VDD.t5 sg13_lv_pmos ad=0.1005p pd=1.34u as=55.5f ps=0.74u w=0.15u l=0.13u
X1417 6ph_rosc_0.buff_d8$1_1.inv_d4$1_0.VIN 6ph_rosc_0.buff_d8$1_1.inv_d2$1_0.VIN VSS.t743 VSS.t742 sg13_lv_nmos ad=55.5f pd=0.74u as=0.1005p ps=1.34u w=0.15u l=0.13u
X1418 VDD.t1171 6to4_0.buff_PI_d32_1.buff_PI_d16$1_0.inv_PI_d8$1_0.VOUT.t25 6to4_0.buff_PI_d32_1.inv_PI_d16$1_0.VIN VDD.t17 sg13_lv_pmos ad=55.5f pd=0.74u as=55.5f ps=0.74u w=0.15u l=0.13u
X1419 VSS.t199 6ph_rosc_0.psdiff_2.buff_d8$1_0.inv_d8$1_0.VIN 6ph_rosc_0.psdiff_2.VOUTDP VSS.t198 sg13_lv_nmos ad=0.1005p pd=1.34u as=55.5f ps=0.74u w=0.15u l=0.13u
X1420 VSS.t660 6ph_rosc_0.buff_d8$1_0.inv_d8$1_0.VIN 6ph_rosc_0.PH2.t2 VSS.t659 sg13_lv_nmos ad=0.1005p pd=1.34u as=55.5f ps=0.74u w=0.15u l=0.13u
X1421 6ph_rosc_0.psdiff_0.buff_d8$1_1.VIN.t27 6ph_rosc_0.psdiff_1.VOUTDN VSS.t1948 VSS.t493 sg13_lv_nmos ad=55.5f pd=0.74u as=55.5f ps=0.74u w=0.15u l=0.13u
X1422 VDD.t237 6to4_0.buff_PI_d32_2.inv_PI_d32_0.VIN.t60 PH270.t71 VDD.t198 sg13_lv_pmos ad=0.1005p pd=1.34u as=55.5f ps=0.74u w=0.15u l=0.13u
X1423 6to4_0.inv_PI_d2$1_2.VOUT 6to4_0.inv_PI_d2$1_3.VOUT VDD.t324 VDD.t99 sg13_lv_pmos ad=0.1005p pd=1.34u as=55.5f ps=0.74u w=0.15u l=0.13u
X1424 PH270.t1 6to4_0.buff_PI_d32_2.inv_PI_d32_0.VIN.t71 VSS.t426 VSS.t425 sg13_lv_nmos ad=55.5f pd=0.74u as=0.1005p ps=1.34u w=0.15u l=0.13u
X1425 VDD.t458 6ph_rosc_0.buff_d8$1_4.inv_d4$1_0.VIN 6ph_rosc_0.buff_d8$1_4.inv_d8$1_0.VIN VDD.t75 sg13_lv_pmos ad=0.1005p pd=1.34u as=55.5f ps=0.74u w=0.15u l=0.13u
X1426 VDD.t206 6to4_0.buff_PI_d32_2.inv_PI_d32_0.VIN.t50 PH270.t70 VDD.t202 sg13_lv_pmos ad=55.5f pd=0.74u as=55.5f ps=0.74u w=0.15u l=0.13u
X1427 VDD.t1249 6ph_rosc_0.PH3.t12 6to4_0.inv_PI_d2$1_3.VOUT VDD.t99 sg13_lv_pmos ad=0.1005p pd=1.34u as=55.5f ps=0.74u w=0.15u l=0.13u
X1428 VSS.t899 6to4_0.buff_PI_d32_1.inv_PI_d32_0.VIN PH0.t25 VSS.t898 sg13_lv_nmos ad=0.1005p pd=1.34u as=55.5f ps=0.74u w=0.15u l=0.13u
X1429 6to4_0.PI_clk_1.inv_PI_d2$1_0.VOUT 6ph_rosc_0.PH4.t14 VDD.t1069 VDD.t126 sg13_lv_pmos ad=0.1005p pd=1.34u as=55.5f ps=0.74u w=0.15u l=0.13u
X1430 6to4_0.buff_PI_d32_0.inv_PI_d16$1_0.VIN.t39 6to4_0.buff_PI_d32_0.buff_PI_d16$1_0.inv_PI_d8$1_0.VOUT.t37 VSS.t1648 VSS.t1647 sg13_lv_nmos ad=55.5f pd=0.74u as=0.1005p ps=1.34u w=0.15u l=0.13u
X1431 PH90.t71 6to4_0.buff_PI_d32_0.inv_PI_d32_0.VIN VDD.t387 VDD.t347 sg13_lv_pmos ad=55.5f pd=0.74u as=0.1005p ps=1.34u w=0.15u l=0.13u
X1432 VDD.t386 6to4_0.buff_PI_d32_0.inv_PI_d32_0.VIN PH90.t70 VDD.t5 sg13_lv_pmos ad=55.5f pd=0.74u as=0.1005p ps=1.34u w=0.15u l=0.13u
X1433 6ph_rosc_0.psdiff_0.buff_d8$1_1.VIN.t18 6ph_rosc_0.psdiff_1.VOUTDN VSS.t1937 VSS.t1947 sg13_lv_nmos ad=55.5f pd=0.74u as=55.5f ps=0.74u w=0.15u l=0.13u
X1434 VDD.t298 6ph_rosc_0.psdiff_0.buff_d8$1_1.inv_d4$1_0.VIN 6ph_rosc_0.psdiff_0.buff_d8$1_1.inv_d8$1_0.VIN VDD.t0 sg13_lv_pmos ad=0.1005p pd=1.34u as=55.5f ps=0.74u w=0.15u l=0.13u
X1435 6to4_0.buff_PI_d32_1.buff_PI_d16$1_0.inv_PI_d8$1_0.VOUT.t16 6to4_0.buff_PI_d32_1.buff_PI_d16$1_0.inv_PI_d4$1_0.VOUT.t17 VDD.t190 VDD.t173 sg13_lv_pmos ad=55.5f pd=0.74u as=0.1005p ps=1.34u w=0.15u l=0.13u
X1436 PH180.t78 6to4_0.buff_PI_d32_3.inv_PI_d32_0.VIN VDD.t727 VDD.t677 sg13_lv_pmos ad=55.5f pd=0.74u as=0.1005p ps=1.34u w=0.15u l=0.13u
X1437 VDD.t1198 6to4_0.buff_PI_d32_3.buff_PI_d16$1_0.inv_PI_d8$1_0.VOUT.t24 6to4_0.buff_PI_d32_3.inv_PI_d16$1_0.VIN.t1 VDD.t99 sg13_lv_pmos ad=0.1005p pd=1.34u as=55.5f ps=0.74u w=0.15u l=0.13u
X1438 VDD.t1093 6to4_0.buff_PI_d32_0.buff_PI_d16$1_0.inv_PI_d8$1_0.VOUT.t28 6to4_0.buff_PI_d32_0.inv_PI_d16$1_0.VIN.t14 VDD.t5 sg13_lv_pmos ad=55.5f pd=0.74u as=0.1005p ps=1.34u w=0.15u l=0.13u
X1439 VSS.t155 6ph_rosc_0.psdiff_2.buff_d8$1_0.inv_d4$1_0.VIN 6ph_rosc_0.psdiff_2.buff_d8$1_0.inv_d8$1_0.VIN VSS.t154 sg13_lv_nmos ad=0.1005p pd=1.34u as=55.5f ps=0.74u w=0.15u l=0.13u
X1440 VDD.t1170 6to4_0.buff_PI_d32_1.buff_PI_d16$1_0.inv_PI_d8$1_0.VOUT.t26 6to4_0.buff_PI_d32_1.inv_PI_d16$1_0.VIN VDD.t173 sg13_lv_pmos ad=55.5f pd=0.74u as=55.5f ps=0.74u w=0.15u l=0.13u
X1441 VDD.t314 6ph_rosc_0.buff_d8$1_1.inv_d4$1_0.VIN 6ph_rosc_0.buff_d8$1_1.inv_d8$1_0.VIN VDD.t75 sg13_lv_pmos ad=0.1005p pd=1.34u as=55.5f ps=0.74u w=0.15u l=0.13u
X1442 VDD.t453 6ph_rosc_0.buff_d8$1_2.inv_d8$1_0.VIN 6ph_rosc_0.PH4.t9 VDD.t330 sg13_lv_pmos ad=0.1005p pd=1.34u as=55.5f ps=0.74u w=0.15u l=0.13u
X1443 VDD.t331 6ph_rosc_0.buff_d8$1_5.inv_d2$1_0.VIN 6ph_rosc_0.buff_d8$1_5.inv_d4$1_0.VIN VDD.t330 sg13_lv_pmos ad=0.1005p pd=1.34u as=55.5f ps=0.74u w=0.15u l=0.13u
X1444 CTRL 6ph_rosc_0.PH1.t10 CTRL VDD.t82 sg13_lv_pmos ad=0.19p pd=1.38u as=0 ps=0 w=1u l=0.13u
X1445 VSS.t1254 6ph_rosc_0.psdiff_1.buff_d8$1_0.VIN.t32 6ph_rosc_0.psdiff_1.buff_d8$1_0.inv_d2$1_0.VIN VSS.t1253 sg13_lv_nmos ad=0.1005p pd=1.34u as=0.1005p ps=1.34u w=0.15u l=0.13u
X1446 PH180.t33 6to4_0.buff_PI_d32_3.inv_PI_d32_0.VIN VDD.t690 VDD.t99 sg13_lv_pmos ad=55.5f pd=0.74u as=55.5f ps=0.74u w=0.15u l=0.13u
X1447 VSS.t1755 6to4_0.buff_PI_d32_1.buff_PI_d16$1_0.inv_PI_d8$1_0.VOUT.t36 6to4_0.buff_PI_d32_1.inv_PI_d16$1_0.VIN VSS.t1754 sg13_lv_nmos ad=0.1005p pd=1.34u as=55.5f ps=0.74u w=0.15u l=0.13u
X1448 VDD.t657 6ph_rosc_0.psdiff_1.buff_d8$1_0.inv_d8$1_0.VIN 6ph_rosc_0.psdiff_1.VOUTDP VDD.t34 sg13_lv_pmos ad=0.1005p pd=1.34u as=55.5f ps=0.74u w=0.15u l=0.13u
X1449 6to4_0.buff_PI_d32_3.inv_PI_d16$1_0.VIN.t14 6to4_0.buff_PI_d32_3.buff_PI_d16$1_0.inv_PI_d8$1_0.VOUT.t28 VDD.t1210 VDD.t679 sg13_lv_pmos ad=55.5f pd=0.74u as=55.5f ps=0.74u w=0.15u l=0.13u
X1450 VDD.t385 6to4_0.buff_PI_d32_0.inv_PI_d32_0.VIN PH90.t69 VDD.t347 sg13_lv_pmos ad=0.1005p pd=1.34u as=55.5f ps=0.74u w=0.15u l=0.13u
X1451 6to4_0.buff_PI_d32_2.inv_PI_d32_0.VIN.t14 6to4_0.buff_PI_d32_2.inv_PI_d16$1_0.VIN.t52 VDD.t981 VDD.t198 sg13_lv_pmos ad=0.1005p pd=1.34u as=55.5f ps=0.74u w=0.15u l=0.13u
X1452 6ph_rosc_0.psdiff_1.buff_d8$1_0.VIN.t16 VSS.t1967 VDD.t1401 VDD.t301 sg13_lv_pmos ad=55.5f pd=0.74u as=55.5f ps=0.74u w=0.15u l=0.13u
X1453 CTRL 6ph_rosc_0.PH1.t10 CTRL VDD.t78 sg13_lv_pmos ad=0.19p pd=1.38u as=0 ps=0 w=1u l=0.13u
X1454 6to4_0.buff_PI_d32_1.inv_PI_d16$1_0.VIN 6to4_0.buff_PI_d32_1.buff_PI_d16$1_0.inv_PI_d8$1_0.VOUT.t39 VDD.t1169 VDD.t17 sg13_lv_pmos ad=55.5f pd=0.74u as=55.5f ps=0.74u w=0.15u l=0.13u
X1455 VSS.t1946 6ph_rosc_0.psdiff_1.VOUTDN 6ph_rosc_0.psdiff_0.buff_d8$1_1.VIN.t24 VSS.t1932 sg13_lv_nmos ad=55.5f pd=0.74u as=55.5f ps=0.74u w=0.15u l=0.13u
X1456 PH270.t52 6to4_0.buff_PI_d32_2.inv_PI_d32_0.VIN.t68 VDD.t262 VDD.t126 sg13_lv_pmos ad=55.5f pd=0.74u as=0.1005p ps=1.34u w=0.15u l=0.13u
X1457 VDD.t1052 6to4_0.buff_PI_d32_2.buff_PI_d16$1_0.inv_PI_d4$1_0.VOUT.t16 6to4_0.buff_PI_d32_2.buff_PI_d16$1_0.inv_PI_d8$1_0.VOUT.t15 VDD.t198 sg13_lv_pmos ad=55.5f pd=0.74u as=55.5f ps=0.74u w=0.15u l=0.13u
X1458 VSS.t897 6to4_0.buff_PI_d32_1.inv_PI_d32_0.VIN PH0.t24 VSS.t896 sg13_lv_nmos ad=0.1005p pd=1.34u as=55.5f ps=0.74u w=0.15u l=0.13u
X1459 VSS.t1458 6to4_0.buff_PI_d32_2.inv_PI_d16$1_0.VIN.t53 6to4_0.buff_PI_d32_2.inv_PI_d32_0.VIN.t15 VSS.t1457 sg13_lv_nmos ad=0.1005p pd=1.34u as=55.5f ps=0.74u w=0.15u l=0.13u
X1460 VSS.t1063 6to4_0.buff_PI_d32_3.inv_PI_d32_0.VIN PH180.t25 VSS.t1062 sg13_lv_nmos ad=0.1005p pd=1.34u as=55.5f ps=0.74u w=0.15u l=0.13u
X1461 6ph_rosc_0.psdiff_1.buff_d8$1_1.VIN.t12 a_9130_2338# VDD.t541 VDD.t301 sg13_lv_pmos ad=55.5f pd=0.74u as=55.5f ps=0.74u w=0.15u l=0.13u
X1462 PH270.t25 6to4_0.buff_PI_d32_2.inv_PI_d32_0.VIN.t53 VSS.t352 VSS.t351 sg13_lv_nmos ad=55.5f pd=0.74u as=0.1005p ps=1.34u w=0.15u l=0.13u
X1463 6to4_0.buff_PI_d32_2.inv_PI_d16$1_0.VIN.t5 6to4_0.buff_PI_d32_2.buff_PI_d16$1_0.inv_PI_d8$1_0.VOUT.t31 VSS.t1208 VSS.t1207 sg13_lv_nmos ad=55.5f pd=0.74u as=0.1005p ps=1.34u w=0.15u l=0.13u
X1464 PH180.t77 6to4_0.buff_PI_d32_3.inv_PI_d32_0.VIN VDD.t725 VDD.t673 sg13_lv_pmos ad=55.5f pd=0.74u as=55.5f ps=0.74u w=0.15u l=0.13u
X1465 PH0.t57 6to4_0.buff_PI_d32_1.inv_PI_d32_0.VIN VDD.t576 VDD.t17 sg13_lv_pmos ad=55.5f pd=0.74u as=55.5f ps=0.74u w=0.15u l=0.13u
X1466 VSS.t1929 6ph_rosc_0.psdiff_1.VOUTDN 6ph_rosc_0.psdiff_0.buff_d8$1_1.VIN.t26 VSS.t1930 sg13_lv_nmos ad=55.5f pd=0.74u as=55.5f ps=0.74u w=0.15u l=0.13u
X1467 6ph_rosc_0.psdiff_1.buff_d8$1_1.VIN.t13 a_9130_2338# VDD.t304 VDD.t301 sg13_lv_pmos ad=55.5f pd=0.74u as=55.5f ps=0.74u w=0.15u l=0.13u
X1468 6ph_rosc_0.psdiff_0.buff_d8$1_0.inv_d8$1_0.VIN 6ph_rosc_0.psdiff_0.buff_d8$1_0.inv_d4$1_0.VIN VDD.t860 VDD.t34 sg13_lv_pmos ad=55.5f pd=0.74u as=0.1005p ps=1.34u w=0.15u l=0.13u
X1469 VDD.t100 6to4_0.buff_PI_d32_3.buff_PI_d16$1_0.inv_PI_d4$1_0.VIN 6to4_0.buff_PI_d32_3.buff_PI_d16$1_0.inv_PI_d4$1_0.VOUT.t7 VDD.t99 sg13_lv_pmos ad=55.5f pd=0.74u as=55.5f ps=0.74u w=0.15u l=0.13u
X1470 VDD.t986 6to4_0.buff_PI_d32_2.inv_PI_d16$1_0.VIN.t54 6to4_0.buff_PI_d32_2.inv_PI_d32_0.VIN.t19 VDD.t126 sg13_lv_pmos ad=0.1005p pd=1.34u as=55.5f ps=0.74u w=0.15u l=0.13u
X1471 PH270.t69 6to4_0.buff_PI_d32_2.inv_PI_d32_0.VIN.t54 VDD.t219 VDD.t215 sg13_lv_pmos ad=55.5f pd=0.74u as=0.1005p ps=1.34u w=0.15u l=0.13u
X1472 PH90.t68 6to4_0.buff_PI_d32_0.inv_PI_d32_0.VIN VDD.t384 VDD.t341 sg13_lv_pmos ad=0.1005p pd=1.34u as=55.5f ps=0.74u w=0.15u l=0.13u
X1473 6to4_0.buff_PI_d32_1.buff_PI_d16$1_0.inv_PI_d4$1_0.VIN 6to4_0.flywheel_clk_1.PH0 VSS.t57 VSS.t56 sg13_lv_nmos ad=55.5f pd=0.74u as=0.1005p ps=1.34u w=0.15u l=0.13u
X1474 VSS.t241 6ph_rosc_0.psdiff_2.VOUTDN 6ph_rosc_0.psdiff_1.buff_d8$1_1.VIN.t22 VSS.t1152 sg13_lv_nmos ad=55.5f pd=0.74u as=55.5f ps=0.74u w=0.15u l=0.13u
X1475 6to4_0.buff_PI_d32_3.inv_PI_d32_0.VIN 6to4_0.buff_PI_d32_3.inv_PI_d16$1_0.VIN.t51 VSS.t1310 VSS.t1309 sg13_lv_nmos ad=55.5f pd=0.74u as=0.1005p ps=1.34u w=0.15u l=0.13u
X1476 VDD.t1083 6to4_0.buff_PI_d32_0.buff_PI_d16$1_0.inv_PI_d8$1_0.VOUT.t25 6to4_0.buff_PI_d32_0.inv_PI_d16$1_0.VIN.t4 VDD.t341 sg13_lv_pmos ad=55.5f pd=0.74u as=55.5f ps=0.74u w=0.15u l=0.13u
X1477 6ph_rosc_0.psdiff_0.buff_d8$1_1.VIN.t0 VSS.t1965 VDD.t1309 VDD.t503 sg13_lv_pmos ad=55.5f pd=0.74u as=55.5f ps=0.74u w=0.15u l=0.13u
X1478 CTRL 6ph_rosc_0.PH2.t10 CTRL VDD.t440 sg13_lv_pmos ad=0.19p pd=1.38u as=0 ps=0 w=1u l=0.13u
X1479 VDD.t1157 6to4_0.buff_PI_d32_1.buff_PI_d16$1_0.inv_PI_d8$1_0.VOUT.t34 6to4_0.buff_PI_d32_1.inv_PI_d16$1_0.VIN VDD.t173 sg13_lv_pmos ad=55.5f pd=0.74u as=0.1005p ps=1.34u w=0.15u l=0.13u
X1480 VSS.t232 6ph_rosc_0.psdiff_2.VOUTDP 6ph_rosc_0.psdiff_1.buff_d8$1_0.VIN.t13 VSS.t228 sg13_lv_nmos ad=55.5f pd=0.74u as=55.5f ps=0.74u w=0.15u l=0.13u
X1481 6ph_rosc_0.PH2.t4 6ph_rosc_0.buff_d8$1_0.inv_d8$1_0.VIN VDD.t444 VDD.t440 sg13_lv_pmos ad=55.5f pd=0.74u as=0.1005p ps=1.34u w=0.15u l=0.13u
X1482 VSS.t1242 6ph_rosc_0.PH0.t11 6ph_rosc_0.PH3.t0 VSS.t1241 sg13_lv_nmos ad=0.1005p pd=1.34u as=55.5f ps=0.74u w=0.15u l=0.13u
X1483 6ph_rosc_0.psdiff_2.buff_d8$1_0.VIN.t7 VSS.t1966 VDD.t1360 VDD.t470 sg13_lv_pmos ad=55.5f pd=0.74u as=0.1005p ps=1.34u w=0.15u l=0.13u
X1484 6to4_0.buff_PI_d32_2.inv_PI_d16$1_0.VIN.t38 6to4_0.buff_PI_d32_2.buff_PI_d16$1_0.inv_PI_d8$1_0.VOUT.t31 VDD.t797 VDD.t198 sg13_lv_pmos ad=55.5f pd=0.74u as=55.5f ps=0.74u w=0.15u l=0.13u
X1485 PH270.t68 6to4_0.buff_PI_d32_2.inv_PI_d32_0.VIN.t73 VDD.t277 VDD.t202 sg13_lv_pmos ad=0.1005p pd=1.34u as=55.5f ps=0.74u w=0.15u l=0.13u
X1486 VSS.t1793 6to4_0.buff_PI_d32_3.buff_PI_d16$1_0.inv_PI_d8$1_0.VOUT.t25 6to4_0.buff_PI_d32_3.inv_PI_d16$1_0.VIN.t3 VSS.t1792 sg13_lv_nmos ad=0.1005p pd=1.34u as=55.5f ps=0.74u w=0.15u l=0.13u
X1487 VSS.t1135 6ph_rosc_0.psdiff_2.VOUTDN 6ph_rosc_0.psdiff_1.buff_d8$1_1.VIN.t21 VSS.t1154 sg13_lv_nmos ad=55.5f pd=0.74u as=55.5f ps=0.74u w=0.15u l=0.13u
X1488 6to4_0.buff_PI_d32_1.inv_PI_d32_0.VIN 6to4_0.buff_PI_d32_1.inv_PI_d16$1_0.VIN VSS.t1889 VSS.t1888 sg13_lv_nmos ad=55.5f pd=0.74u as=0.1005p ps=1.34u w=0.15u l=0.13u
X1489 VSS.t183 6to4_0.buff_PI_d32_2.buff_PI_d16$1_0.inv_PI_d4$1_0.VIN 6to4_0.buff_PI_d32_2.buff_PI_d16$1_0.inv_PI_d4$1_0.VOUT.t3 VSS.t182 sg13_lv_nmos ad=0.1005p pd=1.34u as=55.5f ps=0.74u w=0.15u l=0.13u
X1490 VDD.t674 6to4_0.buff_PI_d32_3.inv_PI_d32_0.VIN PH180.t44 VDD.t673 sg13_lv_pmos ad=55.5f pd=0.74u as=55.5f ps=0.74u w=0.15u l=0.13u
X1491 VDD.t1092 6to4_0.buff_PI_d32_0.buff_PI_d16$1_0.inv_PI_d8$1_0.VOUT.t28 6to4_0.buff_PI_d32_0.inv_PI_d16$1_0.VIN.t13 VDD.t5 sg13_lv_pmos ad=0.1005p pd=1.34u as=55.5f ps=0.74u w=0.15u l=0.13u
X1492 6to4_0.buff_PI_d32_2.buff_PI_d16$1_0.inv_PI_d8$1_0.VOUT.t19 6to4_0.buff_PI_d32_2.buff_PI_d16$1_0.inv_PI_d4$1_0.VOUT.t12 VDD.t1040 VDD.t198 sg13_lv_pmos ad=55.5f pd=0.74u as=55.5f ps=0.74u w=0.15u l=0.13u
X1493 6ph_rosc_0.psdiff_2.buff_d8$1_0.VIN.t6 VSS.t1966 VDD.t1359 VDD.t470 sg13_lv_pmos ad=55.5f pd=0.74u as=55.5f ps=0.74u w=0.15u l=0.13u
X1494 6to4_0.buff_PI_d32_3.inv_PI_d32_0.VIN 6to4_0.buff_PI_d32_3.inv_PI_d16$1_0.VIN.t63 VSS.t1360 VSS.t1359 sg13_lv_nmos ad=55.5f pd=0.74u as=0.1005p ps=1.34u w=0.15u l=0.13u
X1495 6to4_0.buff_PI_d32_3.inv_PI_d16$1_0.VIN.t44 6to4_0.buff_PI_d32_3.buff_PI_d16$1_0.inv_PI_d8$1_0.VOUT.t38 VDD.t1241 VDD.t679 sg13_lv_pmos ad=55.5f pd=0.74u as=0.1005p ps=1.34u w=0.15u l=0.13u
X1496 VSS.t91 6to4_0.buff_PI_d32_0.buff_PI_d16$1_0.inv_PI_d4$1_0.VIN 6to4_0.buff_PI_d32_0.buff_PI_d16$1_0.inv_PI_d4$1_0.VOUT.t3 VSS.t90 sg13_lv_nmos ad=0.1005p pd=1.34u as=55.5f ps=0.74u w=0.15u l=0.13u
X1497 PH270.t67 6to4_0.buff_PI_d32_2.inv_PI_d32_0.VIN.t56 VDD.t225 VDD.t198 sg13_lv_pmos ad=55.5f pd=0.74u as=55.5f ps=0.74u w=0.15u l=0.13u
X1498 CTRL 6ph_rosc_0.PH2.t10 CTRL VDD.t440 sg13_lv_pmos ad=0.19p pd=1.38u as=0 ps=0 w=1u l=0.13u
X1499 VSS.t1182 6to4_0.buff_PI_d32_2.buff_PI_d16$1_0.inv_PI_d8$1_0.VOUT.t25 6to4_0.buff_PI_d32_2.inv_PI_d16$1_0.VIN.t14 VSS.t1181 sg13_lv_nmos ad=0.1005p pd=1.34u as=55.5f ps=0.74u w=0.15u l=0.13u
X1500 VDD.t595 6to4_0.buff_PI_d32_1.inv_PI_d32_0.VIN PH0.t75 VDD.t547 sg13_lv_pmos ad=0.1005p pd=1.34u as=55.5f ps=0.74u w=0.15u l=0.13u
X1501 VSS.t468 6ph_rosc_0.buff_d8$1_1.inv_d4$1_0.VIN 6ph_rosc_0.buff_d8$1_1.inv_d8$1_0.VIN VSS.t467 sg13_lv_nmos ad=0.1005p pd=1.34u as=55.5f ps=0.74u w=0.15u l=0.13u
X1502 VDD.t383 6to4_0.buff_PI_d32_0.inv_PI_d32_0.VIN PH90.t67 VDD.t5 sg13_lv_pmos ad=0.1005p pd=1.34u as=55.5f ps=0.74u w=0.15u l=0.13u
X1503 VDD.t558 6to4_0.buff_PI_d32_1.inv_PI_d32_0.VIN PH0.t74 VDD.t17 sg13_lv_pmos ad=55.5f pd=0.74u as=55.5f ps=0.74u w=0.15u l=0.13u
X1504 6to4_0.buff_PI_d32_1.buff_PI_d16$1_0.inv_PI_d8$1_0.VOUT.t15 6to4_0.buff_PI_d32_1.buff_PI_d16$1_0.inv_PI_d4$1_0.VOUT.t17 VDD.t189 VDD.t173 sg13_lv_pmos ad=0.1005p pd=1.34u as=55.5f ps=0.74u w=0.15u l=0.13u
X1505 VDD.t1400 VSS.t1967 6ph_rosc_0.psdiff_1.buff_d8$1_0.VIN.t19 VDD.t301 sg13_lv_pmos ad=55.5f pd=0.74u as=55.5f ps=0.74u w=0.15u l=0.13u
X1506 PH180.t76 6to4_0.buff_PI_d32_3.inv_PI_d32_0.VIN VDD.t696 VDD.t677 sg13_lv_pmos ad=0.1005p pd=1.34u as=55.5f ps=0.74u w=0.15u l=0.13u
X1507 VDD.t791 6to4_0.buff_PI_d32_2.buff_PI_d16$1_0.inv_PI_d8$1_0.VOUT.t29 6to4_0.buff_PI_d32_2.inv_PI_d16$1_0.VIN.t37 VDD.t126 sg13_lv_pmos ad=55.5f pd=0.74u as=55.5f ps=0.74u w=0.15u l=0.13u
X1508 VSS.t388 6to4_0.buff_PI_d32_2.inv_PI_d32_0.VIN.t62 PH270.t24 VSS.t387 sg13_lv_nmos ad=0.1005p pd=1.34u as=55.5f ps=0.74u w=0.15u l=0.13u
X1509 VDD.t722 6to4_0.buff_PI_d32_3.inv_PI_d32_0.VIN PH180.t75 VDD.t677 sg13_lv_pmos ad=0.1005p pd=1.34u as=55.5f ps=0.74u w=0.15u l=0.13u
X1510 6to4_0.buff_PI_d32_2.inv_PI_d32_0.VIN.t47 6to4_0.buff_PI_d32_2.inv_PI_d16$1_0.VIN.t63 VDD.t1014 VDD.t126 sg13_lv_pmos ad=0.1005p pd=1.34u as=55.5f ps=0.74u w=0.15u l=0.13u
X1511 VDD.t1399 VSS.t1967 6ph_rosc_0.psdiff_1.buff_d8$1_1.VIN.t8 VDD.t301 sg13_lv_pmos ad=55.5f pd=0.74u as=55.5f ps=0.74u w=0.15u l=0.13u
X1512 CTRL 6ph_rosc_0.PH1.t10 CTRL VDD.t82 sg13_lv_pmos ad=0.19p pd=1.38u as=0 ps=0 w=1u l=0.13u
X1513 VDD.t721 6to4_0.buff_PI_d32_3.inv_PI_d32_0.VIN PH180.t74 VDD.t673 sg13_lv_pmos ad=55.5f pd=0.74u as=0.1005p ps=1.34u w=0.15u l=0.13u
X1514 6to4_0.buff_PI_d32_0.inv_PI_d16$1_0.VIN.t31 6to4_0.buff_PI_d32_0.buff_PI_d16$1_0.inv_PI_d8$1_0.VOUT.t34 VDD.t1111 VDD.t341 sg13_lv_pmos ad=55.5f pd=0.74u as=55.5f ps=0.74u w=0.15u l=0.13u
X1515 VDD.t94 6to4_0.PI_clk_1.inv_PI_d2$1_0.VOUT 6to4_0.buff_PI_d32_2.VIN VDD.t92 sg13_lv_pmos ad=0.1005p pd=1.34u as=55.5f ps=0.74u w=0.15u l=0.13u
X1516 VSS.t895 6to4_0.buff_PI_d32_1.inv_PI_d32_0.VIN PH0.t23 VSS.t894 sg13_lv_nmos ad=0.1005p pd=1.34u as=55.5f ps=0.74u w=0.15u l=0.13u
X1517 VSS.t1704 6ph_rosc_0.psdiff_2.CLKP.t8 6ph_rosc_0.psdiff_2.buff_d8$1_1.VIN.t11 VSS.t1703 sg13_lv_nmos ad=55.5f pd=0.74u as=55.5f ps=0.74u w=0.15u l=0.13u
X1518 6ph_rosc_0.psdiff_0.buff_d8$1_1.VIN.t25 6ph_rosc_0.psdiff_1.VOUTDN VSS.t1935 VSS.t1943 sg13_lv_nmos ad=55.5f pd=0.74u as=55.5f ps=0.74u w=0.15u l=0.13u
X1519 6to4_0.buff_PI_d32_3.inv_PI_d16$1_0.VIN.t39 6to4_0.buff_PI_d32_3.buff_PI_d16$1_0.inv_PI_d8$1_0.VOUT.t37 VSS.t1841 VSS.t1840 sg13_lv_nmos ad=55.5f pd=0.74u as=0.1005p ps=1.34u w=0.15u l=0.13u
X1520 PH90.t25 6to4_0.buff_PI_d32_0.inv_PI_d32_0.VIN VSS.t578 VSS.t577 sg13_lv_nmos ad=55.5f pd=0.74u as=0.1005p ps=1.34u w=0.15u l=0.13u
X1521 VDD.t773 6ph_rosc_0.psdiff_2.buff_d8$1_1.inv_d2$1_0.VIN 6ph_rosc_0.psdiff_2.buff_d8$1_1.inv_d4$1_0.VIN VDD.t0 sg13_lv_pmos ad=0.1005p pd=1.34u as=55.5f ps=0.74u w=0.15u l=0.13u
X1522 VDD.t247 6to4_0.buff_PI_d32_2.inv_PI_d32_0.VIN.t63 PH270.t66 VDD.t202 sg13_lv_pmos ad=0.1005p pd=1.34u as=55.5f ps=0.74u w=0.15u l=0.13u
X1523 VSS.t1061 6to4_0.buff_PI_d32_3.inv_PI_d32_0.VIN PH180.t24 VSS.t1060 sg13_lv_nmos ad=0.1005p pd=1.34u as=55.5f ps=0.74u w=0.15u l=0.13u
X1524 VSS.t169 6to4_0.PI_clk_0.inv_PI_d2$1_0.VOUT 6to4_0.flywheel_clk_0.PH0 VSS.t168 sg13_lv_nmos ad=0.1005p pd=1.34u as=55.5f ps=0.74u w=0.15u l=0.13u
X1525 6ph_rosc_0.buff_d8$1_0.inv_d4$1_0.VIN 6ph_rosc_0.buff_d8$1_0.inv_d2$1_0.VIN VSS.t1005 VSS.t1004 sg13_lv_nmos ad=55.5f pd=0.74u as=0.1005p ps=1.34u w=0.15u l=0.13u
X1526 VDD.t1252 6ph_rosc_0.PH3.t13 6ph_rosc_0.PH0.t9 VDD.t824 sg13_lv_pmos ad=0.1005p pd=1.34u as=55.5f ps=0.74u w=0.15u l=0.13u
X1527 6to4_0.buff_PI_d32_0.inv_PI_d16$1_0.VIN.t20 6to4_0.buff_PI_d32_0.buff_PI_d16$1_0.inv_PI_d8$1_0.VOUT.t30 VDD.t1099 VDD.t5 sg13_lv_pmos ad=0.1005p pd=1.34u as=55.5f ps=0.74u w=0.15u l=0.13u
X1528 6ph_rosc_0.psdiff_1.buff_d8$1_1.VIN.t28 6ph_rosc_0.psdiff_2.VOUTDN VSS.t1153 VSS.t1134 sg13_lv_nmos ad=55.5f pd=0.74u as=55.5f ps=0.74u w=0.15u l=0.13u
X1529 VSS.t123 6ph_rosc_0.buff_d8$1_0.inv_d4$1_0.VIN 6ph_rosc_0.buff_d8$1_0.inv_d8$1_0.VIN VSS.t122 sg13_lv_nmos ad=0.1005p pd=1.34u as=55.5f ps=0.74u w=0.15u l=0.13u
X1530 CTRL 6ph_rosc_0.PH1.t10 CTRL VDD.t78 sg13_lv_pmos ad=0.19p pd=1.38u as=0 ps=0 w=1u l=0.13u
X1531 PH180.t73 6to4_0.buff_PI_d32_3.inv_PI_d32_0.VIN VDD.t720 VDD.t679 sg13_lv_pmos ad=55.5f pd=0.74u as=0.1005p ps=1.34u w=0.15u l=0.13u
X1532 6ph_rosc_0.PH2.t1 6ph_rosc_0.buff_d8$1_0.inv_d8$1_0.VIN VSS.t658 VSS.t657 sg13_lv_nmos ad=55.5f pd=0.74u as=0.1005p ps=1.34u w=0.15u l=0.13u
X1533 PH90.t51 6to4_0.buff_PI_d32_0.inv_PI_d32_0.VIN VDD.t364 VDD.t341 sg13_lv_pmos ad=55.5f pd=0.74u as=55.5f ps=0.74u w=0.15u l=0.13u
X1534 VSS.t1546 6to4_0.buff_PI_d32_2.buff_PI_d16$1_0.inv_PI_d4$1_0.VOUT.t15 6to4_0.buff_PI_d32_2.buff_PI_d16$1_0.inv_PI_d8$1_0.VOUT.t6 VSS.t1545 sg13_lv_nmos ad=0.1005p pd=1.34u as=55.5f ps=0.74u w=0.15u l=0.13u
X1535 6to4_0.buff_PI_d32_2.inv_PI_d16$1_0.VIN.t13 6to4_0.buff_PI_d32_2.buff_PI_d16$1_0.inv_PI_d8$1_0.VOUT.t27 VSS.t1190 VSS.t1189 sg13_lv_nmos ad=55.5f pd=0.74u as=0.1005p ps=1.34u w=0.15u l=0.13u
X1536 VSS.t751 6ph_rosc_0.buff_d8$1_4.inv_d8$1_0.VIN 6ph_rosc_0.PH3.t4 VSS.t750 sg13_lv_nmos ad=0.1005p pd=1.34u as=55.5f ps=0.74u w=0.15u l=0.13u
X1537 VSS.t1398 6to4_0.buff_PI_d32_0.inv_PI_d16$1_0.VIN.t54 6to4_0.buff_PI_d32_0.inv_PI_d32_0.VIN VSS.t1397 sg13_lv_nmos ad=0.1005p pd=1.34u as=55.5f ps=0.74u w=0.15u l=0.13u
X1538 VSS.t1702 6ph_rosc_0.psdiff_2.CLKP.t8 6ph_rosc_0.psdiff_2.buff_d8$1_1.VIN.t10 VSS.t492 sg13_lv_nmos ad=55.5f pd=0.74u as=55.5f ps=0.74u w=0.15u l=0.13u
X1539 VSS.t1336 6to4_0.buff_PI_d32_3.inv_PI_d16$1_0.VIN.t57 6to4_0.buff_PI_d32_3.inv_PI_d32_0.VIN VSS.t1335 sg13_lv_nmos ad=0.1005p pd=1.34u as=55.5f ps=0.74u w=0.15u l=0.13u
X1540 VDD.t196 6to4_0.buff_PI_d32_1.buff_PI_d16$1_0.inv_PI_d4$1_0.VOUT.t19 6to4_0.buff_PI_d32_1.buff_PI_d16$1_0.inv_PI_d8$1_0.VOUT.t21 VDD.t173 sg13_lv_pmos ad=0.1005p pd=1.34u as=55.5f ps=0.74u w=0.15u l=0.13u
X1541 VDD.t499 6ph_rosc_0.psdiff_0.buff_d8$1_1.inv_d8$1_0.VIN 6ph_rosc_0.psdiff_2.CLKP.t5 VDD.t0 sg13_lv_pmos ad=0.1005p pd=1.34u as=55.5f ps=0.74u w=0.15u l=0.13u
X1542 VDD.t995 6to4_0.buff_PI_d32_2.inv_PI_d16$1_0.VIN.t57 6to4_0.buff_PI_d32_2.inv_PI_d32_0.VIN.t29 VDD.t198 sg13_lv_pmos ad=55.5f pd=0.74u as=55.5f ps=0.74u w=0.15u l=0.13u
X1543 VDD.t593 6to4_0.buff_PI_d32_1.inv_PI_d32_0.VIN PH0.t46 VDD.t547 sg13_lv_pmos ad=55.5f pd=0.74u as=55.5f ps=0.74u w=0.15u l=0.13u
X1544 6to4_0.buff_PI_d32_2.inv_PI_d16$1_0.VIN.t36 6to4_0.buff_PI_d32_2.buff_PI_d16$1_0.inv_PI_d8$1_0.VOUT.t37 VDD.t815 VDD.t126 sg13_lv_pmos ad=55.5f pd=0.74u as=55.5f ps=0.74u w=0.15u l=0.13u
X1545 VDD.t592 6to4_0.buff_PI_d32_1.inv_PI_d32_0.VIN PH0.t73 VDD.t17 sg13_lv_pmos ad=55.5f pd=0.74u as=0.1005p ps=1.34u w=0.15u l=0.13u
X1546 6ph_rosc_0.psdiff_2.buff_d8$1_1.inv_d8$1_0.VIN 6ph_rosc_0.psdiff_2.buff_d8$1_1.inv_d4$1_0.VIN VDD.t30 VDD.t0 sg13_lv_pmos ad=55.5f pd=0.74u as=0.1005p ps=1.34u w=0.15u l=0.13u
X1547 PH180.t72 6to4_0.buff_PI_d32_3.inv_PI_d32_0.VIN VDD.t719 VDD.t673 sg13_lv_pmos ad=55.5f pd=0.74u as=0.1005p ps=1.34u w=0.15u l=0.13u
X1548 VSS.t576 6to4_0.buff_PI_d32_0.inv_PI_d32_0.VIN PH90.t24 VSS.t575 sg13_lv_nmos ad=0.1005p pd=1.34u as=55.5f ps=0.74u w=0.15u l=0.13u
X1549 VDD.t452 6ph_rosc_0.buff_d8$1_2.inv_d8$1_0.VIN 6ph_rosc_0.PH4.t8 VDD.t451 sg13_lv_pmos ad=0.1005p pd=1.34u as=55.5f ps=0.74u w=0.15u l=0.13u
X1550 VSS.t1586 6ph_rosc_0.psdiff_0.buff_d8$1_0.inv_d8$1_0.VIN 6ph_rosc_0.psdiff_2.CLKN VSS.t1585 sg13_lv_nmos ad=0.1005p pd=1.34u as=55.5f ps=0.74u w=0.15u l=0.13u
X1551 6ph_rosc_0.psdiff_0.buff_d8$1_0.VIN.t4 VSS.t1965 VDD.t1307 VDD.t503 sg13_lv_pmos ad=55.5f pd=0.74u as=55.5f ps=0.74u w=0.15u l=0.13u
X1552 CTRL 6ph_rosc_0.PH3.t11 CTRL VDD.t57 sg13_lv_pmos ad=0.19p pd=1.38u as=0 ps=0 w=1u l=0.13u
X1553 VDD.t1275 6to4_0.buff_PI_d32_1.inv_PI_d16$1_0.VIN 6to4_0.buff_PI_d32_1.inv_PI_d32_0.VIN VDD.t173 sg13_lv_pmos ad=0.1005p pd=1.34u as=55.5f ps=0.74u w=0.15u l=0.13u
X1554 6ph_rosc_0.psdiff_1.buff_d8$1_0.inv_d4$1_0.VIN 6ph_rosc_0.psdiff_1.buff_d8$1_0.inv_d2$1_0.VIN VDD.t116 VDD.t34 sg13_lv_pmos ad=55.5f pd=0.74u as=0.1005p ps=1.34u w=0.15u l=0.13u
X1555 VDD.t81 6ph_rosc_0.buff_d8$1_2.inv_d4$1_0.VIN 6ph_rosc_0.buff_d8$1_2.inv_d8$1_0.VIN VDD.t80 sg13_lv_pmos ad=0.1005p pd=1.34u as=55.5f ps=0.74u w=0.15u l=0.13u
X1556 VDD.t1020 6to4_0.buff_PI_d32_3.buff_PI_d16$1_0.inv_PI_d4$1_0.VOUT.t17 6to4_0.buff_PI_d32_3.buff_PI_d16$1_0.inv_PI_d8$1_0.VOUT.t17 VDD.t679 sg13_lv_pmos ad=55.5f pd=0.74u as=0.1005p ps=1.34u w=0.15u l=0.13u
X1557 6ph_rosc_0.psdiff_0.buff_d8$1_0.VIN.t30 6ph_rosc_0.psdiff_1.VOUTDP VSS.t813 VSS.t808 sg13_lv_nmos ad=55.5f pd=0.74u as=55.5f ps=0.74u w=0.15u l=0.13u
X1558 CTRL 6ph_rosc_0.PH5.t12 CTRL VDD.t87 sg13_lv_pmos ad=0.19p pd=1.38u as=0 ps=0 w=1u l=0.13u
X1559 VSS.t1290 6ph_rosc_0.psdiff_0.buff_d8$1_0.inv_d4$1_0.VIN 6ph_rosc_0.psdiff_0.buff_d8$1_0.inv_d8$1_0.VIN VSS.t1289 sg13_lv_nmos ad=0.1005p pd=1.34u as=55.5f ps=0.74u w=0.15u l=0.13u
X1560 6ph_rosc_0.psdiff_1.VOUTDN 6ph_rosc_0.psdiff_1.buff_d8$1_1.inv_d8$1_0.VIN VSS.t270 VSS.t269 sg13_lv_nmos ad=55.5f pd=0.74u as=0.1005p ps=1.34u w=0.15u l=0.13u
X1561 VSS.t430 6to4_0.buff_PI_d32_2.inv_PI_d32_0.VIN.t72 PH270.t14 VSS.t429 sg13_lv_nmos ad=0.1005p pd=1.34u as=55.5f ps=0.74u w=0.15u l=0.13u
X1562 VDD.t349 6to4_0.buff_PI_d32_0.inv_PI_d32_0.VIN PH90.t66 VDD.t341 sg13_lv_pmos ad=55.5f pd=0.74u as=55.5f ps=0.74u w=0.15u l=0.13u
X1563 6ph_rosc_0.psdiff_2.buff_d8$1_1.VIN.t9 6ph_rosc_0.psdiff_2.CLKP.t8 VSS.t1701 VSS.t1685 sg13_lv_nmos ad=55.5f pd=0.74u as=0.1005p ps=1.34u w=0.15u l=0.13u
X1564 6ph_rosc_0.psdiff_2.CLKN 6ph_rosc_0.psdiff_0.buff_d8$1_0.inv_d8$1_0.VIN VSS.t1584 VSS.t1583 sg13_lv_nmos ad=55.5f pd=0.74u as=0.1005p ps=1.34u w=0.15u l=0.13u
X1565 6to4_0.inv_PI_d2$1_3.VOUT 6ph_rosc_0.PH3.t10 VSS.t1853 VSS.t1852 sg13_lv_nmos ad=55.5f pd=0.74u as=0.1005p ps=1.34u w=0.15u l=0.13u
X1566 6to4_0.buff_PI_d32_0.inv_PI_d32_0.VIN 6to4_0.buff_PI_d32_0.inv_PI_d16$1_0.VIN.t48 VSS.t1374 VSS.t1373 sg13_lv_nmos ad=55.5f pd=0.74u as=0.1005p ps=1.34u w=0.15u l=0.13u
X1567 VDD.t909 6to4_0.buff_PI_d32_3.inv_PI_d16$1_0.VIN.t63 6to4_0.buff_PI_d32_3.inv_PI_d32_0.VIN VDD.t679 sg13_lv_pmos ad=0.1005p pd=1.34u as=55.5f ps=0.74u w=0.15u l=0.13u
X1568 CTRL 6ph_rosc_0.PH3.t11 CTRL VDD.t330 sg13_lv_pmos ad=0.19p pd=1.38u as=0 ps=0 w=1u l=0.13u
X1569 VSS.t1059 6to4_0.buff_PI_d32_3.inv_PI_d32_0.VIN PH180.t23 VSS.t1058 sg13_lv_nmos ad=0.1005p pd=1.34u as=55.5f ps=0.74u w=0.15u l=0.13u
X1570 6to4_0.buff_PI_d32_0.buff_PI_d16$1_0.inv_PI_d4$1_0.VIN 6to4_0.flywheel_clk_0.PH0 VSS.t13 VSS.t12 sg13_lv_nmos ad=55.5f pd=0.74u as=0.1005p ps=1.34u w=0.15u l=0.13u
X1571 6ph_rosc_0.psdiff_2.buff_d8$1_1.VIN.t7 6ph_rosc_0.psdiff_2.CLKP.t8 VSS.t1700 VSS.t498 sg13_lv_nmos ad=55.5f pd=0.74u as=55.5f ps=0.74u w=0.15u l=0.13u
X1572 VDD.t800 6to4_0.buff_PI_d32_2.buff_PI_d16$1_0.inv_PI_d8$1_0.VOUT.t32 6to4_0.buff_PI_d32_2.inv_PI_d16$1_0.VIN.t35 VDD.t198 sg13_lv_pmos ad=55.5f pd=0.74u as=0.1005p ps=1.34u w=0.15u l=0.13u
X1573 VDD.t1358 VSS.t1966 6ph_rosc_0.psdiff_2.buff_d8$1_1.VIN.t21 VDD.t470 sg13_lv_pmos ad=55.5f pd=0.74u as=55.5f ps=0.74u w=0.15u l=0.13u
X1574 CTRL 6ph_rosc_0.PH5.t12 CTRL VDD.t85 sg13_lv_pmos ad=0.19p pd=1.38u as=0 ps=0 w=1u l=0.13u
X1575 PH180.t22 6to4_0.buff_PI_d32_3.inv_PI_d32_0.VIN VSS.t1057 VSS.t1056 sg13_lv_nmos ad=55.5f pd=0.74u as=0.1005p ps=1.34u w=0.15u l=0.13u
X1576 VSS.t1887 6to4_0.buff_PI_d32_1.inv_PI_d16$1_0.VIN 6to4_0.buff_PI_d32_1.inv_PI_d32_0.VIN VSS.t1886 sg13_lv_nmos ad=0.1005p pd=1.34u as=55.5f ps=0.74u w=0.15u l=0.13u
X1577 PH180.t71 6to4_0.buff_PI_d32_3.inv_PI_d32_0.VIN VDD.t692 VDD.t679 sg13_lv_pmos ad=0.1005p pd=1.34u as=55.5f ps=0.74u w=0.15u l=0.13u
X1578 VDD.t977 6to4_0.buff_PI_d32_2.inv_PI_d16$1_0.VIN.t51 6to4_0.buff_PI_d32_2.inv_PI_d32_0.VIN.t10 VDD.t198 sg13_lv_pmos ad=55.5f pd=0.74u as=0.1005p ps=1.34u w=0.15u l=0.13u
X1579 VDD.t1357 VSS.t1966 6ph_rosc_0.psdiff_2.buff_d8$1_0.VIN.t6 VDD.t470 sg13_lv_pmos ad=55.5f pd=0.74u as=55.5f ps=0.74u w=0.15u l=0.13u
X1580 6ph_rosc_0.PH1.t2 6ph_rosc_0.buff_d8$1_3.inv_d8$1_0.VIN VSS.t256 VSS.t255 sg13_lv_nmos ad=55.5f pd=0.74u as=0.1005p ps=1.34u w=0.15u l=0.13u
X1581 6to4_0.buff_PI_d32_2.inv_PI_d16$1_0.VIN.t7 6to4_0.buff_PI_d32_2.buff_PI_d16$1_0.inv_PI_d8$1_0.VOUT.t35 VSS.t1224 VSS.t1223 sg13_lv_nmos ad=55.5f pd=0.74u as=0.1005p ps=1.34u w=0.15u l=0.13u
X1582 CTRL 6ph_rosc_0.PH3.t11 CTRL VDD.t464 sg13_lv_pmos ad=0.19p pd=1.38u as=0 ps=0 w=1u l=0.13u
X1583 6to4_0.buff_PI_d32_1.inv_PI_d32_0.VIN 6to4_0.buff_PI_d32_1.inv_PI_d16$1_0.VIN VDD.t1274 VDD.t17 sg13_lv_pmos ad=55.5f pd=0.74u as=0.1005p ps=1.34u w=0.15u l=0.13u
X1584 6to4_0.buff_PI_d32_0.inv_PI_d32_0.VIN 6to4_0.buff_PI_d32_0.inv_PI_d16$1_0.VIN.t57 VSS.t1412 VSS.t1411 sg13_lv_nmos ad=55.5f pd=0.74u as=0.1005p ps=1.34u w=0.15u l=0.13u
X1585 VSS.t893 6to4_0.buff_PI_d32_1.inv_PI_d32_0.VIN PH0.t22 VSS.t892 sg13_lv_nmos ad=0.1005p pd=1.34u as=55.5f ps=0.74u w=0.15u l=0.13u
X1586 PH0.t72 6to4_0.buff_PI_d32_1.inv_PI_d32_0.VIN VDD.t591 VDD.t173 sg13_lv_pmos ad=0.1005p pd=1.34u as=55.5f ps=0.74u w=0.15u l=0.13u
X1587 VDD.t317 6ph_rosc_0.buff_d8$1_1.inv_d8$1_0.VIN 6ph_rosc_0.PH5.t5 VDD.t75 sg13_lv_pmos ad=0.1005p pd=1.34u as=55.5f ps=0.74u w=0.15u l=0.13u
X1588 PH180.t13 6to4_0.buff_PI_d32_3.inv_PI_d32_0.VIN VSS.t1055 VSS.t1054 sg13_lv_nmos ad=55.5f pd=0.74u as=0.1005p ps=1.34u w=0.15u l=0.13u
X1589 6to4_0.inv_PI_d2$1_2.VOUT 6to4_0.flywheel_clk_1.PH0 VSS.t55 VSS.t54 sg13_lv_nmos ad=55.5f pd=0.74u as=0.1005p ps=1.34u w=0.15u l=0.13u
X1590 VSS.t574 6to4_0.buff_PI_d32_0.inv_PI_d32_0.VIN PH90.t23 VSS.t573 sg13_lv_nmos ad=0.1005p pd=1.34u as=55.5f ps=0.74u w=0.15u l=0.13u
X1591 VDD.t1356 VSS.t1966 6ph_rosc_0.psdiff_2.buff_d8$1_1.VIN.t20 VDD.t470 sg13_lv_pmos ad=55.5f pd=0.74u as=55.5f ps=0.74u w=0.15u l=0.13u
X1592 VDD.t231 6to4_0.buff_PI_d32_2.inv_PI_d32_0.VIN.t58 PH270.t65 VDD.t126 sg13_lv_pmos ad=55.5f pd=0.74u as=55.5f ps=0.74u w=0.15u l=0.13u
X1593 6to4_0.buff_PI_d32_2.buff_PI_d16$1_0.inv_PI_d8$1_0.VOUT.t18 6to4_0.buff_PI_d32_2.buff_PI_d16$1_0.inv_PI_d4$1_0.VOUT.t17 VDD.t1056 VDD.t198 sg13_lv_pmos ad=0.1005p pd=1.34u as=55.5f ps=0.74u w=0.15u l=0.13u
X1594 6to4_0.buff_PI_d32_1.inv_PI_d16$1_0.VIN 6to4_0.buff_PI_d32_1.buff_PI_d16$1_0.inv_PI_d8$1_0.VOUT.t38 VSS.t1753 VSS.t1752 sg13_lv_nmos ad=55.5f pd=0.74u as=0.1005p ps=1.34u w=0.15u l=0.13u
X1595 6to4_0.buff_PI_d32_2.inv_PI_d16$1_0.VIN.t34 6to4_0.buff_PI_d32_2.buff_PI_d16$1_0.inv_PI_d8$1_0.VOUT.t28 VDD.t788 VDD.t126 sg13_lv_pmos ad=55.5f pd=0.74u as=0.1005p ps=1.34u w=0.15u l=0.13u
X1596 PH270.t3 6to4_0.buff_PI_d32_2.inv_PI_d32_0.VIN.t73 VSS.t434 VSS.t433 sg13_lv_nmos ad=55.5f pd=0.74u as=0.1005p ps=1.34u w=0.15u l=0.13u
X1597 VSS.t181 6to4_0.buff_PI_d32_2.buff_PI_d16$1_0.inv_PI_d4$1_0.VIN 6to4_0.buff_PI_d32_2.buff_PI_d16$1_0.inv_PI_d4$1_0.VOUT.t2 VSS.t180 sg13_lv_nmos ad=0.1005p pd=1.34u as=55.5f ps=0.74u w=0.15u l=0.13u
X1598 CTRL 6ph_rosc_0.PH5.t12 CTRL VDD.t89 sg13_lv_pmos ad=0.19p pd=1.38u as=0 ps=0 w=1u l=0.13u
X1599 6to4_0.buff_PI_d32_3.inv_PI_d16$1_0.VIN.t6 6to4_0.buff_PI_d32_3.buff_PI_d16$1_0.inv_PI_d8$1_0.VOUT.t26 VSS.t1797 VSS.t1796 sg13_lv_nmos ad=55.5f pd=0.74u as=0.1005p ps=1.34u w=0.15u l=0.13u
X1600 VSS.t1053 6to4_0.buff_PI_d32_3.inv_PI_d32_0.VIN PH180.t9 VSS.t1052 sg13_lv_nmos ad=0.1005p pd=1.34u as=55.5f ps=0.74u w=0.15u l=0.13u
X1601 VDD.t717 6to4_0.buff_PI_d32_3.inv_PI_d32_0.VIN PH180.t38 VDD.t679 sg13_lv_pmos ad=0.1005p pd=1.34u as=55.5f ps=0.74u w=0.15u l=0.13u
X1602 VDD.t380 6to4_0.buff_PI_d32_0.inv_PI_d32_0.VIN PH90.t65 VDD.t341 sg13_lv_pmos ad=55.5f pd=0.74u as=0.1005p ps=1.34u w=0.15u l=0.13u
X1603 VSS.t141 6to4_0.buff_PI_d32_3.buff_PI_d16$1_0.inv_PI_d4$1_0.VIN 6to4_0.buff_PI_d32_3.buff_PI_d16$1_0.inv_PI_d4$1_0.VOUT.t2 VSS.t140 sg13_lv_nmos ad=0.1005p pd=1.34u as=55.5f ps=0.74u w=0.15u l=0.13u
X1604 6to4_0.buff_PI_d32_2.buff_PI_d16$1_0.inv_PI_d8$1_0.VOUT.t5 6to4_0.buff_PI_d32_2.buff_PI_d16$1_0.inv_PI_d4$1_0.VOUT.t14 VSS.t1542 VSS.t1541 sg13_lv_nmos ad=55.5f pd=0.74u as=0.1005p ps=1.34u w=0.15u l=0.13u
X1605 PH180.t70 6to4_0.buff_PI_d32_3.inv_PI_d32_0.VIN VDD.t716 VDD.t679 sg13_lv_pmos ad=0.1005p pd=1.34u as=55.5f ps=0.74u w=0.15u l=0.13u
X1606 CTRL 6ph_rosc_0.PH4.t10 CTRL VDD.t451 sg13_lv_pmos ad=0.19p pd=1.38u as=0 ps=0 w=1u l=0.13u
X1607 6to4_0.buff_PI_d32_1.inv_PI_d32_0.VIN 6to4_0.buff_PI_d32_1.inv_PI_d16$1_0.VIN VSS.t1885 VSS.t1884 sg13_lv_nmos ad=55.5f pd=0.74u as=0.1005p ps=1.34u w=0.15u l=0.13u
X1608 VDD.t590 6to4_0.buff_PI_d32_1.inv_PI_d32_0.VIN PH0.t71 VDD.t552 sg13_lv_pmos ad=55.5f pd=0.74u as=0.1005p ps=1.34u w=0.15u l=0.13u
X1609 VSS.t572 6to4_0.buff_PI_d32_0.inv_PI_d32_0.VIN PH90.t22 VSS.t571 sg13_lv_nmos ad=0.1005p pd=1.34u as=55.5f ps=0.74u w=0.15u l=0.13u
X1610 6ph_rosc_0.psdiff_2.buff_d8$1_0.VIN.t22 6ph_rosc_0.psdiff_2.CLKN VSS.t709 VSS.t491 sg13_lv_nmos ad=55.5f pd=0.74u as=55.5f ps=0.74u w=0.15u l=0.13u
X1611 VSS.t1003 6ph_rosc_0.buff_d8$1_0.inv_d2$1_0.VIN 6ph_rosc_0.buff_d8$1_0.inv_d4$1_0.VIN VSS.t1002 sg13_lv_nmos ad=0.1005p pd=1.34u as=55.5f ps=0.74u w=0.15u l=0.13u
X1612 6to4_0.buff_PI_d32_0.buff_PI_d16$1_0.inv_PI_d4$1_0.VOUT.t5 6to4_0.buff_PI_d32_0.buff_PI_d16$1_0.inv_PI_d4$1_0.VIN VDD.t63 VDD.t5 sg13_lv_pmos ad=55.5f pd=0.74u as=0.1005p ps=1.34u w=0.15u l=0.13u
X1613 6to4_0.buff_PI_d32_2.inv_PI_d32_0.VIN.t13 6to4_0.buff_PI_d32_2.inv_PI_d16$1_0.VIN.t52 VDD.t980 VDD.t198 sg13_lv_pmos ad=55.5f pd=0.74u as=0.1005p ps=1.34u w=0.15u l=0.13u
X1614 PH270.t64 6to4_0.buff_PI_d32_2.inv_PI_d32_0.VIN.t49 VDD.t203 VDD.t202 sg13_lv_pmos ad=55.5f pd=0.74u as=55.5f ps=0.74u w=0.15u l=0.13u
X1615 VSS.t749 6ph_rosc_0.buff_d8$1_4.inv_d8$1_0.VIN 6ph_rosc_0.PH3.t3 VSS.t748 sg13_lv_nmos ad=0.1005p pd=1.34u as=55.5f ps=0.74u w=0.15u l=0.13u
X1616 6ph_rosc_0.psdiff_2.buff_d8$1_1.inv_d2$1_0.VIN 6ph_rosc_0.psdiff_2.buff_d8$1_1.VIN.t32 VSS.t1682 VSS.t1681 sg13_lv_nmos ad=0.1005p pd=1.34u as=0.1005p ps=1.34u w=0.15u l=0.13u
X1617 VDD.t131 6to4_0.buff_PI_d32_2.buff_PI_d16$1_0.inv_PI_d4$1_0.VIN 6to4_0.buff_PI_d32_2.buff_PI_d16$1_0.inv_PI_d4$1_0.VOUT.t7 VDD.t126 sg13_lv_pmos ad=0.1005p pd=1.34u as=55.5f ps=0.74u w=0.15u l=0.13u
X1618 6ph_rosc_0.buff_d8$1_5.inv_d8$1_0.VIN 6ph_rosc_0.buff_d8$1_5.inv_d4$1_0.VIN VSS.t735 VSS.t734 sg13_lv_nmos ad=55.5f pd=0.74u as=0.1005p ps=1.34u w=0.15u l=0.13u
X1619 VDD.t929 6to4_0.buff_PI_d32_0.inv_PI_d16$1_0.VIN.t51 6to4_0.buff_PI_d32_0.inv_PI_d32_0.VIN VDD.t5 sg13_lv_pmos ad=55.5f pd=0.74u as=55.5f ps=0.74u w=0.15u l=0.13u
X1620 6to4_0.buff_PI_d32_2.inv_PI_d32_0.VIN.t42 6to4_0.buff_PI_d32_2.inv_PI_d16$1_0.VIN.t62 VSS.t1496 VSS.t1495 sg13_lv_nmos ad=55.5f pd=0.74u as=0.1005p ps=1.34u w=0.15u l=0.13u
X1621 6ph_rosc_0.PH1.t5 6ph_rosc_0.buff_d8$1_3.inv_d8$1_0.VIN VDD.t150 VDD.t75 sg13_lv_pmos ad=55.5f pd=0.74u as=0.1005p ps=1.34u w=0.15u l=0.13u
X1622 6ph_rosc_0.buff_d8$1_4.inv_d2$1_0.VIN 6ph_rosc_0.psdiff_2.VOUTDP VSS.t231 VSS.t230 sg13_lv_nmos ad=0.1005p pd=1.34u as=0.1005p ps=1.34u w=0.15u l=0.13u
X1623 6to4_0.buff_PI_d32_1.inv_PI_d32_0.VIN 6to4_0.buff_PI_d32_1.inv_PI_d16$1_0.VIN VDD.t1273 VDD.t173 sg13_lv_pmos ad=55.5f pd=0.74u as=55.5f ps=0.74u w=0.15u l=0.13u
X1624 VSS.t1699 6ph_rosc_0.psdiff_2.CLKP.t8 6ph_rosc_0.psdiff_2.buff_d8$1_1.VIN.t8 VSS.t1696 sg13_lv_nmos ad=55.5f pd=0.74u as=55.5f ps=0.74u w=0.15u l=0.13u
X1625 CTRL 6ph_rosc_0.PH0.t10 CTRL VDD.t57 sg13_lv_pmos ad=0.19p pd=1.38u as=0 ps=0 w=1u l=0.13u
X1626 6ph_rosc_0.psdiff_2.buff_d8$1_0.VIN.t21 6ph_rosc_0.psdiff_2.CLKN VSS.t698 VSS.t708 sg13_lv_nmos ad=55.5f pd=0.74u as=55.5f ps=0.74u w=0.15u l=0.13u
X1627 VSS.t484 6ph_rosc_0.buff_d8$1_1.inv_d8$1_0.VIN 6ph_rosc_0.PH5.t2 VSS.t483 sg13_lv_nmos ad=0.1005p pd=1.34u as=55.5f ps=0.74u w=0.15u l=0.13u
X1628 VDD.t210 6to4_0.buff_PI_d32_2.inv_PI_d32_0.VIN.t51 PH270.t63 VDD.t126 sg13_lv_pmos ad=55.5f pd=0.74u as=0.1005p ps=1.34u w=0.15u l=0.13u
X1629 PH90.t46 6to4_0.buff_PI_d32_0.inv_PI_d32_0.VIN VDD.t379 VDD.t343 sg13_lv_pmos ad=55.5f pd=0.74u as=55.5f ps=0.74u w=0.15u l=0.13u
X1630 VDD.t780 6to4_0.buff_PI_d32_2.buff_PI_d16$1_0.inv_PI_d8$1_0.VOUT.t25 6to4_0.buff_PI_d32_2.inv_PI_d16$1_0.VIN.t33 VDD.t126 sg13_lv_pmos ad=55.5f pd=0.74u as=0.1005p ps=1.34u w=0.15u l=0.13u
X1631 CTRL 6ph_rosc_0.PH3.t11 CTRL VDD.t57 sg13_lv_pmos ad=0.19p pd=1.38u as=0 ps=0 w=1u l=0.13u
X1632 VDD.t39 6to4_0.flywheel_clk_1.PH0 6to4_0.buff_PI_d32_1.buff_PI_d16$1_0.inv_PI_d4$1_0.VIN VDD.t17 sg13_lv_pmos ad=55.5f pd=0.74u as=55.5f ps=0.74u w=0.15u l=0.13u
X1633 VSS.t1692 6ph_rosc_0.psdiff_2.CLKP.t8 6ph_rosc_0.psdiff_2.buff_d8$1_1.VIN.t1 VSS.t1691 sg13_lv_nmos ad=55.5f pd=0.74u as=55.5f ps=0.74u w=0.15u l=0.13u
X1634 VDD.t890 6to4_0.buff_PI_d32_3.inv_PI_d16$1_0.VIN.t57 6to4_0.buff_PI_d32_3.inv_PI_d32_0.VIN VDD.t99 sg13_lv_pmos ad=0.1005p pd=1.34u as=55.5f ps=0.74u w=0.15u l=0.13u
X1635 6to4_0.buff_PI_d32_3.buff_PI_d16$1_0.inv_PI_d8$1_0.VOUT.t16 6to4_0.buff_PI_d32_3.buff_PI_d16$1_0.inv_PI_d4$1_0.VOUT.t15 VDD.t1038 VDD.t679 sg13_lv_pmos ad=0.1005p pd=1.34u as=55.5f ps=0.74u w=0.15u l=0.13u
X1636 VSS.t1883 6to4_0.buff_PI_d32_1.inv_PI_d16$1_0.VIN 6to4_0.buff_PI_d32_1.inv_PI_d32_0.VIN VSS.t1882 sg13_lv_nmos ad=0.1005p pd=1.34u as=55.5f ps=0.74u w=0.15u l=0.13u
X1637 VSS.t1598 6to4_0.buff_PI_d32_0.buff_PI_d16$1_0.inv_PI_d8$1_0.VOUT.t25 6to4_0.buff_PI_d32_0.inv_PI_d16$1_0.VIN.t3 VSS.t1597 sg13_lv_nmos ad=0.1005p pd=1.34u as=55.5f ps=0.74u w=0.15u l=0.13u
X1638 PH0.t70 6to4_0.buff_PI_d32_1.inv_PI_d32_0.VIN VDD.t589 VDD.t552 sg13_lv_pmos ad=55.5f pd=0.74u as=0.1005p ps=1.34u w=0.15u l=0.13u
X1639 VDD.t1017 6to4_0.buff_PI_d32_3.buff_PI_d16$1_0.inv_PI_d4$1_0.VOUT.t16 6to4_0.buff_PI_d32_3.buff_PI_d16$1_0.inv_PI_d8$1_0.VOUT.t15 VDD.t679 sg13_lv_pmos ad=0.1005p pd=1.34u as=55.5f ps=0.74u w=0.15u l=0.13u
X1640 PH270.t23 6to4_0.buff_PI_d32_2.inv_PI_d32_0.VIN.t61 VSS.t384 VSS.t383 sg13_lv_nmos ad=55.5f pd=0.74u as=0.1005p ps=1.34u w=0.15u l=0.13u
X1641 VSS.t1526 6to4_0.buff_PI_d32_3.buff_PI_d16$1_0.inv_PI_d4$1_0.VOUT.t14 6to4_0.buff_PI_d32_3.buff_PI_d16$1_0.inv_PI_d8$1_0.VOUT.t5 VSS.t1525 sg13_lv_nmos ad=0.1005p pd=1.34u as=55.5f ps=0.74u w=0.15u l=0.13u
X1642 6to4_0.buff_PI_d32_3.buff_PI_d16$1_0.inv_PI_d4$1_0.VIN 6to4_0.inv_PI_d2$1_2.VOUT VSS.t516 VSS.t515 sg13_lv_nmos ad=55.5f pd=0.74u as=0.1005p ps=1.34u w=0.15u l=0.13u
X1643 CTRL 6ph_rosc_0.PH5.t12 CTRL VDD.t87 sg13_lv_pmos ad=0.19p pd=1.38u as=0 ps=0 w=1u l=0.13u
X1644 VDD.t498 6ph_rosc_0.psdiff_0.buff_d8$1_1.inv_d8$1_0.VIN 6ph_rosc_0.psdiff_2.CLKP.t4 VDD.t0 sg13_lv_pmos ad=0.1005p pd=1.34u as=55.5f ps=0.74u w=0.15u l=0.13u
X1645 VDD.t1067 6ph_rosc_0.PH4.t12 6ph_rosc_0.PH1.t9 VDD.t917 sg13_lv_pmos ad=0.1005p pd=1.34u as=55.5f ps=0.74u w=0.15u l=0.13u
X1646 6to4_0.buff_PI_d32_0.inv_PI_d32_0.VIN 6to4_0.buff_PI_d32_0.inv_PI_d16$1_0.VIN.t63 VDD.t966 VDD.t341 sg13_lv_pmos ad=55.5f pd=0.74u as=0.1005p ps=1.34u w=0.15u l=0.13u
X1647 VSS.t416 6to4_0.buff_PI_d32_2.inv_PI_d32_0.VIN.t69 PH270.t22 VSS.t415 sg13_lv_nmos ad=0.1005p pd=1.34u as=55.5f ps=0.74u w=0.15u l=0.13u
X1648 VSS.t51 6ph_rosc_0.psdiff_0.buff_d8$1_0.inv_d2$1_0.VIN 6ph_rosc_0.psdiff_0.buff_d8$1_0.inv_d4$1_0.VIN VSS.t50 sg13_lv_nmos ad=0.1005p pd=1.34u as=55.5f ps=0.74u w=0.15u l=0.13u
X1649 VDD.t62 6to4_0.buff_PI_d32_0.buff_PI_d16$1_0.inv_PI_d4$1_0.VIN 6to4_0.buff_PI_d32_0.buff_PI_d16$1_0.inv_PI_d4$1_0.VOUT.t7 VDD.t5 sg13_lv_pmos ad=55.5f pd=0.74u as=0.1005p ps=1.34u w=0.15u l=0.13u
X1650 VSS.t707 6ph_rosc_0.psdiff_2.CLKN 6ph_rosc_0.psdiff_2.buff_d8$1_0.VIN.t20 VSS.t695 sg13_lv_nmos ad=55.5f pd=0.74u as=55.5f ps=0.74u w=0.15u l=0.13u
X1651 VDD.t1355 VSS.t1966 6ph_rosc_0.psdiff_2.buff_d8$1_0.VIN.t5 VDD.t470 sg13_lv_pmos ad=55.5f pd=0.74u as=55.5f ps=0.74u w=0.15u l=0.13u
X1652 6ph_rosc_0.psdiff_0.buff_d8$1_0.VIN.t15 a_10947_2194# VDD.t519 VDD.t503 sg13_lv_pmos ad=55.5f pd=0.74u as=55.5f ps=0.74u w=0.15u l=0.13u
X1653 CTRL 6ph_rosc_0.PH5.t12 CTRL VDD.t85 sg13_lv_pmos ad=0.19p pd=1.38u as=0 ps=0 w=1u l=0.13u
X1654 VSS.t729 6ph_rosc_0.psdiff_2.CLKP.t8 6ph_rosc_0.psdiff_2.buff_d8$1_1.VIN.t7 VSS.t1683 sg13_lv_nmos ad=55.5f pd=0.74u as=55.5f ps=0.74u w=0.15u l=0.13u
X1655 VDD.t1354 VSS.t1966 6ph_rosc_0.psdiff_2.buff_d8$1_0.VIN.t1 VDD.t470 sg13_lv_pmos ad=55.5f pd=0.74u as=55.5f ps=0.74u w=0.15u l=0.13u
X1656 CTRL 6ph_rosc_0.PH4.t10 CTRL VDD.t451 sg13_lv_pmos ad=0.19p pd=1.38u as=0 ps=0 w=1u l=0.13u
X1657 6to4_0.buff_PI_d32_3.inv_PI_d32_0.VIN 6to4_0.buff_PI_d32_3.inv_PI_d16$1_0.VIN.t50 VDD.t869 VDD.t99 sg13_lv_pmos ad=0.1005p pd=1.34u as=55.5f ps=0.74u w=0.15u l=0.13u
X1658 VSS.t706 6ph_rosc_0.psdiff_2.CLKN 6ph_rosc_0.psdiff_2.buff_d8$1_0.VIN.t19 VSS.t693 sg13_lv_nmos ad=55.5f pd=0.74u as=55.5f ps=0.74u w=0.15u l=0.13u
X1659 6to4_0.inv_PI_d2$1_3.VOUT 6ph_rosc_0.PH3.t10 VDD.t1247 VDD.t99 sg13_lv_pmos ad=0.1005p pd=1.34u as=55.5f ps=0.74u w=0.15u l=0.13u
X1660 VDD.t378 6to4_0.buff_PI_d32_0.inv_PI_d32_0.VIN PH90.t64 VDD.t343 sg13_lv_pmos ad=55.5f pd=0.74u as=55.5f ps=0.74u w=0.15u l=0.13u
X1661 VDD.t715 6to4_0.buff_PI_d32_3.inv_PI_d32_0.VIN PH180.t69 VDD.t99 sg13_lv_pmos ad=0.1005p pd=1.34u as=55.5f ps=0.74u w=0.15u l=0.13u
X1662 PH0.t21 6to4_0.buff_PI_d32_1.inv_PI_d32_0.VIN VSS.t891 VSS.t890 sg13_lv_nmos ad=55.5f pd=0.74u as=0.1005p ps=1.34u w=0.15u l=0.13u
X1663 6to4_0.buff_PI_d32_0.buff_PI_d16$1_0.inv_PI_d4$1_0.VIN 6to4_0.flywheel_clk_0.PH0 VDD.t12 VDD.t5 sg13_lv_pmos ad=0.1005p pd=1.34u as=55.5f ps=0.74u w=0.15u l=0.13u
X1664 6to4_0.buff_PI_d32_1.buff_PI_d16$1_0.inv_PI_d4$1_0.VIN 6to4_0.flywheel_clk_1.PH0 VDD.t41 VDD.t17 sg13_lv_pmos ad=55.5f pd=0.74u as=55.5f ps=0.74u w=0.15u l=0.13u
X1665 6ph_rosc_0.psdiff_0.buff_d8$1_1.inv_d8$1_0.VIN 6ph_rosc_0.psdiff_0.buff_d8$1_1.inv_d4$1_0.VIN VDD.t297 VDD.t0 sg13_lv_pmos ad=55.5f pd=0.74u as=0.1005p ps=1.34u w=0.15u l=0.13u
X1666 PH270.t62 6to4_0.buff_PI_d32_2.inv_PI_d32_0.VIN.t67 VDD.t259 VDD.t198 sg13_lv_pmos ad=0.1005p pd=1.34u as=55.5f ps=0.74u w=0.15u l=0.13u
X1667 VSS.t1751 6to4_0.buff_PI_d32_1.buff_PI_d16$1_0.inv_PI_d8$1_0.VOUT.t37 6to4_0.buff_PI_d32_1.inv_PI_d16$1_0.VIN VSS.t1750 sg13_lv_nmos ad=0.1005p pd=1.34u as=55.5f ps=0.74u w=0.15u l=0.13u
X1668 6to4_0.buff_PI_d32_3.inv_PI_d16$1_0.VIN.t36 6to4_0.buff_PI_d32_3.buff_PI_d16$1_0.inv_PI_d8$1_0.VOUT.t36 VSS.t1837 VSS.t1836 sg13_lv_nmos ad=55.5f pd=0.74u as=0.1005p ps=1.34u w=0.15u l=0.13u
X1669 PH180.t21 6to4_0.buff_PI_d32_3.inv_PI_d32_0.VIN VSS.t1051 VSS.t1050 sg13_lv_nmos ad=55.5f pd=0.74u as=0.1005p ps=1.34u w=0.15u l=0.13u
X1670 PH0.t20 6to4_0.buff_PI_d32_1.inv_PI_d32_0.VIN VSS.t889 VSS.t888 sg13_lv_nmos ad=55.5f pd=0.74u as=0.1005p ps=1.34u w=0.15u l=0.13u
X1671 VDD.t794 6to4_0.buff_PI_d32_2.buff_PI_d16$1_0.inv_PI_d8$1_0.VOUT.t30 6to4_0.buff_PI_d32_2.inv_PI_d16$1_0.VIN.t32 VDD.t198 sg13_lv_pmos ad=55.5f pd=0.74u as=55.5f ps=0.74u w=0.15u l=0.13u
X1672 VDD.t526 6ph_rosc_0.buff_d8$1_4.inv_d2$1_0.VIN 6ph_rosc_0.buff_d8$1_4.inv_d4$1_0.VIN VDD.t75 sg13_lv_pmos ad=0.1005p pd=1.34u as=55.5f ps=0.74u w=0.15u l=0.13u
X1673 VSS.t412 6to4_0.buff_PI_d32_2.inv_PI_d32_0.VIN.t68 PH270.t21 VSS.t411 sg13_lv_nmos ad=0.1005p pd=1.34u as=55.5f ps=0.74u w=0.15u l=0.13u
X1674 PH270.t61 6to4_0.buff_PI_d32_2.inv_PI_d32_0.VIN.t71 VDD.t271 VDD.t215 sg13_lv_pmos ad=0.1005p pd=1.34u as=55.5f ps=0.74u w=0.15u l=0.13u
X1675 VDD.t1231 6to4_0.buff_PI_d32_3.buff_PI_d16$1_0.inv_PI_d8$1_0.VOUT.t35 6to4_0.buff_PI_d32_3.inv_PI_d16$1_0.VIN.t34 VDD.t679 sg13_lv_pmos ad=55.5f pd=0.74u as=55.5f ps=0.74u w=0.15u l=0.13u
X1676 6to4_0.buff_PI_d32_0.inv_PI_d16$1_0.VIN.t33 6to4_0.buff_PI_d32_0.buff_PI_d16$1_0.inv_PI_d8$1_0.VOUT.t35 VSS.t1640 VSS.t1639 sg13_lv_nmos ad=55.5f pd=0.74u as=0.1005p ps=1.34u w=0.15u l=0.13u
X1677 PH90.t21 6to4_0.buff_PI_d32_0.inv_PI_d32_0.VIN VSS.t570 VSS.t569 sg13_lv_nmos ad=55.5f pd=0.74u as=0.1005p ps=1.34u w=0.15u l=0.13u
X1678 VDD.t779 6to4_0.buff_PI_d32_2.buff_PI_d16$1_0.inv_PI_d8$1_0.VOUT.t25 6to4_0.buff_PI_d32_2.inv_PI_d16$1_0.VIN.t31 VDD.t126 sg13_lv_pmos ad=0.1005p pd=1.34u as=55.5f ps=0.74u w=0.15u l=0.13u
X1679 6ph_rosc_0.PH5.t1 6ph_rosc_0.buff_d8$1_1.inv_d8$1_0.VIN VSS.t482 VSS.t481 sg13_lv_nmos ad=55.5f pd=0.74u as=0.1005p ps=1.34u w=0.15u l=0.13u
X1680 CTRL 6ph_rosc_0.PH4.t10 CTRL VDD.t451 sg13_lv_pmos ad=0.19p pd=1.38u as=0 ps=0 w=1u l=0.13u
X1681 VDD.t1167 6to4_0.buff_PI_d32_1.buff_PI_d16$1_0.inv_PI_d8$1_0.VOUT.t33 6to4_0.buff_PI_d32_1.inv_PI_d16$1_0.VIN VDD.t173 sg13_lv_pmos ad=0.1005p pd=1.34u as=55.5f ps=0.74u w=0.15u l=0.13u
X1682 PH90.t43 6to4_0.buff_PI_d32_0.inv_PI_d32_0.VIN VDD.t377 VDD.t5 sg13_lv_pmos ad=55.5f pd=0.74u as=0.1005p ps=1.34u w=0.15u l=0.13u
X1683 PH180.t68 6to4_0.buff_PI_d32_3.inv_PI_d32_0.VIN VDD.t714 VDD.t677 sg13_lv_pmos ad=55.5f pd=0.74u as=0.1005p ps=1.34u w=0.15u l=0.13u
X1684 VDD.t849 6to4_0.buff_PI_d32_0.buff_PI_d16$1_0.inv_PI_d4$1_0.VOUT.t17 6to4_0.buff_PI_d32_0.buff_PI_d16$1_0.inv_PI_d8$1_0.VOUT.t17 VDD.t341 sg13_lv_pmos ad=55.5f pd=0.74u as=55.5f ps=0.74u w=0.15u l=0.13u
X1685 VDD.t209 6to4_0.buff_PI_d32_2.inv_PI_d32_0.VIN.t51 PH270.t60 VDD.t126 sg13_lv_pmos ad=0.1005p pd=1.34u as=55.5f ps=0.74u w=0.15u l=0.13u
X1686 CTRL 6ph_rosc_0.PH0.t10 CTRL VDD.t57 sg13_lv_pmos ad=0.19p pd=1.38u as=0 ps=0 w=1u l=0.13u
X1687 6to4_0.buff_PI_d32_3.inv_PI_d16$1_0.VIN.t8 6to4_0.buff_PI_d32_3.buff_PI_d16$1_0.inv_PI_d8$1_0.VOUT.t26 VDD.t1205 VDD.t99 sg13_lv_pmos ad=0.1005p pd=1.34u as=55.5f ps=0.74u w=0.15u l=0.13u
X1688 VSS.t45 6ph_rosc_0.psdiff_2.buff_d8$1_1.inv_d4$1_0.VIN 6ph_rosc_0.psdiff_2.buff_d8$1_1.inv_d8$1_0.VIN VSS.t44 sg13_lv_nmos ad=0.1005p pd=1.34u as=55.5f ps=0.74u w=0.15u l=0.13u
X1689 VDD.t588 6to4_0.buff_PI_d32_1.inv_PI_d32_0.VIN PH0.t69 VDD.t173 sg13_lv_pmos ad=55.5f pd=0.74u as=0.1005p ps=1.34u w=0.15u l=0.13u
X1690 6to4_0.flywheel_clk_1.PH0 6to4_0.inv_PI_d2$1_1.VIN VDD.t491 VDD.t17 sg13_lv_pmos ad=55.5f pd=0.74u as=0.1005p ps=1.34u w=0.15u l=0.13u
X1691 VDD.t713 6to4_0.buff_PI_d32_3.inv_PI_d32_0.VIN PH180.t37 VDD.t99 sg13_lv_pmos ad=55.5f pd=0.74u as=55.5f ps=0.74u w=0.15u l=0.13u
X1692 6to4_0.flywheel_clk_1.PH0 6to4_0.inv_PI_d2$1_1.VIN VSS.t765 VSS.t764 sg13_lv_nmos ad=55.5f pd=0.74u as=0.1005p ps=1.34u w=0.15u l=0.13u
X1693 6to4_0.buff_PI_d32_3.inv_PI_d16$1_0.VIN.t11 6to4_0.buff_PI_d32_3.buff_PI_d16$1_0.inv_PI_d8$1_0.VOUT.t27 VDD.t1207 VDD.t679 sg13_lv_pmos ad=55.5f pd=0.74u as=55.5f ps=0.74u w=0.15u l=0.13u
X1694 6to4_0.buff_PI_d32_0.buff_PI_d16$1_0.inv_PI_d8$1_0.VOUT.t0 6to4_0.buff_PI_d32_0.buff_PI_d16$1_0.inv_PI_d4$1_0.VOUT.t12 VSS.t1256 VSS.t1255 sg13_lv_nmos ad=55.5f pd=0.74u as=0.1005p ps=1.34u w=0.15u l=0.13u
X1695 6ph_rosc_0.psdiff_0.buff_d8$1_1.VIN.t9 VSS.t1965 VDD.t1308 VDD.t503 sg13_lv_pmos ad=55.5f pd=0.74u as=55.5f ps=0.74u w=0.15u l=0.13u
X1696 VSS.t568 6to4_0.buff_PI_d32_0.inv_PI_d32_0.VIN PH90.t20 VSS.t567 sg13_lv_nmos ad=0.1005p pd=1.34u as=55.5f ps=0.74u w=0.15u l=0.13u
X1697 VDD.t307 a_7973_2194# 6ph_rosc_0.psdiff_1.buff_d8$1_0.VIN.t29 VDD.t301 sg13_lv_pmos ad=55.5f pd=0.74u as=55.5f ps=0.74u w=0.15u l=0.13u
X1698 CTRL 6ph_rosc_0.PH2.t10 CTRL VDD.t440 sg13_lv_pmos ad=0.19p pd=1.38u as=0 ps=0 w=1u l=0.13u
X1699 VSS.t1807 6to4_0.buff_PI_d32_3.buff_PI_d16$1_0.inv_PI_d8$1_0.VOUT.t28 6to4_0.buff_PI_d32_3.inv_PI_d16$1_0.VIN.t12 VSS.t1806 sg13_lv_nmos ad=0.1005p pd=1.34u as=55.5f ps=0.74u w=0.15u l=0.13u
X1700 PH90.t63 6to4_0.buff_PI_d32_0.inv_PI_d32_0.VIN VDD.t376 VDD.t347 sg13_lv_pmos ad=0.1005p pd=1.34u as=55.5f ps=0.74u w=0.15u l=0.13u
X1701 PH0.t11 6to4_0.buff_PI_d32_1.inv_PI_d32_0.VIN VSS.t887 VSS.t886 sg13_lv_nmos ad=55.5f pd=0.74u as=0.1005p ps=1.34u w=0.15u l=0.13u
X1702 VDD.t948 6to4_0.buff_PI_d32_0.inv_PI_d16$1_0.VIN.t57 6to4_0.buff_PI_d32_0.inv_PI_d32_0.VIN VDD.t5 sg13_lv_pmos ad=0.1005p pd=1.34u as=55.5f ps=0.74u w=0.15u l=0.13u
X1703 6to4_0.buff_PI_d32_2.inv_PI_d16$1_0.VIN.t30 6to4_0.buff_PI_d32_2.buff_PI_d16$1_0.inv_PI_d8$1_0.VOUT.t24 VDD.t776 VDD.t198 sg13_lv_pmos ad=55.5f pd=0.74u as=55.5f ps=0.74u w=0.15u l=0.13u
X1704 VSS.t239 6ph_rosc_0.psdiff_2.VOUTDN 6ph_rosc_0.psdiff_1.buff_d8$1_1.VIN.t20 VSS.t1152 sg13_lv_nmos ad=55.5f pd=0.74u as=55.5f ps=0.74u w=0.15u l=0.13u
X1705 VDD.t1261 6to4_0.buff_PI_d32_1.inv_PI_d16$1_0.VIN 6to4_0.buff_PI_d32_1.inv_PI_d32_0.VIN VDD.t17 sg13_lv_pmos ad=55.5f pd=0.74u as=55.5f ps=0.74u w=0.15u l=0.13u
X1706 VSS.t801 6ph_rosc_0.psdiff_2.buff_d8$1_1.inv_d8$1_0.VIN 6ph_rosc_0.psdiff_2.VOUTDN VSS.t800 sg13_lv_nmos ad=0.1005p pd=1.34u as=55.5f ps=0.74u w=0.15u l=0.13u
X1707 VSS.t676 6ph_rosc_0.buff_d8$1_2.inv_d8$1_0.VIN 6ph_rosc_0.PH4.t5 VSS.t675 sg13_lv_nmos ad=0.1005p pd=1.34u as=55.5f ps=0.74u w=0.15u l=0.13u
X1708 VDD.t306 a_7973_2194# 6ph_rosc_0.psdiff_1.buff_d8$1_0.VIN.t26 VDD.t301 sg13_lv_pmos ad=55.5f pd=0.74u as=55.5f ps=0.74u w=0.15u l=0.13u
X1709 VDD.t875 6to4_0.buff_PI_d32_3.inv_PI_d16$1_0.VIN.t52 6to4_0.buff_PI_d32_3.inv_PI_d32_0.VIN VDD.t99 sg13_lv_pmos ad=55.5f pd=0.74u as=0.1005p ps=1.34u w=0.15u l=0.13u
X1710 6to4_0.buff_PI_d32_2.inv_PI_d16$1_0.VIN.t6 6to4_0.buff_PI_d32_2.buff_PI_d16$1_0.inv_PI_d8$1_0.VOUT.t38 VSS.t1236 VSS.t1235 sg13_lv_nmos ad=55.5f pd=0.74u as=0.1005p ps=1.34u w=0.15u l=0.13u
X1711 VSS.t1438 6to4_0.buff_PI_d32_2.inv_PI_d16$1_0.VIN.t48 6to4_0.buff_PI_d32_2.inv_PI_d32_0.VIN.t0 VSS.t1437 sg13_lv_nmos ad=0.1005p pd=1.34u as=55.5f ps=0.74u w=0.15u l=0.13u
X1712 VSS.t229 6ph_rosc_0.psdiff_2.VOUTDP 6ph_rosc_0.psdiff_1.buff_d8$1_0.VIN.t12 VSS.t228 sg13_lv_nmos ad=55.5f pd=0.74u as=55.5f ps=0.74u w=0.15u l=0.13u
X1713 6ph_rosc_0.PH4.t4 6ph_rosc_0.buff_d8$1_2.inv_d8$1_0.VIN VSS.t674 VSS.t673 sg13_lv_nmos ad=55.5f pd=0.74u as=0.1005p ps=1.34u w=0.15u l=0.13u
X1714 6ph_rosc_0.buff_d8$1_5.inv_d4$1_0.VIN 6ph_rosc_0.buff_d8$1_5.inv_d2$1_0.VIN VSS.t510 VSS.t509 sg13_lv_nmos ad=55.5f pd=0.74u as=0.1005p ps=1.34u w=0.15u l=0.13u
X1715 6to4_0.buff_PI_d32_2.inv_PI_d16$1_0.VIN.t29 6to4_0.buff_PI_d32_2.buff_PI_d16$1_0.inv_PI_d8$1_0.VOUT.t27 VDD.t786 VDD.t126 sg13_lv_pmos ad=0.1005p pd=1.34u as=55.5f ps=0.74u w=0.15u l=0.13u
X1716 PH90.t19 6to4_0.buff_PI_d32_0.inv_PI_d32_0.VIN VSS.t566 VSS.t565 sg13_lv_nmos ad=55.5f pd=0.74u as=0.1005p ps=1.34u w=0.15u l=0.13u
X1717 CTRL 6ph_rosc_0.PH2.t10 CTRL VDD.t440 sg13_lv_pmos ad=0.19p pd=1.38u as=0 ps=0 w=1u l=0.13u
X1718 VSS.t1378 6to4_0.buff_PI_d32_0.inv_PI_d16$1_0.VIN.t49 6to4_0.buff_PI_d32_0.inv_PI_d32_0.VIN VSS.t1377 sg13_lv_nmos ad=0.1005p pd=1.34u as=55.5f ps=0.74u w=0.15u l=0.13u
X1719 6to4_0.buff_PI_d32_1.inv_PI_d16$1_0.VIN 6to4_0.buff_PI_d32_1.buff_PI_d16$1_0.inv_PI_d8$1_0.VOUT.t28 VDD.t1166 VDD.t173 sg13_lv_pmos ad=0.1005p pd=1.34u as=55.5f ps=0.74u w=0.15u l=0.13u
X1720 PH270.t44 6to4_0.buff_PI_d32_2.inv_PI_d32_0.VIN.t48 VDD.t200 VDD.t198 sg13_lv_pmos ad=55.5f pd=0.74u as=55.5f ps=0.74u w=0.15u l=0.13u
X1721 6ph_rosc_0.psdiff_1.buff_d8$1_1.VIN.t27 6ph_rosc_0.psdiff_2.VOUTDN VSS.t1151 VSS.t1148 sg13_lv_nmos ad=55.5f pd=0.74u as=55.5f ps=0.74u w=0.15u l=0.13u
X1722 VDD.t2 6ph_rosc_0.psdiff_1.buff_d8$1_1.inv_d4$1_0.VIN 6ph_rosc_0.psdiff_1.buff_d8$1_1.inv_d8$1_0.VIN VDD.t0 sg13_lv_pmos ad=0.1005p pd=1.34u as=55.5f ps=0.74u w=0.15u l=0.13u
X1723 VDD.t1318 VSS.t1965 6ph_rosc_0.psdiff_0.buff_d8$1_0.VIN.t0 VDD.t503 sg13_lv_pmos ad=55.5f pd=0.74u as=55.5f ps=0.74u w=0.15u l=0.13u
X1724 6to4_0.buff_PI_d32_0.buff_PI_d16$1_0.inv_PI_d8$1_0.VOUT.t10 6to4_0.buff_PI_d32_0.buff_PI_d16$1_0.inv_PI_d4$1_0.VOUT.t15 VDD.t843 VDD.t341 sg13_lv_pmos ad=55.5f pd=0.74u as=55.5f ps=0.74u w=0.15u l=0.13u
X1725 VDD.t105 6to4_0.buff_PI_d32_3.buff_PI_d16$1_0.inv_PI_d4$1_0.VIN 6to4_0.buff_PI_d32_3.buff_PI_d16$1_0.inv_PI_d4$1_0.VOUT.t9 VDD.t99 sg13_lv_pmos ad=55.5f pd=0.74u as=55.5f ps=0.74u w=0.15u l=0.13u
X1726 VSS.t462 6ph_rosc_0.psdiff_0.buff_d8$1_1.inv_d4$1_0.VIN 6ph_rosc_0.psdiff_0.buff_d8$1_1.inv_d8$1_0.VIN VSS.t461 sg13_lv_nmos ad=0.1005p pd=1.34u as=55.5f ps=0.74u w=0.15u l=0.13u
X1727 6to4_0.buff_PI_d32_3.buff_PI_d16$1_0.inv_PI_d4$1_0.VIN 6to4_0.inv_PI_d2$1_2.VOUT VDD.t336 VDD.t99 sg13_lv_pmos ad=55.5f pd=0.74u as=55.5f ps=0.74u w=0.15u l=0.13u
X1728 VDD.t505 a_12104_2338# 6ph_rosc_0.psdiff_0.buff_d8$1_1.VIN.t13 VDD.t503 sg13_lv_pmos ad=55.5f pd=0.74u as=55.5f ps=0.74u w=0.15u l=0.13u
X1729 PH180.t67 6to4_0.buff_PI_d32_3.inv_PI_d32_0.VIN VDD.t687 VDD.t677 sg13_lv_pmos ad=0.1005p pd=1.34u as=55.5f ps=0.74u w=0.15u l=0.13u
X1730 6to4_0.buff_PI_d32_0.inv_PI_d32_0.VIN 6to4_0.buff_PI_d32_0.inv_PI_d16$1_0.VIN.t52 VDD.t933 VDD.t5 sg13_lv_pmos ad=0.1005p pd=1.34u as=55.5f ps=0.74u w=0.15u l=0.13u
X1731 6to4_0.buff_PI_d32_1.buff_PI_d16$1_0.inv_PI_d8$1_0.VOUT.t2 6to4_0.buff_PI_d32_1.buff_PI_d16$1_0.inv_PI_d4$1_0.VOUT.t12 VSS.t300 VSS.t299 sg13_lv_nmos ad=55.5f pd=0.74u as=0.1005p ps=1.34u w=0.15u l=0.13u
X1732 6to4_0.inv_PI_d2$1_2.VOUT 6to4_0.inv_PI_d2$1_3.VOUT VDD.t326 VDD.t99 sg13_lv_pmos ad=55.5f pd=0.74u as=0.1005p ps=1.34u w=0.15u l=0.13u
X1733 6ph_rosc_0.psdiff_1.buff_d8$1_0.VIN.t22 VSS.t1967 VDD.t1398 VDD.t301 sg13_lv_pmos ad=55.5f pd=0.74u as=55.5f ps=0.74u w=0.15u l=0.13u
X1734 VDD.t1271 6to4_0.buff_PI_d32_1.inv_PI_d16$1_0.VIN 6to4_0.buff_PI_d32_1.inv_PI_d32_0.VIN VDD.t17 sg13_lv_pmos ad=55.5f pd=0.74u as=0.1005p ps=1.34u w=0.15u l=0.13u
X1735 6ph_rosc_0.psdiff_2.CLKP.t6 6ph_rosc_0.psdiff_0.buff_d8$1_1.inv_d8$1_0.VIN VDD.t497 VDD.t0 sg13_lv_pmos ad=55.5f pd=0.74u as=0.1005p ps=1.34u w=0.15u l=0.13u
X1736 VSS.t564 6to4_0.buff_PI_d32_0.inv_PI_d32_0.VIN PH90.t18 VSS.t563 sg13_lv_nmos ad=0.1005p pd=1.34u as=55.5f ps=0.74u w=0.15u l=0.13u
X1737 PH90.t62 6to4_0.buff_PI_d32_0.inv_PI_d32_0.VIN VDD.t375 VDD.t343 sg13_lv_pmos ad=55.5f pd=0.74u as=0.1005p ps=1.34u w=0.15u l=0.13u
X1738 VDD.t61 6to4_0.buff_PI_d32_0.buff_PI_d16$1_0.inv_PI_d4$1_0.VIN 6to4_0.buff_PI_d32_0.buff_PI_d16$1_0.inv_PI_d4$1_0.VOUT.t6 VDD.t5 sg13_lv_pmos ad=55.5f pd=0.74u as=55.5f ps=0.74u w=0.15u l=0.13u
X1739 VDD.t22 6to4_0.buff_PI_d32_1.buff_PI_d16$1_0.inv_PI_d4$1_0.VIN 6to4_0.buff_PI_d32_1.buff_PI_d16$1_0.inv_PI_d4$1_0.VOUT.t8 VDD.t17 sg13_lv_pmos ad=55.5f pd=0.74u as=0.1005p ps=1.34u w=0.15u l=0.13u
X1740 6ph_rosc_0.psdiff_0.buff_d8$1_1.VIN.t22 6ph_rosc_0.psdiff_1.VOUTDN VSS.t1933 VSS.t1943 sg13_lv_nmos ad=55.5f pd=0.74u as=55.5f ps=0.74u w=0.15u l=0.13u
X1741 6ph_rosc_0.psdiff_1.VOUTDP 6ph_rosc_0.psdiff_1.buff_d8$1_0.inv_d8$1_0.VIN VSS.t981 VSS.t980 sg13_lv_nmos ad=55.5f pd=0.74u as=0.1005p ps=1.34u w=0.15u l=0.13u
X1742 6ph_rosc_0.psdiff_2.buff_d8$1_0.inv_d4$1_0.VIN 6ph_rosc_0.psdiff_2.buff_d8$1_0.inv_d2$1_0.VIN VSS.t282 VSS.t281 sg13_lv_nmos ad=55.5f pd=0.74u as=0.1005p ps=1.34u w=0.15u l=0.13u
X1743 6ph_rosc_0.psdiff_0.buff_d8$1_0.VIN.t29 6ph_rosc_0.psdiff_1.VOUTDP VSS.t826 VSS.t822 sg13_lv_nmos ad=55.5f pd=0.74u as=55.5f ps=0.74u w=0.15u l=0.13u
X1744 VSS.t1470 6to4_0.buff_PI_d32_2.inv_PI_d16$1_0.VIN.t56 6to4_0.buff_PI_d32_2.inv_PI_d32_0.VIN.t24 VSS.t1469 sg13_lv_nmos ad=0.1005p pd=1.34u as=55.5f ps=0.74u w=0.15u l=0.13u
X1745 VDD.t212 6to4_0.buff_PI_d32_2.inv_PI_d32_0.VIN.t52 PH270.t59 VDD.t198 sg13_lv_pmos ad=55.5f pd=0.74u as=55.5f ps=0.74u w=0.15u l=0.13u
X1746 6ph_rosc_0.psdiff_1.VOUTDN 6ph_rosc_0.psdiff_1.buff_d8$1_1.inv_d8$1_0.VIN VSS.t268 VSS.t267 sg13_lv_nmos ad=55.5f pd=0.74u as=0.1005p ps=1.34u w=0.15u l=0.13u
X1747 6to4_0.buff_PI_d32_0.buff_PI_d16$1_0.inv_PI_d8$1_0.VOUT.t5 6to4_0.buff_PI_d32_0.buff_PI_d16$1_0.inv_PI_d4$1_0.VOUT.t13 VDD.t838 VDD.t341 sg13_lv_pmos ad=55.5f pd=0.74u as=0.1005p ps=1.34u w=0.15u l=0.13u
X1748 VDD.t711 6to4_0.buff_PI_d32_3.inv_PI_d32_0.VIN PH180.t35 VDD.t677 sg13_lv_pmos ad=0.1005p pd=1.34u as=55.5f ps=0.74u w=0.15u l=0.13u
X1749 6ph_rosc_0.PH5.t0 6ph_rosc_0.buff_d8$1_1.inv_d8$1_0.VIN VSS.t480 VSS.t479 sg13_lv_nmos ad=55.5f pd=0.74u as=0.1005p ps=1.34u w=0.15u l=0.13u
X1750 VDD.t587 6to4_0.buff_PI_d32_1.inv_PI_d32_0.VIN PH0.t68 VDD.t173 sg13_lv_pmos ad=0.1005p pd=1.34u as=55.5f ps=0.74u w=0.15u l=0.13u
X1751 PH180.t66 6to4_0.buff_PI_d32_3.inv_PI_d32_0.VIN VDD.t710 VDD.t677 sg13_lv_pmos ad=0.1005p pd=1.34u as=55.5f ps=0.74u w=0.15u l=0.13u
X1752 PH0.t67 6to4_0.buff_PI_d32_1.inv_PI_d32_0.VIN VDD.t586 VDD.t547 sg13_lv_pmos ad=55.5f pd=0.74u as=55.5f ps=0.74u w=0.15u l=0.13u
X1753 6to4_0.flywheel_clk_1.PH0 6to4_0.inv_PI_d2$1_1.VIN VDD.t490 VDD.t17 sg13_lv_pmos ad=0.1005p pd=1.34u as=55.5f ps=0.74u w=0.15u l=0.13u
X1754 VDD.t709 6to4_0.buff_PI_d32_3.inv_PI_d32_0.VIN PH180.t65 VDD.t673 sg13_lv_pmos ad=55.5f pd=0.74u as=0.1005p ps=1.34u w=0.15u l=0.13u
X1755 VDD.t953 6to4_0.buff_PI_d32_0.inv_PI_d16$1_0.VIN.t59 6to4_0.buff_PI_d32_0.inv_PI_d32_0.VIN VDD.t341 sg13_lv_pmos ad=55.5f pd=0.74u as=55.5f ps=0.74u w=0.15u l=0.13u
X1756 6ph_rosc_0.PH4.t7 6ph_rosc_0.buff_d8$1_2.inv_d8$1_0.VIN VDD.t450 VDD.t330 sg13_lv_pmos ad=55.5f pd=0.74u as=0.1005p ps=1.34u w=0.15u l=0.13u
X1757 CTRL 6ph_rosc_0.PH1.t10 CTRL VDD.t80 sg13_lv_pmos ad=0.19p pd=1.38u as=0 ps=0 w=1u l=0.13u
X1758 6to4_0.buff_PI_d32_3.inv_PI_d16$1_0.VIN.t20 6to4_0.buff_PI_d32_3.buff_PI_d16$1_0.inv_PI_d8$1_0.VOUT.t30 VDD.t1217 VDD.t99 sg13_lv_pmos ad=55.5f pd=0.74u as=0.1005p ps=1.34u w=0.15u l=0.13u
X1759 6ph_rosc_0.psdiff_0.buff_d8$1_0.VIN.t28 6ph_rosc_0.psdiff_1.VOUTDP VSS.t811 VSS.t825 sg13_lv_nmos ad=55.5f pd=0.74u as=55.5f ps=0.74u w=0.15u l=0.13u
X1760 6ph_rosc_0.psdiff_0.buff_d8$1_1.VIN.t8 VSS.t1965 VDD.t1317 VDD.t503 sg13_lv_pmos ad=55.5f pd=0.74u as=55.5f ps=0.74u w=0.15u l=0.13u
X1761 CTRL 6ph_rosc_0.PH2.t10 CTRL VDD.t440 sg13_lv_pmos ad=0.19p pd=1.38u as=0 ps=0 w=1u l=0.13u
X1762 PH90.t17 6to4_0.buff_PI_d32_0.inv_PI_d32_0.VIN VSS.t562 VSS.t561 sg13_lv_nmos ad=55.5f pd=0.74u as=0.1005p ps=1.34u w=0.15u l=0.13u
X1763 VSS.t885 6to4_0.buff_PI_d32_1.inv_PI_d32_0.VIN PH0.t19 VSS.t884 sg13_lv_nmos ad=0.1005p pd=1.34u as=55.5f ps=0.74u w=0.15u l=0.13u
X1764 CTRL 6ph_rosc_0.PH3.t11 CTRL VDD.t330 sg13_lv_pmos ad=0.19p pd=1.38u as=0 ps=0 w=1u l=0.13u
X1765 VSS.t1346 6to4_0.buff_PI_d32_3.inv_PI_d16$1_0.VIN.t60 6to4_0.buff_PI_d32_3.inv_PI_d32_0.VIN VSS.t1345 sg13_lv_nmos ad=0.1005p pd=1.34u as=55.5f ps=0.74u w=0.15u l=0.13u
X1766 6to4_0.buff_PI_d32_1.inv_PI_d32_0.VIN 6to4_0.buff_PI_d32_1.inv_PI_d16$1_0.VIN VDD.t1270 VDD.t173 sg13_lv_pmos ad=0.1005p pd=1.34u as=55.5f ps=0.74u w=0.15u l=0.13u
X1767 6to4_0.PI_clk_0.inv_PI_d2$1_0.VOUT 6ph_rosc_0.PH1.t11 VSS.t1364 VSS.t1363 sg13_lv_nmos ad=55.5f pd=0.74u as=0.1005p ps=1.34u w=0.15u l=0.13u
X1768 PH270.t20 6to4_0.buff_PI_d32_2.inv_PI_d32_0.VIN.t76 VSS.t444 VSS.t443 sg13_lv_nmos ad=55.5f pd=0.74u as=0.1005p ps=1.34u w=0.15u l=0.13u
X1769 CTRL 6ph_rosc_0.PH2.t10 CTRL VDD.t440 sg13_lv_pmos ad=0.19p pd=1.38u as=0 ps=0 w=1u l=0.13u
X1770 6to4_0.buff_PI_d32_3.inv_PI_d32_0.VIN 6to4_0.buff_PI_d32_3.inv_PI_d16$1_0.VIN.t55 VSS.t1326 VSS.t1325 sg13_lv_nmos ad=55.5f pd=0.74u as=0.1005p ps=1.34u w=0.15u l=0.13u
X1771 VDD.t222 6to4_0.buff_PI_d32_2.inv_PI_d32_0.VIN.t55 PH270.t58 VDD.t198 sg13_lv_pmos ad=55.5f pd=0.74u as=0.1005p ps=1.34u w=0.15u l=0.13u
X1772 VDD.t585 6to4_0.buff_PI_d32_1.inv_PI_d32_0.VIN PH0.t32 VDD.t547 sg13_lv_pmos ad=55.5f pd=0.74u as=55.5f ps=0.74u w=0.15u l=0.13u
X1773 PH180.t64 6to4_0.buff_PI_d32_3.inv_PI_d32_0.VIN VDD.t708 VDD.t673 sg13_lv_pmos ad=55.5f pd=0.74u as=0.1005p ps=1.34u w=0.15u l=0.13u
X1774 6to4_0.buff_PI_d32_0.inv_PI_d32_0.VIN 6to4_0.buff_PI_d32_0.inv_PI_d16$1_0.VIN.t56 VDD.t944 VDD.t5 sg13_lv_pmos ad=55.5f pd=0.74u as=55.5f ps=0.74u w=0.15u l=0.13u
X1775 PH90.t6 6to4_0.buff_PI_d32_0.inv_PI_d32_0.VIN VSS.t560 VSS.t559 sg13_lv_nmos ad=55.5f pd=0.74u as=0.1005p ps=1.34u w=0.15u l=0.13u
X1776 PH0.t45 6to4_0.buff_PI_d32_1.inv_PI_d32_0.VIN VDD.t584 VDD.t17 sg13_lv_pmos ad=55.5f pd=0.74u as=0.1005p ps=1.34u w=0.15u l=0.13u
X1777 VDD.t183 6to4_0.buff_PI_d32_1.buff_PI_d16$1_0.inv_PI_d4$1_0.VOUT.t15 6to4_0.buff_PI_d32_1.buff_PI_d16$1_0.inv_PI_d8$1_0.VOUT.t9 VDD.t173 sg13_lv_pmos ad=55.5f pd=0.74u as=55.5f ps=0.74u w=0.15u l=0.13u
X1778 VDD.t40 6to4_0.flywheel_clk_1.PH0 6to4_0.inv_PI_d2$1_2.VOUT VDD.t37 sg13_lv_pmos ad=0.1005p pd=1.34u as=55.5f ps=0.74u w=0.15u l=0.13u
X1779 VSS.t1942 6ph_rosc_0.psdiff_1.VOUTDN 6ph_rosc_0.psdiff_0.buff_d8$1_1.VIN.t17 VSS.t497 sg13_lv_nmos ad=55.5f pd=0.74u as=55.5f ps=0.74u w=0.15u l=0.13u
X1780 VSS.t1881 6to4_0.buff_PI_d32_1.inv_PI_d16$1_0.VIN 6to4_0.buff_PI_d32_1.inv_PI_d32_0.VIN VSS.t1880 sg13_lv_nmos ad=0.1005p pd=1.34u as=55.5f ps=0.74u w=0.15u l=0.13u
X1781 6to4_0.buff_PI_d32_2.buff_PI_d16$1_0.inv_PI_d4$1_0.VOUT.t4 6to4_0.buff_PI_d32_2.buff_PI_d16$1_0.inv_PI_d4$1_0.VIN VDD.t130 VDD.t126 sg13_lv_pmos ad=55.5f pd=0.74u as=0.1005p ps=1.34u w=0.15u l=0.13u
X1782 CTRL 6ph_rosc_0.PH3.t11 CTRL VDD.t464 sg13_lv_pmos ad=0.19p pd=1.38u as=0 ps=0 w=1u l=0.13u
X1783 VDD.t983 6to4_0.buff_PI_d32_2.inv_PI_d16$1_0.VIN.t53 6to4_0.buff_PI_d32_2.inv_PI_d32_0.VIN.t16 VDD.t126 sg13_lv_pmos ad=55.5f pd=0.74u as=55.5f ps=0.74u w=0.15u l=0.13u
X1784 VDD.t957 6to4_0.buff_PI_d32_0.inv_PI_d16$1_0.VIN.t60 6to4_0.buff_PI_d32_0.inv_PI_d32_0.VIN VDD.t341 sg13_lv_pmos ad=55.5f pd=0.74u as=0.1005p ps=1.34u w=0.15u l=0.13u
X1785 VSS.t227 6ph_rosc_0.psdiff_2.VOUTDP 6ph_rosc_0.psdiff_1.buff_d8$1_0.VIN.t11 VSS.t224 sg13_lv_nmos ad=55.5f pd=0.74u as=55.5f ps=0.74u w=0.15u l=0.13u
X1786 6to4_0.buff_PI_d32_3.inv_PI_d32_0.VIN 6to4_0.buff_PI_d32_3.inv_PI_d16$1_0.VIN.t58 VDD.t894 VDD.t99 sg13_lv_pmos ad=55.5f pd=0.74u as=0.1005p ps=1.34u w=0.15u l=0.13u
X1787 VDD.t846 6to4_0.buff_PI_d32_0.buff_PI_d16$1_0.inv_PI_d4$1_0.VOUT.t16 6to4_0.buff_PI_d32_0.buff_PI_d16$1_0.inv_PI_d8$1_0.VOUT.t13 VDD.t341 sg13_lv_pmos ad=55.5f pd=0.74u as=0.1005p ps=1.34u w=0.15u l=0.13u
X1788 VSS.t799 6ph_rosc_0.psdiff_2.buff_d8$1_1.inv_d8$1_0.VIN 6ph_rosc_0.psdiff_2.VOUTDN VSS.t798 sg13_lv_nmos ad=0.1005p pd=1.34u as=55.5f ps=0.74u w=0.15u l=0.13u
X1789 VSS.t1194 6to4_0.buff_PI_d32_2.buff_PI_d16$1_0.inv_PI_d8$1_0.VOUT.t28 6to4_0.buff_PI_d32_2.inv_PI_d16$1_0.VIN.t12 VSS.t1193 sg13_lv_nmos ad=0.1005p pd=1.34u as=55.5f ps=0.74u w=0.15u l=0.13u
X1790 6to4_0.buff_PI_d32_3.buff_PI_d16$1_0.inv_PI_d8$1_0.VOUT.t4 6to4_0.buff_PI_d32_3.buff_PI_d16$1_0.inv_PI_d4$1_0.VOUT.t17 VSS.t1506 VSS.t1505 sg13_lv_nmos ad=55.5f pd=0.74u as=0.1005p ps=1.34u w=0.15u l=0.13u
X1791 VDD.t583 6to4_0.buff_PI_d32_1.inv_PI_d32_0.VIN PH0.t66 VDD.t547 sg13_lv_pmos ad=55.5f pd=0.74u as=0.1005p ps=1.34u w=0.15u l=0.13u
X1792 VDD.t1269 6to4_0.buff_PI_d32_1.inv_PI_d16$1_0.VIN 6to4_0.buff_PI_d32_1.inv_PI_d32_0.VIN VDD.t17 sg13_lv_pmos ad=0.1005p pd=1.34u as=55.5f ps=0.74u w=0.15u l=0.13u
X1793 PH270.t39 6to4_0.buff_PI_d32_2.inv_PI_d32_0.VIN.t61 VDD.t241 VDD.t202 sg13_lv_pmos ad=55.5f pd=0.74u as=55.5f ps=0.74u w=0.15u l=0.13u
X1794 6ph_rosc_0.psdiff_2.buff_d8$1_0.VIN.t4 VSS.t1966 VDD.t1353 VDD.t470 sg13_lv_pmos ad=55.5f pd=0.74u as=55.5f ps=0.74u w=0.15u l=0.13u
X1795 6ph_rosc_0.PH4.t3 6ph_rosc_0.buff_d8$1_2.inv_d8$1_0.VIN VSS.t672 VSS.t671 sg13_lv_nmos ad=55.5f pd=0.74u as=0.1005p ps=1.34u w=0.15u l=0.13u
X1796 6to4_0.flywheel_clk_1.PH0 6to4_0.inv_PI_d2$1_2.VOUT VDD.t335 VDD.t37 sg13_lv_pmos ad=55.5f pd=0.74u as=0.1005p ps=1.34u w=0.15u l=0.13u
X1797 6to4_0.buff_PI_d32_0.inv_PI_d32_0.VIN 6to4_0.buff_PI_d32_0.inv_PI_d16$1_0.VIN.t53 VSS.t1394 VSS.t1393 sg13_lv_nmos ad=55.5f pd=0.74u as=0.1005p ps=1.34u w=0.15u l=0.13u
X1798 VDD.t1237 6to4_0.buff_PI_d32_3.buff_PI_d16$1_0.inv_PI_d8$1_0.VOUT.t37 6to4_0.buff_PI_d32_3.inv_PI_d16$1_0.VIN.t40 VDD.t679 sg13_lv_pmos ad=0.1005p pd=1.34u as=55.5f ps=0.74u w=0.15u l=0.13u
X1799 VDD.t374 6to4_0.buff_PI_d32_0.inv_PI_d32_0.VIN PH90.t61 VDD.t347 sg13_lv_pmos ad=55.5f pd=0.74u as=0.1005p ps=1.34u w=0.15u l=0.13u
X1800 PH0.t18 6to4_0.buff_PI_d32_1.inv_PI_d32_0.VIN VSS.t883 VSS.t882 sg13_lv_nmos ad=55.5f pd=0.74u as=0.1005p ps=1.34u w=0.15u l=0.13u
X1801 6to4_0.buff_PI_d32_3.inv_PI_d16$1_0.VIN.t43 6to4_0.buff_PI_d32_3.buff_PI_d16$1_0.inv_PI_d8$1_0.VOUT.t38 VDD.t1240 VDD.t679 sg13_lv_pmos ad=0.1005p pd=1.34u as=55.5f ps=0.74u w=0.15u l=0.13u
X1802 VSS.t226 6ph_rosc_0.psdiff_2.VOUTDP 6ph_rosc_0.psdiff_1.buff_d8$1_0.VIN.t10 VSS.t222 sg13_lv_nmos ad=55.5f pd=0.74u as=55.5f ps=0.74u w=0.15u l=0.13u
X1803 PH180.t20 6to4_0.buff_PI_d32_3.inv_PI_d32_0.VIN VSS.t1049 VSS.t1048 sg13_lv_nmos ad=55.5f pd=0.74u as=0.1005p ps=1.34u w=0.15u l=0.13u
X1804 6to4_0.buff_PI_d32_2.buff_PI_d16$1_0.inv_PI_d8$1_0.VOUT.t1 6to4_0.buff_PI_d32_2.buff_PI_d16$1_0.inv_PI_d4$1_0.VOUT.t12 VSS.t1536 VSS.t1535 sg13_lv_nmos ad=55.5f pd=0.74u as=0.1005p ps=1.34u w=0.15u l=0.13u
X1805 6to4_0.buff_PI_d32_1.inv_PI_d16$1_0.VIN 6to4_0.buff_PI_d32_1.buff_PI_d16$1_0.inv_PI_d8$1_0.VOUT.t29 VDD.t1165 VDD.t173 sg13_lv_pmos ad=55.5f pd=0.74u as=55.5f ps=0.74u w=0.15u l=0.13u
X1806 VDD.t1074 6ph_rosc_0.psdiff_0.buff_d8$1_0.inv_d8$1_0.VIN 6ph_rosc_0.psdiff_2.CLKN VDD.t34 sg13_lv_pmos ad=0.1005p pd=1.34u as=55.5f ps=0.74u w=0.15u l=0.13u
X1807 VDD.t373 6to4_0.buff_PI_d32_0.inv_PI_d32_0.VIN PH90.t60 VDD.t5 sg13_lv_pmos ad=55.5f pd=0.74u as=55.5f ps=0.74u w=0.15u l=0.13u
X1808 VSS.t29 6to4_0.buff_PI_d32_1.buff_PI_d16$1_0.inv_PI_d4$1_0.VIN 6to4_0.buff_PI_d32_1.buff_PI_d16$1_0.inv_PI_d4$1_0.VOUT.t2 VSS.t28 sg13_lv_nmos ad=0.1005p pd=1.34u as=55.5f ps=0.74u w=0.15u l=0.13u
X1809 6to4_0.buff_PI_d32_0.buff_PI_d16$1_0.inv_PI_d8$1_0.VOUT.t4 6to4_0.buff_PI_d32_0.buff_PI_d16$1_0.inv_PI_d4$1_0.VOUT.t13 VDD.t837 VDD.t341 sg13_lv_pmos ad=0.1005p pd=1.34u as=55.5f ps=0.74u w=0.15u l=0.13u
X1810 PH270.t5 6to4_0.buff_PI_d32_2.inv_PI_d32_0.VIN.t56 VSS.t366 VSS.t365 sg13_lv_nmos ad=55.5f pd=0.74u as=0.1005p ps=1.34u w=0.15u l=0.13u
X1811 6to4_0.buff_PI_d32_1.buff_PI_d16$1_0.inv_PI_d8$1_0.VOUT.t12 6to4_0.buff_PI_d32_1.buff_PI_d16$1_0.inv_PI_d4$1_0.VOUT.t16 VDD.t186 VDD.t173 sg13_lv_pmos ad=55.5f pd=0.74u as=55.5f ps=0.74u w=0.15u l=0.13u
X1812 6ph_rosc_0.psdiff_1.buff_d8$1_1.VIN.t26 6ph_rosc_0.psdiff_2.VOUTDN VSS.t1150 VSS.t1145 sg13_lv_nmos ad=55.5f pd=0.74u as=0.1005p ps=1.34u w=0.15u l=0.13u
X1813 6ph_rosc_0.psdiff_2.buff_d8$1_1.VIN.t31 a_6156_2338# VDD.t475 VDD.t470 sg13_lv_pmos ad=55.5f pd=0.74u as=55.5f ps=0.74u w=0.15u l=0.13u
X1814 6ph_rosc_0.psdiff_2.buff_d8$1_0.VIN.t3 VSS.t1966 VDD.t1352 VDD.t470 sg13_lv_pmos ad=55.5f pd=0.74u as=55.5f ps=0.74u w=0.15u l=0.13u
X1815 6to4_0.buff_PI_d32_2.inv_PI_d32_0.VIN.t40 6to4_0.buff_PI_d32_2.inv_PI_d16$1_0.VIN.t61 VDD.t1008 VDD.t198 sg13_lv_pmos ad=55.5f pd=0.74u as=0.1005p ps=1.34u w=0.15u l=0.13u
X1816 VSS.t1047 6to4_0.buff_PI_d32_3.inv_PI_d32_0.VIN PH180.t3 VSS.t1046 sg13_lv_nmos ad=0.1005p pd=1.34u as=55.5f ps=0.74u w=0.15u l=0.13u
X1817 VSS.t773 6ph_rosc_0.psdiff_0.buff_d8$1_1.inv_d8$1_0.VIN 6ph_rosc_0.psdiff_2.CLKP.t1 VSS.t772 sg13_lv_nmos ad=0.1005p pd=1.34u as=55.5f ps=0.74u w=0.15u l=0.13u
X1818 CTRL 6ph_rosc_0.PH4.t10 CTRL VDD.t78 sg13_lv_pmos ad=0.19p pd=1.38u as=0 ps=0 w=1u l=0.13u
X1819 VDD.t129 6to4_0.buff_PI_d32_2.buff_PI_d16$1_0.inv_PI_d4$1_0.VIN 6to4_0.buff_PI_d32_2.buff_PI_d16$1_0.inv_PI_d4$1_0.VOUT.t6 VDD.t126 sg13_lv_pmos ad=55.5f pd=0.74u as=0.1005p ps=1.34u w=0.15u l=0.13u
X1820 VDD.t1397 VSS.t1967 6ph_rosc_0.psdiff_1.buff_d8$1_1.VIN.t7 VDD.t301 sg13_lv_pmos ad=55.5f pd=0.74u as=55.5f ps=0.74u w=0.15u l=0.13u
X1821 PH0.t65 6to4_0.buff_PI_d32_1.inv_PI_d32_0.VIN VDD.t582 VDD.t173 sg13_lv_pmos ad=55.5f pd=0.74u as=55.5f ps=0.74u w=0.15u l=0.13u
X1822 PH180.t19 6to4_0.buff_PI_d32_3.inv_PI_d32_0.VIN VSS.t1045 VSS.t1044 sg13_lv_nmos ad=55.5f pd=0.74u as=0.1005p ps=1.34u w=0.15u l=0.13u
X1823 VSS.t1749 6to4_0.buff_PI_d32_1.buff_PI_d16$1_0.inv_PI_d8$1_0.VOUT.t35 6to4_0.buff_PI_d32_1.inv_PI_d16$1_0.VIN VSS.t1748 sg13_lv_nmos ad=0.1005p pd=1.34u as=55.5f ps=0.74u w=0.15u l=0.13u
X1824 6ph_rosc_0.psdiff_0.buff_d8$1_1.inv_d8$1_0.VIN 6ph_rosc_0.psdiff_0.buff_d8$1_1.inv_d4$1_0.VIN VSS.t460 VSS.t459 sg13_lv_nmos ad=55.5f pd=0.74u as=0.1005p ps=1.34u w=0.15u l=0.13u
X1825 PH0.t64 6to4_0.buff_PI_d32_1.inv_PI_d32_0.VIN VDD.t581 VDD.t547 sg13_lv_pmos ad=55.5f pd=0.74u as=0.1005p ps=1.34u w=0.15u l=0.13u
X1826 VSS.t824 6ph_rosc_0.psdiff_1.VOUTDP 6ph_rosc_0.psdiff_0.buff_d8$1_0.VIN.t27 VSS.t819 sg13_lv_nmos ad=0.1005p pd=1.34u as=55.5f ps=0.74u w=0.15u l=0.13u
X1827 6ph_rosc_0.buff_d8$1_3.inv_d8$1_0.VIN 6ph_rosc_0.buff_d8$1_3.inv_d4$1_0.VIN VDD.t166 VDD.t75 sg13_lv_pmos ad=55.5f pd=0.74u as=0.1005p ps=1.34u w=0.15u l=0.13u
X1828 6ph_rosc_0.psdiff_1.VOUTDN 6ph_rosc_0.psdiff_1.buff_d8$1_1.inv_d8$1_0.VIN VDD.t157 VDD.t0 sg13_lv_pmos ad=55.5f pd=0.74u as=0.1005p ps=1.34u w=0.15u l=0.13u
X1829 VSS.t881 6to4_0.buff_PI_d32_1.inv_PI_d32_0.VIN PH0.t17 VSS.t880 sg13_lv_nmos ad=0.1005p pd=1.34u as=55.5f ps=0.74u w=0.15u l=0.13u
X1830 6ph_rosc_0.psdiff_2.buff_d8$1_1.VIN.t30 a_6156_2338# VDD.t474 VDD.t470 sg13_lv_pmos ad=55.5f pd=0.74u as=55.5f ps=0.74u w=0.15u l=0.13u
X1831 VDD.t1104 6to4_0.buff_PI_d32_0.buff_PI_d16$1_0.inv_PI_d8$1_0.VOUT.t32 6to4_0.buff_PI_d32_0.inv_PI_d16$1_0.VIN.t25 VDD.t5 sg13_lv_pmos ad=0.1005p pd=1.34u as=55.5f ps=0.74u w=0.15u l=0.13u
X1832 VDD.t1154 6to4_0.buff_PI_d32_1.buff_PI_d16$1_0.inv_PI_d8$1_0.VOUT.t31 6to4_0.buff_PI_d32_1.inv_PI_d16$1_0.VIN VDD.t17 sg13_lv_pmos ad=55.5f pd=0.74u as=55.5f ps=0.74u w=0.15u l=0.13u
X1833 6to4_0.buff_PI_d32_1.inv_PI_d32_0.VIN 6to4_0.buff_PI_d32_1.inv_PI_d16$1_0.VIN VDD.t1268 VDD.t17 sg13_lv_pmos ad=0.1005p pd=1.34u as=55.5f ps=0.74u w=0.15u l=0.13u
X1834 VSS.t1697 6ph_rosc_0.psdiff_2.CLKP.t8 6ph_rosc_0.psdiff_2.buff_d8$1_1.VIN.t6 VSS.t1696 sg13_lv_nmos ad=55.5f pd=0.74u as=55.5f ps=0.74u w=0.15u l=0.13u
X1835 VDD.t1396 VSS.t1967 6ph_rosc_0.psdiff_1.buff_d8$1_1.VIN.t6 VDD.t301 sg13_lv_pmos ad=55.5f pd=0.74u as=55.5f ps=0.74u w=0.15u l=0.13u
X1836 CTRL 6ph_rosc_0.PH3.t11 CTRL VDD.t57 sg13_lv_pmos ad=0.19p pd=1.38u as=0 ps=0 w=1u l=0.13u
X1837 VSS.t741 6ph_rosc_0.buff_d8$1_1.inv_d2$1_0.VIN 6ph_rosc_0.buff_d8$1_1.inv_d4$1_0.VIN VSS.t740 sg13_lv_nmos ad=0.1005p pd=1.34u as=55.5f ps=0.74u w=0.15u l=0.13u
X1838 VDD.t243 6to4_0.buff_PI_d32_2.inv_PI_d32_0.VIN.t62 PH270.t57 VDD.t202 sg13_lv_pmos ad=55.5f pd=0.74u as=55.5f ps=0.74u w=0.15u l=0.13u
X1839 6ph_rosc_0.psdiff_1.VOUTDP 6ph_rosc_0.psdiff_1.buff_d8$1_0.inv_d8$1_0.VIN VSS.t979 VSS.t978 sg13_lv_nmos ad=55.5f pd=0.74u as=0.1005p ps=1.34u w=0.15u l=0.13u
X1840 6ph_rosc_0.psdiff_2.CLKP.t0 6ph_rosc_0.psdiff_0.buff_d8$1_1.inv_d8$1_0.VIN VSS.t771 VSS.t770 sg13_lv_nmos ad=55.5f pd=0.74u as=0.1005p ps=1.34u w=0.15u l=0.13u
X1841 6to4_0.buff_PI_d32_2.buff_PI_d16$1_0.inv_PI_d4$1_0.VIN 6to4_0.buff_PI_d32_2.VIN VDD.t664 VDD.t126 sg13_lv_pmos ad=0.1005p pd=1.34u as=55.5f ps=0.74u w=0.15u l=0.13u
X1842 CTRL 6ph_rosc_0.PH1.t10 CTRL VDD.t82 sg13_lv_pmos ad=0.19p pd=1.38u as=0 ps=0 w=1u l=0.13u
X1843 VSS.t139 6to4_0.buff_PI_d32_3.buff_PI_d16$1_0.inv_PI_d4$1_0.VIN 6to4_0.buff_PI_d32_3.buff_PI_d16$1_0.inv_PI_d4$1_0.VOUT.t1 VSS.t138 sg13_lv_nmos ad=0.1005p pd=1.34u as=55.5f ps=0.74u w=0.15u l=0.13u
X1844 6ph_rosc_0.psdiff_1.buff_d8$1_0.VIN.t21 VSS.t1967 VDD.t1395 VDD.t301 sg13_lv_pmos ad=55.5f pd=0.74u as=0.1005p ps=1.34u w=0.15u l=0.13u
X1845 PH180.t63 6to4_0.buff_PI_d32_3.inv_PI_d32_0.VIN VDD.t707 VDD.t679 sg13_lv_pmos ad=0.1005p pd=1.34u as=55.5f ps=0.74u w=0.15u l=0.13u
X1846 VSS.t1695 6ph_rosc_0.psdiff_2.CLKP.t8 6ph_rosc_0.psdiff_2.buff_d8$1_1.VIN.t5 VSS.t1691 sg13_lv_nmos ad=55.5f pd=0.74u as=55.5f ps=0.74u w=0.15u l=0.13u
X1847 PH90.t39 6to4_0.buff_PI_d32_0.inv_PI_d32_0.VIN VDD.t372 VDD.t341 sg13_lv_pmos ad=55.5f pd=0.74u as=0.1005p ps=1.34u w=0.15u l=0.13u
X1848 6to4_0.buff_PI_d32_1.inv_PI_d32_0.VIN 6to4_0.buff_PI_d32_1.inv_PI_d16$1_0.VIN VSS.t1879 VSS.t1878 sg13_lv_nmos ad=55.5f pd=0.74u as=0.1005p ps=1.34u w=0.15u l=0.13u
X1849 CTRL 6ph_rosc_0.PH5.t12 CTRL VDD.t87 sg13_lv_pmos ad=0.19p pd=1.38u as=0 ps=0 w=1u l=0.13u
X1850 6to4_0.flywheel_clk_0.PH0 6to4_0.buff_PI_d32_2.VIN VSS.t997 VSS.t996 sg13_lv_nmos ad=55.5f pd=0.74u as=0.1005p ps=1.34u w=0.15u l=0.13u
X1851 VDD.t1129 6ph_rosc_0.PH5.t10 6to4_0.PI_clk_1.inv_PI_d2$1_0.VOUT VDD.t1128 sg13_lv_pmos ad=55.5f pd=0.74u as=0.1005p ps=1.34u w=0.15u l=0.13u
X1852 VSS.t1043 6to4_0.buff_PI_d32_3.inv_PI_d32_0.VIN PH180.t18 VSS.t1042 sg13_lv_nmos ad=0.1005p pd=1.34u as=55.5f ps=0.74u w=0.15u l=0.13u
X1853 PH270.t19 6to4_0.buff_PI_d32_2.inv_PI_d32_0.VIN.t66 VSS.t404 VSS.t403 sg13_lv_nmos ad=55.5f pd=0.74u as=0.1005p ps=1.34u w=0.15u l=0.13u
X1854 CTRL 6ph_rosc_0.PH3.t11 CTRL VDD.t330 sg13_lv_pmos ad=0.19p pd=1.38u as=0 ps=0 w=1u l=0.13u
X1855 VSS.t129 6to4_0.PI_clk_1.inv_PI_d2$1_0.VOUT 6to4_0.buff_PI_d32_2.VIN VSS.t128 sg13_lv_nmos ad=0.1005p pd=1.34u as=55.5f ps=0.74u w=0.15u l=0.13u
X1856 6ph_rosc_0.psdiff_1.buff_d8$1_1.VIN.t15 a_9130_2338# VDD.t538 VDD.t301 sg13_lv_pmos ad=55.5f pd=0.74u as=55.5f ps=0.74u w=0.15u l=0.13u
X1857 CTRL 6ph_rosc_0.PH1.t10 CTRL VDD.t82 sg13_lv_pmos ad=0.19p pd=1.38u as=0 ps=0 w=1u l=0.13u
X1858 PH0.t63 6to4_0.buff_PI_d32_1.inv_PI_d32_0.VIN VDD.t580 VDD.t552 sg13_lv_pmos ad=55.5f pd=0.74u as=0.1005p ps=1.34u w=0.15u l=0.13u
X1859 VDD.t234 6to4_0.buff_PI_d32_2.inv_PI_d32_0.VIN.t59 PH270.t56 VDD.t215 sg13_lv_pmos ad=55.5f pd=0.74u as=0.1005p ps=1.34u w=0.15u l=0.13u
X1860 VSS.t290 6ph_rosc_0.buff_d8$1_3.inv_d4$1_0.VIN 6ph_rosc_0.buff_d8$1_3.inv_d8$1_0.VIN VSS.t289 sg13_lv_nmos ad=0.1005p pd=1.34u as=55.5f ps=0.74u w=0.15u l=0.13u
X1861 VDD.t1316 VSS.t1965 6ph_rosc_0.psdiff_0.buff_d8$1_1.VIN.t7 VDD.t503 sg13_lv_pmos ad=0.1005p pd=1.34u as=55.5f ps=0.74u w=0.15u l=0.13u
X1862 6to4_0.buff_PI_d32_3.inv_PI_d32_0.VIN 6to4_0.buff_PI_d32_3.inv_PI_d16$1_0.VIN.t49 VDD.t866 VDD.t679 sg13_lv_pmos ad=55.5f pd=0.74u as=55.5f ps=0.74u w=0.15u l=0.13u
X1863 6to4_0.buff_PI_d32_1.inv_PI_d16$1_0.VIN 6to4_0.buff_PI_d32_1.buff_PI_d16$1_0.inv_PI_d8$1_0.VOUT.t30 VSS.t1747 VSS.t1746 sg13_lv_nmos ad=55.5f pd=0.74u as=0.1005p ps=1.34u w=0.15u l=0.13u
X1864 CTRL 6ph_rosc_0.PH5.t12 CTRL VDD.t85 sg13_lv_pmos ad=0.19p pd=1.38u as=0 ps=0 w=1u l=0.13u
X1865 CTRL 6ph_rosc_0.PH3.t11 CTRL VDD.t464 sg13_lv_pmos ad=0.19p pd=1.38u as=0 ps=0 w=1u l=0.13u
X1866 6to4_0.buff_PI_d32_2.VIN 6to4_0.flywheel_clk_0.PH0 VDD.t11 VDD.t9 sg13_lv_pmos ad=55.5f pd=0.74u as=0.1005p ps=1.34u w=0.15u l=0.13u
X1867 VDD.t956 6to4_0.buff_PI_d32_0.inv_PI_d16$1_0.VIN.t60 6to4_0.buff_PI_d32_0.inv_PI_d32_0.VIN VDD.t341 sg13_lv_pmos ad=0.1005p pd=1.34u as=55.5f ps=0.74u w=0.15u l=0.13u
X1868 VSS.t1041 6to4_0.buff_PI_d32_3.inv_PI_d32_0.VIN PH180.t17 VSS.t1040 sg13_lv_nmos ad=0.1005p pd=1.34u as=55.5f ps=0.74u w=0.15u l=0.13u
X1869 6to4_0.buff_PI_d32_0.inv_PI_d16$1_0.VIN.t1 6to4_0.buff_PI_d32_0.buff_PI_d16$1_0.inv_PI_d8$1_0.VOUT.t24 VDD.t1080 VDD.t5 sg13_lv_pmos ad=0.1005p pd=1.34u as=55.5f ps=0.74u w=0.15u l=0.13u
X1870 VDD.t1256 6to4_0.buff_PI_d32_1.inv_PI_d16$1_0.VIN 6to4_0.buff_PI_d32_1.inv_PI_d32_0.VIN VDD.t173 sg13_lv_pmos ad=55.5f pd=0.74u as=55.5f ps=0.74u w=0.15u l=0.13u
X1871 6to4_0.buff_PI_d32_1.inv_PI_d16$1_0.VIN 6to4_0.buff_PI_d32_1.buff_PI_d16$1_0.inv_PI_d8$1_0.VOUT.t32 VDD.t1163 VDD.t17 sg13_lv_pmos ad=55.5f pd=0.74u as=55.5f ps=0.74u w=0.15u l=0.13u
X1872 PH270.t36 6to4_0.buff_PI_d32_2.inv_PI_d32_0.VIN.t78 VDD.t292 VDD.t126 sg13_lv_pmos ad=55.5f pd=0.74u as=0.1005p ps=1.34u w=0.15u l=0.13u
X1873 VDD.t1043 6to4_0.buff_PI_d32_2.buff_PI_d16$1_0.inv_PI_d4$1_0.VOUT.t13 6to4_0.buff_PI_d32_2.buff_PI_d16$1_0.inv_PI_d8$1_0.VOUT.t17 VDD.t198 sg13_lv_pmos ad=55.5f pd=0.74u as=55.5f ps=0.74u w=0.15u l=0.13u
X1874 VDD.t900 6to4_0.buff_PI_d32_3.inv_PI_d16$1_0.VIN.t60 6to4_0.buff_PI_d32_3.inv_PI_d32_0.VIN VDD.t99 sg13_lv_pmos ad=0.1005p pd=1.34u as=55.5f ps=0.74u w=0.15u l=0.13u
X1875 VSS.t1486 6to4_0.buff_PI_d32_2.inv_PI_d16$1_0.VIN.t60 6to4_0.buff_PI_d32_2.inv_PI_d32_0.VIN.t36 VSS.t1485 sg13_lv_nmos ad=0.1005p pd=1.34u as=55.5f ps=0.74u w=0.15u l=0.13u
X1876 6to4_0.buff_PI_d32_3.inv_PI_d32_0.VIN 6to4_0.buff_PI_d32_3.inv_PI_d16$1_0.VIN.t55 VDD.t885 VDD.t99 sg13_lv_pmos ad=0.1005p pd=1.34u as=55.5f ps=0.74u w=0.15u l=0.13u
X1877 VDD.t1019 6to4_0.buff_PI_d32_3.buff_PI_d16$1_0.inv_PI_d4$1_0.VOUT.t17 6to4_0.buff_PI_d32_3.buff_PI_d16$1_0.inv_PI_d8$1_0.VOUT.t14 VDD.t679 sg13_lv_pmos ad=0.1005p pd=1.34u as=55.5f ps=0.74u w=0.15u l=0.13u
X1878 VSS.t1530 6to4_0.buff_PI_d32_3.buff_PI_d16$1_0.inv_PI_d4$1_0.VOUT.t15 6to4_0.buff_PI_d32_3.buff_PI_d16$1_0.inv_PI_d8$1_0.VOUT.t3 VSS.t1529 sg13_lv_nmos ad=0.1005p pd=1.34u as=55.5f ps=0.74u w=0.15u l=0.13u
X1879 VSS.t1386 6to4_0.buff_PI_d32_0.inv_PI_d16$1_0.VIN.t51 6to4_0.buff_PI_d32_0.inv_PI_d32_0.VIN VSS.t1385 sg13_lv_nmos ad=0.1005p pd=1.34u as=55.5f ps=0.74u w=0.15u l=0.13u
X1880 VDD.t371 6to4_0.buff_PI_d32_0.inv_PI_d32_0.VIN PH90.t59 VDD.t347 sg13_lv_pmos ad=0.1005p pd=1.34u as=55.5f ps=0.74u w=0.15u l=0.13u
X1881 PH90.t58 6to4_0.buff_PI_d32_0.inv_PI_d32_0.VIN VDD.t370 VDD.t5 sg13_lv_pmos ad=0.1005p pd=1.34u as=55.5f ps=0.74u w=0.15u l=0.13u
X1882 6to4_0.PI_clk_1.inv_PI_d2$1_0.VOUT 6ph_rosc_0.PH4.t14 VSS.t1576 VSS.t1575 sg13_lv_nmos ad=55.5f pd=0.74u as=0.1005p ps=1.34u w=0.15u l=0.13u
X1883 VSS.t1370 6ph_rosc_0.PH1.t13 6ph_rosc_0.PH4.t0 VSS.t1369 sg13_lv_nmos ad=0.1005p pd=1.34u as=55.5f ps=0.74u w=0.15u l=0.13u
X1884 VSS.t879 6to4_0.buff_PI_d32_1.inv_PI_d32_0.VIN PH0.t16 VSS.t878 sg13_lv_nmos ad=0.1005p pd=1.34u as=55.5f ps=0.74u w=0.15u l=0.13u
X1885 6ph_rosc_0.psdiff_2.buff_d8$1_1.VIN.t4 6ph_rosc_0.psdiff_2.CLKP.t8 VSS.t1694 VSS.t1693 sg13_lv_nmos ad=55.5f pd=0.74u as=55.5f ps=0.74u w=0.15u l=0.13u
X1886 6to4_0.buff_PI_d32_0.inv_PI_d16$1_0.VIN.t9 6to4_0.buff_PI_d32_0.buff_PI_d16$1_0.inv_PI_d8$1_0.VOUT.t27 VSS.t1606 VSS.t1605 sg13_lv_nmos ad=55.5f pd=0.74u as=0.1005p ps=1.34u w=0.15u l=0.13u
X1887 6to4_0.buff_PI_d32_3.inv_PI_d16$1_0.VIN.t26 6to4_0.buff_PI_d32_3.buff_PI_d16$1_0.inv_PI_d8$1_0.VOUT.t32 VDD.t1222 VDD.t99 sg13_lv_pmos ad=55.5f pd=0.74u as=55.5f ps=0.74u w=0.15u l=0.13u
X1888 VDD.t968 6to4_0.buff_PI_d32_2.inv_PI_d16$1_0.VIN.t48 6to4_0.buff_PI_d32_2.inv_PI_d32_0.VIN.t1 VDD.t126 sg13_lv_pmos ad=0.1005p pd=1.34u as=55.5f ps=0.74u w=0.15u l=0.13u
X1889 PH270.t55 6to4_0.buff_PI_d32_2.inv_PI_d32_0.VIN.t71 VDD.t270 VDD.t215 sg13_lv_pmos ad=55.5f pd=0.74u as=0.1005p ps=1.34u w=0.15u l=0.13u
X1890 VSS.t1039 6to4_0.buff_PI_d32_3.inv_PI_d32_0.VIN PH180.t16 VSS.t1038 sg13_lv_nmos ad=0.1005p pd=1.34u as=55.5f ps=0.74u w=0.15u l=0.13u
X1891 PH180.t62 6to4_0.buff_PI_d32_3.inv_PI_d32_0.VIN VDD.t706 VDD.t679 sg13_lv_pmos ad=55.5f pd=0.74u as=55.5f ps=0.74u w=0.15u l=0.13u
X1892 VDD.t334 6to4_0.inv_PI_d2$1_2.VOUT 6to4_0.flywheel_clk_1.PH0 VDD.t37 sg13_lv_pmos ad=0.1005p pd=1.34u as=55.5f ps=0.74u w=0.15u l=0.13u
X1893 6to4_0.buff_PI_d32_3.inv_PI_d16$1_0.VIN.t0 6to4_0.buff_PI_d32_3.buff_PI_d16$1_0.inv_PI_d8$1_0.VOUT.t24 VSS.t1789 VSS.t1788 sg13_lv_nmos ad=55.5f pd=0.74u as=0.1005p ps=1.34u w=0.15u l=0.13u
X1894 6ph_rosc_0.buff_d8$1_3.inv_d8$1_0.VIN 6ph_rosc_0.buff_d8$1_3.inv_d4$1_0.VIN VSS.t288 VSS.t287 sg13_lv_nmos ad=55.5f pd=0.74u as=0.1005p ps=1.34u w=0.15u l=0.13u
X1895 VDD.t705 6to4_0.buff_PI_d32_3.inv_PI_d32_0.VIN PH180.t61 VDD.t679 sg13_lv_pmos ad=55.5f pd=0.74u as=55.5f ps=0.74u w=0.15u l=0.13u
X1896 CTRL 6ph_rosc_0.PH4.t10 CTRL VDD.t451 sg13_lv_pmos ad=0.19p pd=1.38u as=0 ps=0 w=1u l=0.13u
X1897 6ph_rosc_0.psdiff_2.buff_d8$1_1.VIN.t3 6ph_rosc_0.psdiff_2.CLKP.t8 VSS.t1690 VSS.t1689 sg13_lv_nmos ad=55.5f pd=0.74u as=55.5f ps=0.74u w=0.15u l=0.13u
X1898 VDD.t1116 6to4_0.buff_PI_d32_0.buff_PI_d16$1_0.inv_PI_d8$1_0.VOUT.t36 6to4_0.buff_PI_d32_0.inv_PI_d16$1_0.VIN.t38 VDD.t341 sg13_lv_pmos ad=55.5f pd=0.74u as=55.5f ps=0.74u w=0.15u l=0.13u
X1899 VDD.t1152 6to4_0.buff_PI_d32_1.buff_PI_d16$1_0.inv_PI_d8$1_0.VOUT.t33 6to4_0.buff_PI_d32_1.inv_PI_d16$1_0.VIN VDD.t173 sg13_lv_pmos ad=55.5f pd=0.74u as=0.1005p ps=1.34u w=0.15u l=0.13u
X1900 VDD.t1351 VSS.t1966 6ph_rosc_0.psdiff_2.buff_d8$1_1.VIN.t19 VDD.t470 sg13_lv_pmos ad=55.5f pd=0.74u as=55.5f ps=0.74u w=0.15u l=0.13u
X1901 a_7973_2194# CTRL 6ph_rosc_0.psdiff_1.buff_d8$1_1.VIN.t10 VSS.t494 sg13_lv_nmos ad=55.5f pd=0.74u as=0.1005p ps=1.34u w=0.15u l=0.13u
X1902 6to4_0.buff_PI_d32_0.inv_PI_d32_0.VIN 6to4_0.buff_PI_d32_0.inv_PI_d16$1_0.VIN.t50 VDD.t926 VDD.t341 sg13_lv_pmos ad=0.1005p pd=1.34u as=55.5f ps=0.74u w=0.15u l=0.13u
X1903 VDD.t113 6ph_rosc_0.psdiff_2.buff_d8$1_0.inv_d4$1_0.VIN 6ph_rosc_0.psdiff_2.buff_d8$1_0.inv_d8$1_0.VIN VDD.t34 sg13_lv_pmos ad=0.1005p pd=1.34u as=55.5f ps=0.74u w=0.15u l=0.13u
X1904 VSS.t558 6to4_0.buff_PI_d32_0.inv_PI_d32_0.VIN PH90.t16 VSS.t557 sg13_lv_nmos ad=0.1005p pd=1.34u as=55.5f ps=0.74u w=0.15u l=0.13u
X1905 VDD.t1266 6to4_0.buff_PI_d32_1.inv_PI_d16$1_0.VIN 6to4_0.buff_PI_d32_1.inv_PI_d32_0.VIN VDD.t173 sg13_lv_pmos ad=55.5f pd=0.74u as=0.1005p ps=1.34u w=0.15u l=0.13u
X1906 6to4_0.buff_PI_d32_2.buff_PI_d16$1_0.inv_PI_d8$1_0.VOUT.t16 6to4_0.buff_PI_d32_2.buff_PI_d16$1_0.inv_PI_d4$1_0.VOUT.t14 VDD.t1046 VDD.t198 sg13_lv_pmos ad=55.5f pd=0.74u as=55.5f ps=0.74u w=0.15u l=0.13u
X1907 6ph_rosc_0.PH1.t8 6ph_rosc_0.PH4.t13 VSS.t1572 VSS.t1571 sg13_lv_nmos ad=55.5f pd=0.74u as=0.1005p ps=1.34u w=0.15u l=0.13u
X1908 VDD.t682 6to4_0.buff_PI_d32_3.inv_PI_d32_0.VIN PH180.t60 VDD.t679 sg13_lv_pmos ad=55.5f pd=0.74u as=0.1005p ps=1.34u w=0.15u l=0.13u
X1909 VDD.t228 6to4_0.buff_PI_d32_2.inv_PI_d32_0.VIN.t57 PH270.t54 VDD.t215 sg13_lv_pmos ad=0.1005p pd=1.34u as=55.5f ps=0.74u w=0.15u l=0.13u
X1910 6to4_0.buff_PI_d32_1.inv_PI_d16$1_0.VIN 6to4_0.buff_PI_d32_1.buff_PI_d16$1_0.inv_PI_d8$1_0.VOUT.t39 VSS.t1745 VSS.t1744 sg13_lv_nmos ad=55.5f pd=0.74u as=0.1005p ps=1.34u w=0.15u l=0.13u
X1911 VDD.t911 6ph_rosc_0.PH1.t11 6to4_0.PI_clk_0.inv_PI_d2$1_0.VOUT VDD.t5 sg13_lv_pmos ad=0.1005p pd=1.34u as=55.5f ps=0.74u w=0.15u l=0.13u
X1912 VSS.t89 6to4_0.buff_PI_d32_0.buff_PI_d16$1_0.inv_PI_d4$1_0.VIN 6to4_0.buff_PI_d32_0.buff_PI_d16$1_0.inv_PI_d4$1_0.VOUT.t2 VSS.t88 sg13_lv_nmos ad=0.1005p pd=1.34u as=55.5f ps=0.74u w=0.15u l=0.13u
X1913 VDD.t473 a_6156_2338# 6ph_rosc_0.psdiff_2.buff_d8$1_1.VIN.t29 VDD.t470 sg13_lv_pmos ad=0.1005p pd=1.34u as=55.5f ps=0.74u w=0.15u l=0.13u
X1914 6ph_rosc_0.psdiff_2.VOUTDN 6ph_rosc_0.psdiff_2.buff_d8$1_1.inv_d8$1_0.VIN VSS.t797 VSS.t796 sg13_lv_nmos ad=55.5f pd=0.74u as=0.1005p ps=1.34u w=0.15u l=0.13u
X1915 VDD.t1139 6ph_rosc_0.PH2.t11 6to4_0.PI_clk_0.inv_PI_d2$1_0.VOUT VDD.t1138 sg13_lv_pmos ad=55.5f pd=0.74u as=55.5f ps=0.74u w=0.15u l=0.13u
X1916 VSS.t1238 6to4_0.buff_PI_d32_2.buff_PI_d16$1_0.inv_PI_d8$1_0.VOUT.t39 6to4_0.buff_PI_d32_2.inv_PI_d16$1_0.VIN.t11 VSS.t1237 sg13_lv_nmos ad=0.1005p pd=1.34u as=55.5f ps=0.74u w=0.15u l=0.13u
X1917 CTRL 6ph_rosc_0.PH3.t11 CTRL VDD.t57 sg13_lv_pmos ad=0.19p pd=1.38u as=0 ps=0 w=1u l=0.13u
X1918 VDD.t1201 6to4_0.buff_PI_d32_3.buff_PI_d16$1_0.inv_PI_d8$1_0.VOUT.t25 6to4_0.buff_PI_d32_3.inv_PI_d16$1_0.VIN.t4 VDD.t99 sg13_lv_pmos ad=55.5f pd=0.74u as=55.5f ps=0.74u w=0.15u l=0.13u
X1919 VSS.t356 6to4_0.buff_PI_d32_2.inv_PI_d32_0.VIN.t54 PH270.t18 VSS.t355 sg13_lv_nmos ad=0.1005p pd=1.34u as=55.5f ps=0.74u w=0.15u l=0.13u
X1920 VDD.t52 6ph_rosc_0.buff_d8$1_5.inv_d8$1_0.VIN 6ph_rosc_0.PH0.t6 VDD.t51 sg13_lv_pmos ad=0.1005p pd=1.34u as=55.5f ps=0.74u w=0.15u l=0.13u
X1921 VDD.t369 6to4_0.buff_PI_d32_0.inv_PI_d32_0.VIN PH90.t57 VDD.t5 sg13_lv_pmos ad=0.1005p pd=1.34u as=55.5f ps=0.74u w=0.15u l=0.13u
X1922 VSS.t1490 6to4_0.buff_PI_d32_2.inv_PI_d16$1_0.VIN.t61 6to4_0.buff_PI_d32_2.inv_PI_d32_0.VIN.t39 VSS.t1489 sg13_lv_nmos ad=0.1005p pd=1.34u as=55.5f ps=0.74u w=0.15u l=0.13u
X1923 6ph_rosc_0.psdiff_2.buff_d8$1_1.inv_d4$1_0.VIN 6ph_rosc_0.psdiff_2.buff_d8$1_1.inv_d2$1_0.VIN VSS.t1172 VSS.t1171 sg13_lv_nmos ad=55.5f pd=0.74u as=0.1005p ps=1.34u w=0.15u l=0.13u
X1924 VDD.t579 6to4_0.buff_PI_d32_1.inv_PI_d32_0.VIN PH0.t62 VDD.t17 sg13_lv_pmos ad=55.5f pd=0.74u as=55.5f ps=0.74u w=0.15u l=0.13u
X1925 VSS.t1566 6ph_rosc_0.PH4.t11 6to4_0.PI_clk_1.inv_PI_d2$1_0.VOUT VSS.t1565 sg13_lv_nmos ad=0.1005p pd=1.34u as=55.5f ps=0.74u w=0.15u l=0.13u
X1926 6to4_0.buff_PI_d32_1.buff_PI_d16$1_0.inv_PI_d8$1_0.VOUT.t1 6to4_0.buff_PI_d32_1.buff_PI_d16$1_0.inv_PI_d4$1_0.VOUT.t12 VDD.t174 VDD.t173 sg13_lv_pmos ad=0.1005p pd=1.34u as=55.5f ps=0.74u w=0.15u l=0.13u
X1927 PH180.t15 6to4_0.buff_PI_d32_3.inv_PI_d32_0.VIN VSS.t1037 VSS.t1036 sg13_lv_nmos ad=55.5f pd=0.74u as=0.1005p ps=1.34u w=0.15u l=0.13u
X1928 VSS.t1610 6to4_0.buff_PI_d32_0.buff_PI_d16$1_0.inv_PI_d8$1_0.VOUT.t28 6to4_0.buff_PI_d32_0.inv_PI_d16$1_0.VIN.t12 VSS.t1609 sg13_lv_nmos ad=0.1005p pd=1.34u as=55.5f ps=0.74u w=0.15u l=0.13u
X1929 6ph_rosc_0.psdiff_2.buff_d8$1_0.VIN.t18 6ph_rosc_0.psdiff_2.CLKN VSS.t694 VSS.t700 sg13_lv_nmos ad=55.5f pd=0.74u as=55.5f ps=0.74u w=0.15u l=0.13u
X1930 6ph_rosc_0.buff_d8$1_3.inv_d2$1_0.VIN 6ph_rosc_0.psdiff_1.VOUTDP VDD.t546 VDD.t75 sg13_lv_pmos ad=0.1005p pd=1.34u as=0.1005p ps=1.34u w=0.15u l=0.13u
X1931 VSS.t396 6to4_0.buff_PI_d32_2.inv_PI_d32_0.VIN.t64 PH270.t17 VSS.t395 sg13_lv_nmos ad=0.1005p pd=1.34u as=55.5f ps=0.74u w=0.15u l=0.13u
X1932 PH180.t59 6to4_0.buff_PI_d32_3.inv_PI_d32_0.VIN VDD.t703 VDD.t99 sg13_lv_pmos ad=55.5f pd=0.74u as=55.5f ps=0.74u w=0.15u l=0.13u
X1933 6to4_0.buff_PI_d32_2.inv_PI_d32_0.VIN.t4 6to4_0.buff_PI_d32_2.inv_PI_d16$1_0.VIN.t49 VDD.t971 VDD.t126 sg13_lv_pmos ad=0.1005p pd=1.34u as=55.5f ps=0.74u w=0.15u l=0.13u
X1934 6to4_0.buff_PI_d32_1.inv_PI_d16$1_0.VIN 6to4_0.buff_PI_d32_1.buff_PI_d16$1_0.inv_PI_d8$1_0.VOUT.t38 VDD.t1161 VDD.t17 sg13_lv_pmos ad=55.5f pd=0.74u as=0.1005p ps=1.34u w=0.15u l=0.13u
X1935 CTRL 6ph_rosc_0.PH5.t12 CTRL VDD.t87 sg13_lv_pmos ad=0.19p pd=1.38u as=0 ps=0 w=1u l=0.13u
X1936 VDD.t1228 6to4_0.buff_PI_d32_3.buff_PI_d16$1_0.inv_PI_d8$1_0.VOUT.t34 6to4_0.buff_PI_d32_3.inv_PI_d16$1_0.VIN.t31 VDD.t679 sg13_lv_pmos ad=55.5f pd=0.74u as=55.5f ps=0.74u w=0.15u l=0.13u
X1937 6to4_0.buff_PI_d32_1.inv_PI_d16$1_0.VIN 6to4_0.buff_PI_d32_1.buff_PI_d16$1_0.inv_PI_d8$1_0.VOUT.t29 VSS.t1743 VSS.t1742 sg13_lv_nmos ad=55.5f pd=0.74u as=0.1005p ps=1.34u w=0.15u l=0.13u
X1938 PH0.t61 6to4_0.buff_PI_d32_1.inv_PI_d32_0.VIN VDD.t554 VDD.t552 sg13_lv_pmos ad=0.1005p pd=1.34u as=55.5f ps=0.74u w=0.15u l=0.13u
X1939 6to4_0.buff_PI_d32_3.buff_PI_d16$1_0.inv_PI_d8$1_0.VOUT.t13 6to4_0.buff_PI_d32_3.buff_PI_d16$1_0.inv_PI_d4$1_0.VOUT.t18 VDD.t1022 VDD.t679 sg13_lv_pmos ad=55.5f pd=0.74u as=55.5f ps=0.74u w=0.15u l=0.13u
X1940 VSS.t27 6to4_0.buff_PI_d32_1.buff_PI_d16$1_0.inv_PI_d4$1_0.VIN 6to4_0.buff_PI_d32_1.buff_PI_d16$1_0.inv_PI_d4$1_0.VOUT.t1 VSS.t26 sg13_lv_nmos ad=0.1005p pd=1.34u as=55.5f ps=0.74u w=0.15u l=0.13u
X1941 6ph_rosc_0.psdiff_2.CLKN 6ph_rosc_0.psdiff_0.buff_d8$1_0.inv_d8$1_0.VIN VDD.t1073 VDD.t34 sg13_lv_pmos ad=55.5f pd=0.74u as=0.1005p ps=1.34u w=0.15u l=0.13u
X1942 VSS.t769 6ph_rosc_0.psdiff_0.buff_d8$1_1.inv_d8$1_0.VIN 6ph_rosc_0.psdiff_2.CLKP.t0 VSS.t768 sg13_lv_nmos ad=0.1005p pd=1.34u as=55.5f ps=0.74u w=0.15u l=0.13u
X1943 6to4_0.buff_PI_d32_3.inv_PI_d16$1_0.VIN.t33 6to4_0.buff_PI_d32_3.buff_PI_d16$1_0.inv_PI_d8$1_0.VOUT.t35 VSS.t1833 VSS.t1832 sg13_lv_nmos ad=55.5f pd=0.74u as=0.1005p ps=1.34u w=0.15u l=0.13u
X1944 VDD.t577 6to4_0.buff_PI_d32_1.inv_PI_d32_0.VIN PH0.t60 VDD.t552 sg13_lv_pmos ad=0.1005p pd=1.34u as=55.5f ps=0.74u w=0.15u l=0.13u
X1945 PH270.t53 6to4_0.buff_PI_d32_2.inv_PI_d32_0.VIN.t73 VDD.t276 VDD.t202 sg13_lv_pmos ad=55.5f pd=0.74u as=0.1005p ps=1.34u w=0.15u l=0.13u
X1946 6to4_0.buff_PI_d32_0.inv_PI_d16$1_0.VIN.t16 6to4_0.buff_PI_d32_0.buff_PI_d16$1_0.inv_PI_d8$1_0.VOUT.t29 VDD.t1095 VDD.t341 sg13_lv_pmos ad=55.5f pd=0.74u as=55.5f ps=0.74u w=0.15u l=0.13u
X1947 VDD.t128 6to4_0.buff_PI_d32_2.buff_PI_d16$1_0.inv_PI_d4$1_0.VIN 6to4_0.buff_PI_d32_2.buff_PI_d16$1_0.inv_PI_d4$1_0.VOUT.t5 VDD.t126 sg13_lv_pmos ad=55.5f pd=0.74u as=55.5f ps=0.74u w=0.15u l=0.13u
X1948 VDD.t1315 VSS.t1965 6ph_rosc_0.psdiff_0.buff_d8$1_1.VIN.t6 VDD.t503 sg13_lv_pmos ad=55.5f pd=0.74u as=55.5f ps=0.74u w=0.15u l=0.13u
X1949 VDD.t1302 6ph_rosc_0.psdiff_1.VOUTDN 6ph_rosc_0.buff_d8$1_2.inv_d2$1_0.VIN VDD.t80 sg13_lv_pmos ad=0.1005p pd=1.34u as=0.1005p ps=1.34u w=0.15u l=0.13u
X1950 CTRL 6ph_rosc_0.PH5.t12 CTRL VDD.t85 sg13_lv_pmos ad=0.19p pd=1.38u as=0 ps=0 w=1u l=0.13u
X1951 PH90.t15 6to4_0.buff_PI_d32_0.inv_PI_d32_0.VIN VSS.t556 VSS.t555 sg13_lv_nmos ad=55.5f pd=0.74u as=0.1005p ps=1.34u w=0.15u l=0.13u
X1952 6to4_0.buff_PI_d32_3.buff_PI_d16$1_0.inv_PI_d8$1_0.VOUT.t12 6to4_0.buff_PI_d32_3.buff_PI_d16$1_0.inv_PI_d4$1_0.VOUT.t15 VDD.t1037 VDD.t679 sg13_lv_pmos ad=55.5f pd=0.74u as=0.1005p ps=1.34u w=0.15u l=0.13u
X1953 PH90.t56 6to4_0.buff_PI_d32_0.inv_PI_d32_0.VIN VDD.t368 VDD.t343 sg13_lv_pmos ad=0.1005p pd=1.34u as=55.5f ps=0.74u w=0.15u l=0.13u
X1954 6to4_0.buff_PI_d32_1.inv_PI_d32_0.VIN 6to4_0.buff_PI_d32_1.inv_PI_d16$1_0.VIN VDD.t1265 VDD.t173 sg13_lv_pmos ad=55.5f pd=0.74u as=0.1005p ps=1.34u w=0.15u l=0.13u
X1955 PH180.t14 6to4_0.buff_PI_d32_3.inv_PI_d32_0.VIN VSS.t1035 VSS.t1034 sg13_lv_nmos ad=55.5f pd=0.74u as=0.1005p ps=1.34u w=0.15u l=0.13u
X1956 6ph_rosc_0.psdiff_1.buff_d8$1_1.VIN.t25 6ph_rosc_0.psdiff_2.VOUTDN VSS.t1149 VSS.t1148 sg13_lv_nmos ad=55.5f pd=0.74u as=55.5f ps=0.74u w=0.15u l=0.13u
X1957 VDD.t21 6to4_0.buff_PI_d32_1.buff_PI_d16$1_0.inv_PI_d4$1_0.VIN 6to4_0.buff_PI_d32_1.buff_PI_d16$1_0.inv_PI_d4$1_0.VOUT.t7 VDD.t17 sg13_lv_pmos ad=0.1005p pd=1.34u as=55.5f ps=0.74u w=0.15u l=0.13u
X1958 6ph_rosc_0.psdiff_1.buff_d8$1_1.inv_d4$1_0.VIN 6ph_rosc_0.psdiff_1.buff_d8$1_1.inv_d2$1_0.VIN VDD.t514 VDD.t0 sg13_lv_pmos ad=55.5f pd=0.74u as=0.1005p ps=1.34u w=0.15u l=0.13u
X1959 6to4_0.buff_PI_d32_2.buff_PI_d16$1_0.inv_PI_d8$1_0.VOUT.t15 6to4_0.buff_PI_d32_2.buff_PI_d16$1_0.inv_PI_d4$1_0.VOUT.t16 VDD.t1053 VDD.t198 sg13_lv_pmos ad=55.5f pd=0.74u as=0.1005p ps=1.34u w=0.15u l=0.13u
X1960 6ph_rosc_0.psdiff_2.buff_d8$1_1.VIN.t18 VSS.t1966 VDD.t1343 VDD.t470 sg13_lv_pmos ad=55.5f pd=0.74u as=55.5f ps=0.74u w=0.15u l=0.13u
X1961 VSS.t1558 6to4_0.buff_PI_d32_2.buff_PI_d16$1_0.inv_PI_d4$1_0.VOUT.t18 6to4_0.buff_PI_d32_2.buff_PI_d16$1_0.inv_PI_d8$1_0.VOUT.t4 VSS.t1557 sg13_lv_nmos ad=0.1005p pd=1.34u as=55.5f ps=0.74u w=0.15u l=0.13u
X1962 6ph_rosc_0.PH4.t1 6ph_rosc_0.PH1.t14 VDD.t919 VDD.t917 sg13_lv_pmos ad=55.5f pd=0.74u as=0.1005p ps=1.34u w=0.15u l=0.13u
X1963 VDD.t702 6to4_0.buff_PI_d32_3.inv_PI_d32_0.VIN PH180.t58 VDD.t99 sg13_lv_pmos ad=55.5f pd=0.74u as=55.5f ps=0.74u w=0.15u l=0.13u
X1964 6to4_0.PI_clk_0.inv_PI_d2$1_0.VOUT 6ph_rosc_0.PH2.t12 VDD.t1142 VDD.t1138 sg13_lv_pmos ad=55.5f pd=0.74u as=55.5f ps=0.74u w=0.15u l=0.13u
X1965 VDD.t826 6ph_rosc_0.PH0.t12 6to4_0.inv_PI_d2$1_1.VIN VDD.t17 sg13_lv_pmos ad=55.5f pd=0.74u as=0.1005p ps=1.34u w=0.15u l=0.13u
X1966 VSS.t1272 6to4_0.buff_PI_d32_0.buff_PI_d16$1_0.inv_PI_d4$1_0.VOUT.t16 6to4_0.buff_PI_d32_0.buff_PI_d16$1_0.inv_PI_d8$1_0.VOUT.t12 VSS.t1271 sg13_lv_nmos ad=0.1005p pd=1.34u as=55.5f ps=0.74u w=0.15u l=0.13u
X1967 PH90.t55 6to4_0.buff_PI_d32_0.inv_PI_d32_0.VIN VDD.t367 VDD.t347 sg13_lv_pmos ad=55.5f pd=0.74u as=55.5f ps=0.74u w=0.15u l=0.13u
X1968 VSS.t1801 6to4_0.buff_PI_d32_3.buff_PI_d16$1_0.inv_PI_d8$1_0.VOUT.t27 6to4_0.buff_PI_d32_3.inv_PI_d16$1_0.VIN.t9 VSS.t1800 sg13_lv_nmos ad=0.1005p pd=1.34u as=55.5f ps=0.74u w=0.15u l=0.13u
X1969 6to4_0.buff_PI_d32_0.inv_PI_d16$1_0.VIN.t18 6to4_0.buff_PI_d32_0.buff_PI_d16$1_0.inv_PI_d8$1_0.VOUT.t30 VSS.t1618 VSS.t1617 sg13_lv_nmos ad=55.5f pd=0.74u as=0.1005p ps=1.34u w=0.15u l=0.13u
X1970 VSS.t1218 6to4_0.buff_PI_d32_2.buff_PI_d16$1_0.inv_PI_d8$1_0.VOUT.t34 6to4_0.buff_PI_d32_2.inv_PI_d16$1_0.VIN.t10 VSS.t1217 sg13_lv_nmos ad=0.1005p pd=1.34u as=55.5f ps=0.74u w=0.15u l=0.13u
X1971 VDD.t333 6to4_0.inv_PI_d2$1_2.VOUT 6to4_0.buff_PI_d32_3.buff_PI_d16$1_0.inv_PI_d4$1_0.VIN VDD.t99 sg13_lv_pmos ad=55.5f pd=0.74u as=55.5f ps=0.74u w=0.15u l=0.13u
X1972 VDD.t989 6to4_0.buff_PI_d32_2.inv_PI_d16$1_0.VIN.t55 6to4_0.buff_PI_d32_2.inv_PI_d32_0.VIN.t23 VDD.t198 sg13_lv_pmos ad=55.5f pd=0.74u as=55.5f ps=0.74u w=0.15u l=0.13u
X1973 VDD.t576 6to4_0.buff_PI_d32_1.inv_PI_d32_0.VIN PH0.t59 VDD.t17 sg13_lv_pmos ad=55.5f pd=0.74u as=0.1005p ps=1.34u w=0.15u l=0.13u
X1974 6ph_rosc_0.psdiff_0.buff_d8$1_0.VIN.t5 VSS.t1965 VDD.t1314 VDD.t503 sg13_lv_pmos ad=55.5f pd=0.74u as=0.1005p ps=1.34u w=0.15u l=0.13u
X1975 VDD.t1160 6to4_0.buff_PI_d32_1.buff_PI_d16$1_0.inv_PI_d8$1_0.VOUT.t35 6to4_0.buff_PI_d32_1.inv_PI_d16$1_0.VIN VDD.t17 sg13_lv_pmos ad=55.5f pd=0.74u as=0.1005p ps=1.34u w=0.15u l=0.13u
X1976 VSS.t73 6ph_rosc_0.buff_d8$1_5.inv_d8$1_0.VIN 6ph_rosc_0.PH0.t2 VSS.t72 sg13_lv_nmos ad=0.1005p pd=1.34u as=55.5f ps=0.74u w=0.15u l=0.13u
X1977 6to4_0.buff_PI_d32_2.inv_PI_d32_0.VIN.t45 6to4_0.buff_PI_d32_2.inv_PI_d16$1_0.VIN.t63 VSS.t1500 VSS.t1499 sg13_lv_nmos ad=55.5f pd=0.74u as=0.1005p ps=1.34u w=0.15u l=0.13u
X1978 VDD.t1016 6to4_0.buff_PI_d32_3.buff_PI_d16$1_0.inv_PI_d4$1_0.VOUT.t16 6to4_0.buff_PI_d32_3.buff_PI_d16$1_0.inv_PI_d8$1_0.VOUT.t11 VDD.t679 sg13_lv_pmos ad=55.5f pd=0.74u as=0.1005p ps=1.34u w=0.15u l=0.13u
X1979 6ph_rosc_0.psdiff_0.buff_d8$1_0.VIN.t14 a_10947_2194# VDD.t518 VDD.t503 sg13_lv_pmos ad=55.5f pd=0.74u as=55.5f ps=0.74u w=0.15u l=0.13u
X1980 VSS.t747 6ph_rosc_0.buff_d8$1_4.inv_d8$1_0.VIN 6ph_rosc_0.PH3.t2 VSS.t746 sg13_lv_nmos ad=0.1005p pd=1.34u as=55.5f ps=0.74u w=0.15u l=0.13u
X1981 CTRL 6ph_rosc_0.PH4.t10 CTRL VDD.t451 sg13_lv_pmos ad=0.19p pd=1.38u as=0 ps=0 w=1u l=0.13u
X1982 VDD.t701 6to4_0.buff_PI_d32_3.inv_PI_d32_0.VIN PH180.t57 VDD.t99 sg13_lv_pmos ad=55.5f pd=0.74u as=0.1005p ps=1.34u w=0.15u l=0.13u
X1983 VSS.t704 6ph_rosc_0.psdiff_2.CLKN 6ph_rosc_0.psdiff_2.buff_d8$1_0.VIN.t17 VSS.t496 sg13_lv_nmos ad=55.5f pd=0.74u as=55.5f ps=0.74u w=0.15u l=0.13u
X1984 6ph_rosc_0.psdiff_0.buff_d8$1_0.VIN.t26 6ph_rosc_0.psdiff_1.VOUTDP VSS.t823 VSS.t822 sg13_lv_nmos ad=55.5f pd=0.74u as=55.5f ps=0.74u w=0.15u l=0.13u
X1985 6ph_rosc_0.psdiff_0.buff_d8$1_0.VIN.t13 a_10947_2194# VDD.t517 VDD.t503 sg13_lv_pmos ad=55.5f pd=0.74u as=55.5f ps=0.74u w=0.15u l=0.13u
X1986 6to4_0.buff_PI_d32_2.inv_PI_d32_0.VIN.t32 6to4_0.buff_PI_d32_2.inv_PI_d16$1_0.VIN.t58 VDD.t998 VDD.t126 sg13_lv_pmos ad=55.5f pd=0.74u as=55.5f ps=0.74u w=0.15u l=0.13u
X1987 6to4_0.inv_PI_d2$1_2.VOUT 6to4_0.inv_PI_d2$1_3.VOUT VDD.t325 VDD.t99 sg13_lv_pmos ad=55.5f pd=0.74u as=55.5f ps=0.74u w=0.15u l=0.13u
X1988 VDD.t366 6to4_0.buff_PI_d32_0.inv_PI_d32_0.VIN PH90.t54 VDD.t341 sg13_lv_pmos ad=55.5f pd=0.74u as=55.5f ps=0.74u w=0.15u l=0.13u
X1989 VSS.t478 6ph_rosc_0.buff_d8$1_1.inv_d8$1_0.VIN 6ph_rosc_0.PH5.t1 VSS.t477 sg13_lv_nmos ad=0.1005p pd=1.34u as=55.5f ps=0.74u w=0.15u l=0.13u
X1990 VSS.t1941 6ph_rosc_0.psdiff_1.VOUTDN 6ph_rosc_0.psdiff_0.buff_d8$1_1.VIN.t25 VSS.t1936 sg13_lv_nmos ad=55.5f pd=0.74u as=55.5f ps=0.74u w=0.15u l=0.13u
X1991 6to4_0.buff_PI_d32_0.inv_PI_d16$1_0.VIN.t7 6to4_0.buff_PI_d32_0.buff_PI_d16$1_0.inv_PI_d8$1_0.VOUT.t26 VDD.t1086 VDD.t341 sg13_lv_pmos ad=55.5f pd=0.74u as=0.1005p ps=1.34u w=0.15u l=0.13u
X1992 6to4_0.buff_PI_d32_2.inv_PI_d16$1_0.VIN.t9 6to4_0.buff_PI_d32_2.buff_PI_d16$1_0.inv_PI_d8$1_0.VOUT.t33 VSS.t1214 VSS.t1213 sg13_lv_nmos ad=55.5f pd=0.74u as=0.1005p ps=1.34u w=0.15u l=0.13u
X1993 VDD.t1225 6to4_0.buff_PI_d32_3.buff_PI_d16$1_0.inv_PI_d8$1_0.VOUT.t33 6to4_0.buff_PI_d32_3.inv_PI_d16$1_0.VIN.t28 VDD.t99 sg13_lv_pmos ad=55.5f pd=0.74u as=55.5f ps=0.74u w=0.15u l=0.13u
X1994 6to4_0.inv_PI_d2$1_3.VOUT 6ph_rosc_0.PH3.t10 VDD.t1246 VDD.t99 sg13_lv_pmos ad=55.5f pd=0.74u as=0.1005p ps=1.34u w=0.15u l=0.13u
X1995 VDD.t993 6to4_0.buff_PI_d32_2.inv_PI_d16$1_0.VIN.t56 6to4_0.buff_PI_d32_2.inv_PI_d32_0.VIN.t26 VDD.t198 sg13_lv_pmos ad=55.5f pd=0.74u as=0.1005p ps=1.34u w=0.15u l=0.13u
X1996 VSS.t328 6to4_0.buff_PI_d32_1.buff_PI_d16$1_0.inv_PI_d4$1_0.VOUT.t19 6to4_0.buff_PI_d32_1.buff_PI_d16$1_0.inv_PI_d8$1_0.VOUT.t23 VSS.t327 sg13_lv_nmos ad=0.1005p pd=1.34u as=55.5f ps=0.74u w=0.15u l=0.13u
X1997 6ph_rosc_0.psdiff_1.buff_d8$1_1.VIN.t5 VSS.t1967 VDD.t1394 VDD.t301 sg13_lv_pmos ad=55.5f pd=0.74u as=55.5f ps=0.74u w=0.15u l=0.13u
X1998 CTRL 6ph_rosc_0.PH0.t10 CTRL VDD.t51 sg13_lv_pmos ad=0.19p pd=1.38u as=0 ps=0 w=1u l=0.13u
X1999 VSS.t197 6ph_rosc_0.psdiff_2.buff_d8$1_0.inv_d8$1_0.VIN 6ph_rosc_0.psdiff_2.VOUTDP VSS.t196 sg13_lv_nmos ad=0.1005p pd=1.34u as=55.5f ps=0.74u w=0.15u l=0.13u
X2000 VSS.t656 6ph_rosc_0.buff_d8$1_0.inv_d8$1_0.VIN 6ph_rosc_0.PH2.t1 VSS.t655 sg13_lv_nmos ad=0.1005p pd=1.34u as=55.5f ps=0.74u w=0.15u l=0.13u
X2001 6to4_0.buff_PI_d32_0.inv_PI_d32_0.VIN 6to4_0.buff_PI_d32_0.inv_PI_d16$1_0.VIN.t62 VDD.t963 VDD.t5 sg13_lv_pmos ad=55.5f pd=0.74u as=55.5f ps=0.74u w=0.15u l=0.13u
X2002 VDD.t1049 6to4_0.buff_PI_d32_2.buff_PI_d16$1_0.inv_PI_d4$1_0.VOUT.t15 6to4_0.buff_PI_d32_2.buff_PI_d16$1_0.inv_PI_d8$1_0.VOUT.t14 VDD.t198 sg13_lv_pmos ad=55.5f pd=0.74u as=0.1005p ps=1.34u w=0.15u l=0.13u
X2003 6to4_0.buff_PI_d32_2.inv_PI_d16$1_0.VIN.t2 6to4_0.buff_PI_d32_2.buff_PI_d16$1_0.inv_PI_d8$1_0.VOUT.t37 VSS.t1232 VSS.t1231 sg13_lv_nmos ad=55.5f pd=0.74u as=0.1005p ps=1.34u w=0.15u l=0.13u
X2004 PH180.t56 6to4_0.buff_PI_d32_3.inv_PI_d32_0.VIN VDD.t700 VDD.t99 sg13_lv_pmos ad=55.5f pd=0.74u as=0.1005p ps=1.34u w=0.15u l=0.13u
X2005 VDD.t465 6ph_rosc_0.buff_d8$1_5.inv_d4$1_0.VIN 6ph_rosc_0.buff_d8$1_5.inv_d8$1_0.VIN VDD.t464 sg13_lv_pmos ad=0.1005p pd=1.34u as=55.5f ps=0.74u w=0.15u l=0.13u
X2006 VDD.t1244 6to4_0.buff_PI_d32_3.buff_PI_d16$1_0.inv_PI_d8$1_0.VOUT.t39 6to4_0.buff_PI_d32_3.inv_PI_d16$1_0.VIN.t47 VDD.t679 sg13_lv_pmos ad=55.5f pd=0.74u as=0.1005p ps=1.34u w=0.15u l=0.13u
X2007 PH0.t58 6to4_0.buff_PI_d32_1.inv_PI_d32_0.VIN VDD.t575 VDD.t173 sg13_lv_pmos ad=0.1005p pd=1.34u as=55.5f ps=0.74u w=0.15u l=0.13u
X2008 6to4_0.buff_PI_d32_0.inv_PI_d16$1_0.VIN.t24 6to4_0.buff_PI_d32_0.buff_PI_d16$1_0.inv_PI_d8$1_0.VOUT.t32 VSS.t1628 VSS.t1627 sg13_lv_nmos ad=55.5f pd=0.74u as=0.1005p ps=1.34u w=0.15u l=0.13u
X2009 6to4_0.buff_PI_d32_2.inv_PI_d32_0.VIN.t6 6to4_0.buff_PI_d32_2.inv_PI_d16$1_0.VIN.t50 VSS.t1446 VSS.t1445 sg13_lv_nmos ad=55.5f pd=0.74u as=0.1005p ps=1.34u w=0.15u l=0.13u
X2010 PH90.t53 6to4_0.buff_PI_d32_0.inv_PI_d32_0.VIN VDD.t365 VDD.t5 sg13_lv_pmos ad=55.5f pd=0.74u as=55.5f ps=0.74u w=0.15u l=0.13u
X2011 CTRL 6ph_rosc_0.PH0.t10 CTRL VDD.t51 sg13_lv_pmos ad=0.19p pd=1.38u as=0 ps=0 w=1u l=0.13u
X2012 VDD.t853 6to4_0.buff_PI_d32_0.buff_PI_d16$1_0.inv_PI_d4$1_0.VOUT.t18 6to4_0.buff_PI_d32_0.buff_PI_d16$1_0.inv_PI_d8$1_0.VOUT.t20 VDD.t341 sg13_lv_pmos ad=0.1005p pd=1.34u as=55.5f ps=0.74u w=0.15u l=0.13u
X2013 VDD.t1159 6to4_0.buff_PI_d32_1.buff_PI_d16$1_0.inv_PI_d8$1_0.VOUT.t37 6to4_0.buff_PI_d32_1.inv_PI_d16$1_0.VIN VDD.t173 sg13_lv_pmos ad=55.5f pd=0.74u as=55.5f ps=0.74u w=0.15u l=0.13u
X2014 6ph_rosc_0.psdiff_1.buff_d8$1_1.VIN.t4 VSS.t1967 VDD.t1393 VDD.t301 sg13_lv_pmos ad=55.5f pd=0.74u as=55.5f ps=0.74u w=0.15u l=0.13u
X2015 VSS.t877 6to4_0.buff_PI_d32_1.inv_PI_d32_0.VIN PH0.t15 VSS.t876 sg13_lv_nmos ad=0.1005p pd=1.34u as=55.5f ps=0.74u w=0.15u l=0.13u
X2016 VSS.t821 6ph_rosc_0.psdiff_1.VOUTDP 6ph_rosc_0.psdiff_0.buff_d8$1_0.VIN.t25 VSS.t495 sg13_lv_nmos ad=55.5f pd=0.74u as=55.5f ps=0.74u w=0.15u l=0.13u
X2017 PH270.t16 6to4_0.buff_PI_d32_2.inv_PI_d32_0.VIN.t74 VSS.t436 VSS.t435 sg13_lv_nmos ad=55.5f pd=0.74u as=0.1005p ps=1.34u w=0.15u l=0.13u
X2018 VDD.t1313 VSS.t1965 6ph_rosc_0.psdiff_0.buff_d8$1_0.VIN.t4 VDD.t503 sg13_lv_pmos ad=55.5f pd=0.74u as=55.5f ps=0.74u w=0.15u l=0.13u
X2019 VSS.t179 6to4_0.buff_PI_d32_2.buff_PI_d16$1_0.inv_PI_d4$1_0.VIN 6to4_0.buff_PI_d32_2.buff_PI_d16$1_0.inv_PI_d4$1_0.VOUT.t1 VSS.t178 sg13_lv_nmos ad=0.1005p pd=1.34u as=55.5f ps=0.74u w=0.15u l=0.13u
X2020 VDD.t261 6to4_0.buff_PI_d32_2.inv_PI_d32_0.VIN.t68 PH270.t52 VDD.t126 sg13_lv_pmos ad=55.5f pd=0.74u as=55.5f ps=0.74u w=0.15u l=0.13u
X2021 PH180.t55 6to4_0.buff_PI_d32_3.inv_PI_d32_0.VIN VDD.t699 VDD.t677 sg13_lv_pmos ad=0.1005p pd=1.34u as=55.5f ps=0.74u w=0.15u l=0.13u
X2022 6to4_0.buff_PI_d32_2.buff_PI_d16$1_0.inv_PI_d8$1_0.VOUT.t13 6to4_0.buff_PI_d32_2.buff_PI_d16$1_0.inv_PI_d4$1_0.VOUT.t16 VDD.t1052 VDD.t198 sg13_lv_pmos ad=0.1005p pd=1.34u as=55.5f ps=0.74u w=0.15u l=0.13u
X2023 VDD.t1158 6to4_0.buff_PI_d32_1.buff_PI_d16$1_0.inv_PI_d8$1_0.VOUT.t35 6to4_0.buff_PI_d32_1.inv_PI_d16$1_0.VIN VDD.t17 sg13_lv_pmos ad=0.1005p pd=1.34u as=55.5f ps=0.74u w=0.15u l=0.13u
X2024 VSS.t1322 6to4_0.buff_PI_d32_3.inv_PI_d16$1_0.VIN.t54 6to4_0.buff_PI_d32_3.inv_PI_d32_0.VIN VSS.t1321 sg13_lv_nmos ad=0.1005p pd=1.34u as=55.5f ps=0.74u w=0.15u l=0.13u
X2025 VSS.t1582 6ph_rosc_0.psdiff_0.buff_d8$1_0.inv_d8$1_0.VIN 6ph_rosc_0.psdiff_2.CLKN VSS.t1581 sg13_lv_nmos ad=0.1005p pd=1.34u as=55.5f ps=0.74u w=0.15u l=0.13u
X2026 VSS.t161 6ph_rosc_0.psdiff_1.buff_d8$1_0.inv_d2$1_0.VIN 6ph_rosc_0.psdiff_1.buff_d8$1_0.inv_d4$1_0.VIN VSS.t160 sg13_lv_nmos ad=0.1005p pd=1.34u as=55.5f ps=0.74u w=0.15u l=0.13u
X2027 VDD.t364 6to4_0.buff_PI_d32_0.inv_PI_d32_0.VIN PH90.t52 VDD.t341 sg13_lv_pmos ad=55.5f pd=0.74u as=0.1005p ps=1.34u w=0.15u l=0.13u
X2028 6ph_rosc_0.PH1.t0 6ph_rosc_0.buff_d8$1_3.inv_d8$1_0.VIN VSS.t254 VSS.t253 sg13_lv_nmos ad=55.5f pd=0.74u as=0.1005p ps=1.34u w=0.15u l=0.13u
X2029 VDD.t149 6ph_rosc_0.buff_d8$1_3.inv_d8$1_0.VIN 6ph_rosc_0.PH1.t5 VDD.t75 sg13_lv_pmos ad=0.1005p pd=1.34u as=55.5f ps=0.74u w=0.15u l=0.13u
X2030 VDD.t443 6ph_rosc_0.buff_d8$1_0.inv_d8$1_0.VIN 6ph_rosc_0.PH2.t6 VDD.t80 sg13_lv_pmos ad=0.1005p pd=1.34u as=55.5f ps=0.74u w=0.15u l=0.13u
X2031 VSS.t87 6to4_0.buff_PI_d32_0.buff_PI_d16$1_0.inv_PI_d4$1_0.VIN 6to4_0.buff_PI_d32_0.buff_PI_d16$1_0.inv_PI_d4$1_0.VOUT.t1 VSS.t86 sg13_lv_nmos ad=0.1005p pd=1.34u as=55.5f ps=0.74u w=0.15u l=0.13u
X2032 VDD.t656 6ph_rosc_0.psdiff_1.buff_d8$1_0.inv_d8$1_0.VIN 6ph_rosc_0.psdiff_1.VOUTDP VDD.t34 sg13_lv_pmos ad=0.1005p pd=1.34u as=55.5f ps=0.74u w=0.15u l=0.13u
X2033 PH180.t54 6to4_0.buff_PI_d32_3.inv_PI_d32_0.VIN VDD.t698 VDD.t673 sg13_lv_pmos ad=55.5f pd=0.74u as=0.1005p ps=1.34u w=0.15u l=0.13u
X2034 VDD.t1123 6to4_0.buff_PI_d32_0.buff_PI_d16$1_0.inv_PI_d8$1_0.VOUT.t38 6to4_0.buff_PI_d32_0.inv_PI_d16$1_0.VIN.t44 VDD.t341 sg13_lv_pmos ad=55.5f pd=0.74u as=0.1005p ps=1.34u w=0.15u l=0.13u
X2035 6to4_0.buff_PI_d32_3.inv_PI_d16$1_0.VIN.t7 6to4_0.buff_PI_d32_3.buff_PI_d16$1_0.inv_PI_d8$1_0.VOUT.t26 VDD.t1204 VDD.t99 sg13_lv_pmos ad=55.5f pd=0.74u as=0.1005p ps=1.34u w=0.15u l=0.13u
X2036 VDD.t574 6to4_0.buff_PI_d32_1.inv_PI_d32_0.VIN PH0.t57 VDD.t17 sg13_lv_pmos ad=0.1005p pd=1.34u as=55.5f ps=0.74u w=0.15u l=0.13u
X2037 6to4_0.buff_PI_d32_0.buff_PI_d16$1_0.inv_PI_d8$1_0.VOUT.t9 6to4_0.buff_PI_d32_0.buff_PI_d16$1_0.inv_PI_d4$1_0.VOUT.t15 VSS.t1268 VSS.t1267 sg13_lv_nmos ad=55.5f pd=0.74u as=0.1005p ps=1.34u w=0.15u l=0.13u
X2038 VSS.t11 6to4_0.flywheel_clk_0.PH0 6to4_0.buff_PI_d32_2.VIN VSS.t10 sg13_lv_nmos ad=0.1005p pd=1.34u as=55.5f ps=0.74u w=0.15u l=0.13u
X2039 VDD.t104 6to4_0.buff_PI_d32_3.buff_PI_d16$1_0.inv_PI_d4$1_0.VIN 6to4_0.buff_PI_d32_3.buff_PI_d16$1_0.inv_PI_d4$1_0.VOUT.t8 VDD.t99 sg13_lv_pmos ad=55.5f pd=0.74u as=0.1005p ps=1.34u w=0.15u l=0.13u
X2040 VDD.t809 6to4_0.buff_PI_d32_2.buff_PI_d16$1_0.inv_PI_d8$1_0.VOUT.t35 6to4_0.buff_PI_d32_2.inv_PI_d16$1_0.VIN.t28 VDD.t126 sg13_lv_pmos ad=0.1005p pd=1.34u as=55.5f ps=0.74u w=0.15u l=0.13u
X2041 VDD.t959 6to4_0.buff_PI_d32_0.inv_PI_d16$1_0.VIN.t61 6to4_0.buff_PI_d32_0.inv_PI_d32_0.VIN VDD.t5 sg13_lv_pmos ad=55.5f pd=0.74u as=55.5f ps=0.74u w=0.15u l=0.13u
X2042 CTRL 6ph_rosc_0.PH2.t10 CTRL VDD.t89 sg13_lv_pmos ad=0.19p pd=1.38u as=0 ps=0 w=1u l=0.13u
X2043 VSS.t225 6ph_rosc_0.psdiff_2.VOUTDP 6ph_rosc_0.psdiff_1.buff_d8$1_0.VIN.t9 VSS.t224 sg13_lv_nmos ad=55.5f pd=0.74u as=55.5f ps=0.74u w=0.15u l=0.13u
X2044 6ph_rosc_0.psdiff_0.buff_d8$1_1.VIN.t24 6ph_rosc_0.psdiff_1.VOUTDN VSS.t1940 VSS.t1939 sg13_lv_nmos ad=55.5f pd=0.74u as=0.1005p ps=1.34u w=0.15u l=0.13u
X2045 6ph_rosc_0.psdiff_2.VOUTDP 6ph_rosc_0.psdiff_2.buff_d8$1_0.inv_d8$1_0.VIN VDD.t141 VDD.t34 sg13_lv_pmos ad=55.5f pd=0.74u as=0.1005p ps=1.34u w=0.15u l=0.13u
X2046 6to4_0.buff_PI_d32_2.inv_PI_d16$1_0.VIN.t0 6to4_0.buff_PI_d32_2.buff_PI_d16$1_0.inv_PI_d8$1_0.VOUT.t24 VSS.t1180 VSS.t1179 sg13_lv_nmos ad=55.5f pd=0.74u as=0.1005p ps=1.34u w=0.15u l=0.13u
X2047 VDD.t305 a_7973_2194# 6ph_rosc_0.psdiff_1.buff_d8$1_0.VIN.t28 VDD.t301 sg13_lv_pmos ad=55.5f pd=0.74u as=55.5f ps=0.74u w=0.15u l=0.13u
X2048 6to4_0.buff_PI_d32_0.inv_PI_d32_0.VIN 6to4_0.buff_PI_d32_0.inv_PI_d16$1_0.VIN.t58 VSS.t1416 VSS.t1415 sg13_lv_nmos ad=55.5f pd=0.74u as=0.1005p ps=1.34u w=0.15u l=0.13u
X2049 VSS.t440 6to4_0.buff_PI_d32_2.inv_PI_d32_0.VIN.t75 PH270.t15 VSS.t439 sg13_lv_nmos ad=0.1005p pd=1.34u as=55.5f ps=0.74u w=0.15u l=0.13u
X2050 6to4_0.buff_PI_d32_3.inv_PI_d32_0.VIN 6to4_0.buff_PI_d32_3.inv_PI_d16$1_0.VIN.t58 VSS.t1338 VSS.t1337 sg13_lv_nmos ad=55.5f pd=0.74u as=0.1005p ps=1.34u w=0.15u l=0.13u
X2051 6to4_0.buff_PI_d32_1.inv_PI_d16$1_0.VIN 6to4_0.buff_PI_d32_1.buff_PI_d16$1_0.inv_PI_d8$1_0.VOUT.t34 VDD.t1157 VDD.t173 sg13_lv_pmos ad=55.5f pd=0.74u as=55.5f ps=0.74u w=0.15u l=0.13u
X2052 PH270.t32 6to4_0.buff_PI_d32_2.inv_PI_d32_0.VIN.t79 VDD.t295 VDD.t198 sg13_lv_pmos ad=55.5f pd=0.74u as=0.1005p ps=1.34u w=0.15u l=0.13u
X2053 CTRL 6ph_rosc_0.PH2.t10 CTRL VDD.t440 sg13_lv_pmos ad=0.19p pd=1.38u as=0 ps=0 w=1u l=0.13u
X2054 6ph_rosc_0.psdiff_1.buff_d8$1_1.VIN.t24 6ph_rosc_0.psdiff_2.VOUTDN VSS.t1147 VSS.t1140 sg13_lv_nmos ad=55.5f pd=0.74u as=55.5f ps=0.74u w=0.15u l=0.13u
X2055 VSS.t223 6ph_rosc_0.psdiff_2.VOUTDP 6ph_rosc_0.psdiff_1.buff_d8$1_0.VIN.t8 VSS.t222 sg13_lv_nmos ad=55.5f pd=0.74u as=55.5f ps=0.74u w=0.15u l=0.13u
X2056 6ph_rosc_0.psdiff_0.buff_d8$1_0.inv_d8$1_0.VIN 6ph_rosc_0.psdiff_0.buff_d8$1_0.inv_d4$1_0.VIN VDD.t859 VDD.t34 sg13_lv_pmos ad=55.5f pd=0.74u as=0.1005p ps=1.34u w=0.15u l=0.13u
X2057 VDD.t1243 6to4_0.buff_PI_d32_3.buff_PI_d16$1_0.inv_PI_d8$1_0.VOUT.t39 6to4_0.buff_PI_d32_3.inv_PI_d16$1_0.VIN.t46 VDD.t679 sg13_lv_pmos ad=0.1005p pd=1.34u as=55.5f ps=0.74u w=0.15u l=0.13u
X2058 VSS.t1877 6to4_0.buff_PI_d32_1.inv_PI_d16$1_0.VIN 6to4_0.buff_PI_d32_1.inv_PI_d32_0.VIN VSS.t1876 sg13_lv_nmos ad=0.1005p pd=1.34u as=55.5f ps=0.74u w=0.15u l=0.13u
X2059 VDD.t1312 VSS.t1965 6ph_rosc_0.psdiff_0.buff_d8$1_0.VIN.t3 VDD.t503 sg13_lv_pmos ad=55.5f pd=0.74u as=55.5f ps=0.74u w=0.15u l=0.13u
X2060 VSS.t1033 6to4_0.buff_PI_d32_3.inv_PI_d32_0.VIN PH180.t13 VSS.t1032 sg13_lv_nmos ad=0.1005p pd=1.34u as=55.5f ps=0.74u w=0.15u l=0.13u
X2061 6to4_0.buff_PI_d32_1.inv_PI_d16$1_0.VIN 6to4_0.buff_PI_d32_1.buff_PI_d16$1_0.inv_PI_d8$1_0.VOUT.t30 VDD.t1156 VDD.t17 sg13_lv_pmos ad=0.1005p pd=1.34u as=55.5f ps=0.74u w=0.15u l=0.13u
X2062 PH270.t14 6to4_0.buff_PI_d32_2.inv_PI_d32_0.VIN.t72 VSS.t428 VSS.t427 sg13_lv_nmos ad=55.5f pd=0.74u as=0.1005p ps=1.34u w=0.15u l=0.13u
X2063 VSS.t1562 6to4_0.buff_PI_d32_2.buff_PI_d16$1_0.inv_PI_d4$1_0.VOUT.t19 6to4_0.buff_PI_d32_2.buff_PI_d16$1_0.inv_PI_d8$1_0.VOUT.t3 VSS.t1561 sg13_lv_nmos ad=0.1005p pd=1.34u as=55.5f ps=0.74u w=0.15u l=0.13u
X2064 PH0.t56 6to4_0.buff_PI_d32_1.inv_PI_d32_0.VIN VDD.t549 VDD.t173 sg13_lv_pmos ad=55.5f pd=0.74u as=55.5f ps=0.74u w=0.15u l=0.13u
X2065 6ph_rosc_0.psdiff_1.buff_d8$1_1.VIN.t23 6ph_rosc_0.psdiff_2.VOUTDN VSS.t1146 VSS.t1145 sg13_lv_nmos ad=55.5f pd=0.74u as=0.1005p ps=1.34u w=0.15u l=0.13u
X2066 6ph_rosc_0.psdiff_1.buff_d8$1_1.VIN.t22 6ph_rosc_0.psdiff_2.VOUTDN VSS.t1144 VSS.t500 sg13_lv_nmos ad=55.5f pd=0.74u as=55.5f ps=0.74u w=0.15u l=0.13u
X2067 PH180.t53 6to4_0.buff_PI_d32_3.inv_PI_d32_0.VIN VDD.t697 VDD.t677 sg13_lv_pmos ad=55.5f pd=0.74u as=55.5f ps=0.74u w=0.15u l=0.13u
X2068 VDD.t992 6to4_0.buff_PI_d32_2.inv_PI_d16$1_0.VIN.t56 6to4_0.buff_PI_d32_2.inv_PI_d32_0.VIN.t25 VDD.t198 sg13_lv_pmos ad=0.1005p pd=1.34u as=55.5f ps=0.74u w=0.15u l=0.13u
X2069 VDD.t696 6to4_0.buff_PI_d32_3.inv_PI_d32_0.VIN PH180.t52 VDD.t677 sg13_lv_pmos ad=55.5f pd=0.74u as=55.5f ps=0.74u w=0.15u l=0.13u
X2070 6to4_0.buff_PI_d32_2.inv_PI_d16$1_0.VIN.t27 6to4_0.buff_PI_d32_2.buff_PI_d16$1_0.inv_PI_d8$1_0.VOUT.t29 VDD.t791 VDD.t126 sg13_lv_pmos ad=0.1005p pd=1.34u as=55.5f ps=0.74u w=0.15u l=0.13u
X2071 VSS.t476 6ph_rosc_0.buff_d8$1_1.inv_d8$1_0.VIN 6ph_rosc_0.PH5.t0 VSS.t475 sg13_lv_nmos ad=0.1005p pd=1.34u as=55.5f ps=0.74u w=0.15u l=0.13u
X2072 VDD.t572 6to4_0.buff_PI_d32_1.inv_PI_d32_0.VIN PH0.t55 VDD.t547 sg13_lv_pmos ad=55.5f pd=0.74u as=0.1005p ps=1.34u w=0.15u l=0.13u
X2073 VSS.t554 6to4_0.buff_PI_d32_0.inv_PI_d32_0.VIN PH90.t14 VSS.t553 sg13_lv_nmos ad=0.1005p pd=1.34u as=55.5f ps=0.74u w=0.15u l=0.13u
X2074 6to4_0.buff_PI_d32_1.buff_PI_d16$1_0.inv_PI_d8$1_0.VOUT.t20 6to4_0.buff_PI_d32_1.buff_PI_d16$1_0.inv_PI_d4$1_0.VOUT.t18 VSS.t324 VSS.t323 sg13_lv_nmos ad=55.5f pd=0.74u as=0.1005p ps=1.34u w=0.15u l=0.13u
X2075 VSS.t820 6ph_rosc_0.psdiff_1.VOUTDP 6ph_rosc_0.psdiff_0.buff_d8$1_0.VIN.t24 VSS.t819 sg13_lv_nmos ad=0.1005p pd=1.34u as=55.5f ps=0.74u w=0.15u l=0.13u
X2076 VDD.t648 a_4999_2194# 6ph_rosc_0.psdiff_2.buff_d8$1_0.VIN.t30 VDD.t470 sg13_lv_pmos ad=55.5f pd=0.74u as=55.5f ps=0.74u w=0.15u l=0.13u
X2077 6ph_rosc_0.PH0.t1 6ph_rosc_0.buff_d8$1_5.inv_d8$1_0.VIN VSS.t71 VSS.t70 sg13_lv_nmos ad=55.5f pd=0.74u as=0.1005p ps=1.34u w=0.15u l=0.13u
X2078 CTRL 6ph_rosc_0.PH1.t10 CTRL VDD.t82 sg13_lv_pmos ad=0.19p pd=1.38u as=0 ps=0 w=1u l=0.13u
X2079 VDD.t10 6to4_0.flywheel_clk_0.PH0 6to4_0.buff_PI_d32_2.VIN VDD.t9 sg13_lv_pmos ad=0.1005p pd=1.34u as=55.5f ps=0.74u w=0.15u l=0.13u
X2080 6ph_rosc_0.psdiff_1.buff_d8$1_0.VIN.t7 6ph_rosc_0.psdiff_2.VOUTDP VSS.t221 VSS.t220 sg13_lv_nmos ad=55.5f pd=0.74u as=55.5f ps=0.74u w=0.15u l=0.13u
X2081 6ph_rosc_0.psdiff_0.buff_d8$1_0.VIN.t23 6ph_rosc_0.psdiff_1.VOUTDP VSS.t818 VSS.t815 sg13_lv_nmos ad=55.5f pd=0.74u as=55.5f ps=0.74u w=0.15u l=0.13u
X2082 6ph_rosc_0.psdiff_1.buff_d8$1_0.VIN.t20 VSS.t1967 VDD.t1392 VDD.t301 sg13_lv_pmos ad=55.5f pd=0.74u as=55.5f ps=0.74u w=0.15u l=0.13u
X2083 6ph_rosc_0.buff_d8$1_1.inv_d2$1_0.VIN 6ph_rosc_0.psdiff_2.CLKN VSS.t703 VSS.t702 sg13_lv_nmos ad=0.1005p pd=1.34u as=0.1005p ps=1.34u w=0.15u l=0.13u
X2084 CTRL 6ph_rosc_0.PH0.t10 CTRL VDD.t51 sg13_lv_pmos ad=0.19p pd=1.38u as=0 ps=0 w=1u l=0.13u
X2085 VDD.t678 6to4_0.buff_PI_d32_3.inv_PI_d32_0.VIN PH180.t51 VDD.t677 sg13_lv_pmos ad=55.5f pd=0.74u as=0.1005p ps=1.34u w=0.15u l=0.13u
X2086 VSS.t1845 6to4_0.buff_PI_d32_3.buff_PI_d16$1_0.inv_PI_d8$1_0.VOUT.t38 6to4_0.buff_PI_d32_3.inv_PI_d16$1_0.VIN.t42 VSS.t1844 sg13_lv_nmos ad=0.1005p pd=1.34u as=55.5f ps=0.74u w=0.15u l=0.13u
X2087 PH270.t51 6to4_0.buff_PI_d32_2.inv_PI_d32_0.VIN.t70 VDD.t268 VDD.t126 sg13_lv_pmos ad=0.1005p pd=1.34u as=55.5f ps=0.74u w=0.15u l=0.13u
X2088 6to4_0.buff_PI_d32_1.inv_PI_d32_0.VIN 6to4_0.buff_PI_d32_1.inv_PI_d16$1_0.VIN VSS.t1875 VSS.t1874 sg13_lv_nmos ad=55.5f pd=0.74u as=0.1005p ps=1.34u w=0.15u l=0.13u
X2089 6ph_rosc_0.psdiff_0.buff_d8$1_0.VIN.t22 6ph_rosc_0.psdiff_1.VOUTDP VSS.t817 VSS.t499 sg13_lv_nmos ad=55.5f pd=0.74u as=55.5f ps=0.74u w=0.15u l=0.13u
X2090 VDD.t1122 6to4_0.buff_PI_d32_0.buff_PI_d16$1_0.inv_PI_d8$1_0.VOUT.t38 6to4_0.buff_PI_d32_0.inv_PI_d16$1_0.VIN.t43 VDD.t341 sg13_lv_pmos ad=0.1005p pd=1.34u as=55.5f ps=0.74u w=0.15u l=0.13u
X2091 VDD.t647 a_4999_2194# 6ph_rosc_0.psdiff_2.buff_d8$1_0.VIN.t29 VDD.t470 sg13_lv_pmos ad=55.5f pd=0.74u as=55.5f ps=0.74u w=0.15u l=0.13u
X2092 CTRL 6ph_rosc_0.PH1.t10 CTRL VDD.t82 sg13_lv_pmos ad=0.19p pd=1.38u as=0 ps=0 w=1u l=0.13u
X2093 VDD.t887 6to4_0.buff_PI_d32_3.inv_PI_d16$1_0.VIN.t56 6to4_0.buff_PI_d32_3.inv_PI_d32_0.VIN VDD.t679 sg13_lv_pmos ad=0.1005p pd=1.34u as=55.5f ps=0.74u w=0.15u l=0.13u
X2094 6ph_rosc_0.psdiff_1.buff_d8$1_0.VIN.t6 6ph_rosc_0.psdiff_2.VOUTDP VSS.t219 VSS.t218 sg13_lv_nmos ad=55.5f pd=0.74u as=55.5f ps=0.74u w=0.15u l=0.13u
X2095 6ph_rosc_0.psdiff_1.buff_d8$1_0.VIN.t19 VSS.t1967 VDD.t1391 VDD.t301 sg13_lv_pmos ad=55.5f pd=0.74u as=55.5f ps=0.74u w=0.15u l=0.13u
X2096 CTRL 6ph_rosc_0.PH0.t10 CTRL VDD.t51 sg13_lv_pmos ad=0.34p pd=2.68u as=0 ps=0 w=1u l=0.13u
X2097 VDD.t363 6to4_0.buff_PI_d32_0.inv_PI_d32_0.VIN PH90.t51 VDD.t341 sg13_lv_pmos ad=0.1005p pd=1.34u as=55.5f ps=0.74u w=0.15u l=0.13u
X2098 VDD.t571 6to4_0.buff_PI_d32_1.inv_PI_d32_0.VIN PH0.t54 VDD.t173 sg13_lv_pmos ad=55.5f pd=0.74u as=55.5f ps=0.74u w=0.15u l=0.13u
X2099 PH0.t53 6to4_0.buff_PI_d32_1.inv_PI_d32_0.VIN VDD.t570 VDD.t547 sg13_lv_pmos ad=55.5f pd=0.74u as=0.1005p ps=1.34u w=0.15u l=0.13u
X2100 PH180.t50 6to4_0.buff_PI_d32_3.inv_PI_d32_0.VIN VDD.t694 VDD.t673 sg13_lv_pmos ad=0.1005p pd=1.34u as=55.5f ps=0.74u w=0.15u l=0.13u
X2101 VDD.t782 6to4_0.buff_PI_d32_2.buff_PI_d16$1_0.inv_PI_d8$1_0.VOUT.t26 6to4_0.buff_PI_d32_2.inv_PI_d16$1_0.VIN.t26 VDD.t198 sg13_lv_pmos ad=55.5f pd=0.74u as=55.5f ps=0.74u w=0.15u l=0.13u
X2102 PH0.t14 6to4_0.buff_PI_d32_1.inv_PI_d32_0.VIN VSS.t875 VSS.t874 sg13_lv_nmos ad=55.5f pd=0.74u as=0.1005p ps=1.34u w=0.15u l=0.13u
X2103 6to4_0.buff_PI_d32_2.inv_PI_d32_0.VIN.t28 6to4_0.buff_PI_d32_2.inv_PI_d16$1_0.VIN.t57 VDD.t995 VDD.t198 sg13_lv_pmos ad=0.1005p pd=1.34u as=55.5f ps=0.74u w=0.15u l=0.13u
X2104 VSS.t452 6to4_0.buff_PI_d32_2.inv_PI_d32_0.VIN.t78 PH270.t13 VSS.t451 sg13_lv_nmos ad=0.1005p pd=1.34u as=55.5f ps=0.74u w=0.15u l=0.13u
X2105 6ph_rosc_0.psdiff_0.buff_d8$1_1.VIN.t5 VSS.t1965 VDD.t1311 VDD.t503 sg13_lv_pmos ad=55.5f pd=0.74u as=55.5f ps=0.74u w=0.15u l=0.13u
X2106 VDD.t693 6to4_0.buff_PI_d32_3.inv_PI_d32_0.VIN PH180.t49 VDD.t673 sg13_lv_pmos ad=0.1005p pd=1.34u as=55.5f ps=0.74u w=0.15u l=0.13u
X2107 6to4_0.buff_PI_d32_0.inv_PI_d16$1_0.VIN.t47 6to4_0.buff_PI_d32_0.buff_PI_d16$1_0.inv_PI_d8$1_0.VOUT.t39 VDD.t1126 VDD.t5 sg13_lv_pmos ad=0.1005p pd=1.34u as=55.5f ps=0.74u w=0.15u l=0.13u
X2108 VSS.t552 6to4_0.buff_PI_d32_0.inv_PI_d32_0.VIN PH90.t13 VSS.t551 sg13_lv_nmos ad=0.1005p pd=1.34u as=55.5f ps=0.74u w=0.15u l=0.13u
X2109 6to4_0.buff_PI_d32_3.inv_PI_d16$1_0.VIN.t19 6to4_0.buff_PI_d32_3.buff_PI_d16$1_0.inv_PI_d8$1_0.VOUT.t30 VDD.t1216 VDD.t99 sg13_lv_pmos ad=0.1005p pd=1.34u as=55.5f ps=0.74u w=0.15u l=0.13u
X2110 6to4_0.buff_PI_d32_2.inv_PI_d16$1_0.VIN.t8 6to4_0.buff_PI_d32_2.buff_PI_d16$1_0.inv_PI_d8$1_0.VOUT.t36 VSS.t1226 VSS.t1225 sg13_lv_nmos ad=55.5f pd=0.74u as=0.1005p ps=1.34u w=0.15u l=0.13u
X2111 6ph_rosc_0.psdiff_0.buff_d8$1_1.VIN.t4 VSS.t1965 VDD.t1310 VDD.t503 sg13_lv_pmos ad=55.5f pd=0.74u as=55.5f ps=0.74u w=0.15u l=0.13u
X2112 VDD.t1064 6ph_rosc_0.PH4.t11 6to4_0.PI_clk_1.inv_PI_d2$1_0.VOUT VDD.t126 sg13_lv_pmos ad=0.1005p pd=1.34u as=55.5f ps=0.74u w=0.15u l=0.13u
X2113 VSS.t873 6to4_0.buff_PI_d32_1.inv_PI_d32_0.VIN PH0.t13 VSS.t872 sg13_lv_nmos ad=0.1005p pd=1.34u as=55.5f ps=0.74u w=0.15u l=0.13u
X2114 6ph_rosc_0.psdiff_2.VOUTDP 6ph_rosc_0.psdiff_2.buff_d8$1_0.inv_d8$1_0.VIN VSS.t195 VSS.t194 sg13_lv_nmos ad=55.5f pd=0.74u as=0.1005p ps=1.34u w=0.15u l=0.13u
X2115 VDD.t72 6ph_rosc_0.psdiff_1.buff_d8$1_0.inv_d4$1_0.VIN 6ph_rosc_0.psdiff_1.buff_d8$1_0.inv_d8$1_0.VIN VDD.t34 sg13_lv_pmos ad=0.1005p pd=1.34u as=55.5f ps=0.74u w=0.15u l=0.13u
X2116 PH90.t12 6to4_0.buff_PI_d32_0.inv_PI_d32_0.VIN VSS.t550 VSS.t549 sg13_lv_nmos ad=55.5f pd=0.74u as=0.1005p ps=1.34u w=0.15u l=0.13u
X2117 VDD.t249 6to4_0.buff_PI_d32_2.inv_PI_d32_0.VIN.t64 PH270.t50 VDD.t126 sg13_lv_pmos ad=0.1005p pd=1.34u as=55.5f ps=0.74u w=0.15u l=0.13u
X2118 VSS.t1031 6to4_0.buff_PI_d32_3.inv_PI_d32_0.VIN PH180.t12 VSS.t1030 sg13_lv_nmos ad=0.1005p pd=1.34u as=55.5f ps=0.74u w=0.15u l=0.13u
X2119 CTRL 6ph_rosc_0.PH2.t10 CTRL VDD.t440 sg13_lv_pmos ad=0.19p pd=1.38u as=0 ps=0 w=1u l=0.13u
X2120 6to4_0.buff_PI_d32_0.inv_PI_d16$1_0.VIN.t22 6to4_0.buff_PI_d32_0.buff_PI_d16$1_0.inv_PI_d8$1_0.VOUT.t31 VDD.t1101 VDD.t341 sg13_lv_pmos ad=0.1005p pd=1.34u as=55.5f ps=0.74u w=0.15u l=0.13u
X2121 PH0.t52 6to4_0.buff_PI_d32_1.inv_PI_d32_0.VIN VDD.t569 VDD.t552 sg13_lv_pmos ad=55.5f pd=0.74u as=0.1005p ps=1.34u w=0.15u l=0.13u
X2122 VDD.t449 6ph_rosc_0.buff_d8$1_2.inv_d8$1_0.VIN 6ph_rosc_0.PH4.t6 VDD.t78 sg13_lv_pmos ad=0.1005p pd=1.34u as=55.5f ps=0.74u w=0.15u l=0.13u
X2123 6to4_0.buff_PI_d32_3.inv_PI_d32_0.VIN 6to4_0.buff_PI_d32_3.inv_PI_d16$1_0.VIN.t61 VDD.t902 VDD.t679 sg13_lv_pmos ad=55.5f pd=0.74u as=55.5f ps=0.74u w=0.15u l=0.13u
X2124 6to4_0.buff_PI_d32_0.inv_PI_d32_0.VIN 6to4_0.buff_PI_d32_0.inv_PI_d16$1_0.VIN.t55 VDD.t941 VDD.t5 sg13_lv_pmos ad=55.5f pd=0.74u as=0.1005p ps=1.34u w=0.15u l=0.13u
X2125 VSS.t1580 6ph_rosc_0.psdiff_0.buff_d8$1_0.inv_d8$1_0.VIN 6ph_rosc_0.psdiff_2.CLKN VSS.t1579 sg13_lv_nmos ad=0.1005p pd=1.34u as=55.5f ps=0.74u w=0.15u l=0.13u
X2126 6to4_0.inv_PI_d2$1_3.VOUT 6ph_rosc_0.PH3.t12 VSS.t1857 VSS.t1856 sg13_lv_nmos ad=55.5f pd=0.74u as=0.1005p ps=1.34u w=0.15u l=0.13u
X2127 6ph_rosc_0.psdiff_1.buff_d8$1_1.inv_d8$1_0.VIN 6ph_rosc_0.psdiff_1.buff_d8$1_1.inv_d4$1_0.VIN VSS.t1 VSS.t0 sg13_lv_nmos ad=55.5f pd=0.74u as=0.1005p ps=1.34u w=0.15u l=0.13u
X2128 VSS.t1302 6to4_0.buff_PI_d32_3.inv_PI_d16$1_0.VIN.t49 6to4_0.buff_PI_d32_3.inv_PI_d32_0.VIN VSS.t1301 sg13_lv_nmos ad=0.1005p pd=1.34u as=55.5f ps=0.74u w=0.15u l=0.13u
X2129 VDD.t905 6to4_0.buff_PI_d32_3.inv_PI_d16$1_0.VIN.t62 6to4_0.buff_PI_d32_3.inv_PI_d32_0.VIN VDD.t679 sg13_lv_pmos ad=55.5f pd=0.74u as=55.5f ps=0.74u w=0.15u l=0.13u
X2130 CTRL 6ph_rosc_0.PH2.t10 CTRL VDD.t440 sg13_lv_pmos ad=0.19p pd=1.38u as=0 ps=0 w=1u l=0.13u
X2131 PH90.t50 6to4_0.buff_PI_d32_0.inv_PI_d32_0.VIN VDD.t362 VDD.t347 sg13_lv_pmos ad=0.1005p pd=1.34u as=55.5f ps=0.74u w=0.15u l=0.13u
X2132 VSS.t833 6ph_rosc_0.psdiff_1.VOUTDN 6ph_rosc_0.psdiff_0.buff_d8$1_1.VIN.t23 VSS.t1938 sg13_lv_nmos ad=55.5f pd=0.74u as=55.5f ps=0.74u w=0.15u l=0.13u
X2133 PH0.t12 6to4_0.buff_PI_d32_1.inv_PI_d32_0.VIN VSS.t871 VSS.t870 sg13_lv_nmos ad=55.5f pd=0.74u as=0.1005p ps=1.34u w=0.15u l=0.13u
X2134 VDD.t568 6to4_0.buff_PI_d32_1.inv_PI_d32_0.VIN PH0.t51 VDD.t173 sg13_lv_pmos ad=55.5f pd=0.74u as=0.1005p ps=1.34u w=0.15u l=0.13u
X2135 VSS.t995 6to4_0.buff_PI_d32_2.VIN 6to4_0.flywheel_clk_0.PH0 VSS.t994 sg13_lv_nmos ad=0.1005p pd=1.34u as=55.5f ps=0.74u w=0.15u l=0.13u
X2136 6to4_0.buff_PI_d32_2.inv_PI_d16$1_0.VIN.t25 6to4_0.buff_PI_d32_2.buff_PI_d16$1_0.inv_PI_d8$1_0.VOUT.t32 VDD.t800 VDD.t198 sg13_lv_pmos ad=55.5f pd=0.74u as=55.5f ps=0.74u w=0.15u l=0.13u
X2137 VDD.t120 6to4_0.PI_clk_0.inv_PI_d2$1_0.VOUT 6to4_0.flywheel_clk_0.PH0 VDD.t9 sg13_lv_pmos ad=55.5f pd=0.74u as=0.1005p ps=1.34u w=0.15u l=0.13u
X2138 6ph_rosc_0.PH0.t5 6ph_rosc_0.buff_d8$1_5.inv_d8$1_0.VIN VDD.t50 VDD.t48 sg13_lv_pmos ad=55.5f pd=0.74u as=0.1005p ps=1.34u w=0.15u l=0.13u
X2139 PH180.t11 6to4_0.buff_PI_d32_3.inv_PI_d32_0.VIN VSS.t1029 VSS.t1028 sg13_lv_nmos ad=55.5f pd=0.74u as=0.1005p ps=1.34u w=0.15u l=0.13u
X2140 VDD.t858 6ph_rosc_0.psdiff_0.buff_d8$1_0.VIN.t32 6ph_rosc_0.psdiff_0.buff_d8$1_0.inv_d2$1_0.VIN VDD.t34 sg13_lv_pmos ad=0.1005p pd=1.34u as=0.1005p ps=1.34u w=0.15u l=0.13u
X2141 VDD.t361 6to4_0.buff_PI_d32_0.inv_PI_d32_0.VIN PH90.t49 VDD.t343 sg13_lv_pmos ad=55.5f pd=0.74u as=0.1005p ps=1.34u w=0.15u l=0.13u
X2142 VSS.t456 6to4_0.buff_PI_d32_2.inv_PI_d32_0.VIN.t79 PH270.t12 VSS.t455 sg13_lv_nmos ad=0.1005p pd=1.34u as=55.5f ps=0.74u w=0.15u l=0.13u
X2143 PH270.t49 6to4_0.buff_PI_d32_2.inv_PI_d32_0.VIN.t74 VDD.t280 VDD.t202 sg13_lv_pmos ad=0.1005p pd=1.34u as=55.5f ps=0.74u w=0.15u l=0.13u
X2144 6to4_0.buff_PI_d32_1.buff_PI_d16$1_0.inv_PI_d4$1_0.VOUT.t6 6to4_0.buff_PI_d32_1.buff_PI_d16$1_0.inv_PI_d4$1_0.VIN VDD.t20 VDD.t17 sg13_lv_pmos ad=55.5f pd=0.74u as=0.1005p ps=1.34u w=0.15u l=0.13u
X2145 6to4_0.buff_PI_d32_3.inv_PI_d32_0.VIN 6to4_0.buff_PI_d32_3.inv_PI_d16$1_0.VIN.t58 VDD.t893 VDD.t99 sg13_lv_pmos ad=0.1005p pd=1.34u as=55.5f ps=0.74u w=0.15u l=0.13u
X2146 VSS.t217 6ph_rosc_0.psdiff_2.VOUTDP 6ph_rosc_0.psdiff_1.buff_d8$1_0.VIN.t5 VSS.t214 sg13_lv_nmos ad=55.5f pd=0.74u as=55.5f ps=0.74u w=0.15u l=0.13u
X2147 6to4_0.buff_PI_d32_0.inv_PI_d16$1_0.VIN.t6 6to4_0.buff_PI_d32_0.buff_PI_d16$1_0.inv_PI_d8$1_0.VOUT.t26 VSS.t1602 VSS.t1601 sg13_lv_nmos ad=55.5f pd=0.74u as=0.1005p ps=1.34u w=0.15u l=0.13u
X2148 VDD.t1120 6to4_0.buff_PI_d32_0.buff_PI_d16$1_0.inv_PI_d8$1_0.VOUT.t37 6to4_0.buff_PI_d32_0.inv_PI_d16$1_0.VIN.t41 VDD.t5 sg13_lv_pmos ad=0.1005p pd=1.34u as=55.5f ps=0.74u w=0.15u l=0.13u
X2149 VSS.t1222 6to4_0.buff_PI_d32_2.buff_PI_d16$1_0.inv_PI_d8$1_0.VOUT.t35 6to4_0.buff_PI_d32_2.inv_PI_d16$1_0.VIN.t7 VSS.t1221 sg13_lv_nmos ad=0.1005p pd=1.34u as=55.5f ps=0.74u w=0.15u l=0.13u
X2150 VDD.t1264 6to4_0.buff_PI_d32_1.inv_PI_d16$1_0.VIN 6to4_0.buff_PI_d32_1.inv_PI_d32_0.VIN VDD.t17 sg13_lv_pmos ad=55.5f pd=0.74u as=55.5f ps=0.74u w=0.15u l=0.13u
X2151 VSS.t1410 6to4_0.buff_PI_d32_0.inv_PI_d16$1_0.VIN.t57 6to4_0.buff_PI_d32_0.inv_PI_d32_0.VIN VSS.t1409 sg13_lv_nmos ad=0.1005p pd=1.34u as=55.5f ps=0.74u w=0.15u l=0.13u
X2152 VSS.t1250 6ph_rosc_0.PH0.t14 6to4_0.inv_PI_d2$1_1.VIN VSS.t1249 sg13_lv_nmos ad=0.1005p pd=1.34u as=55.5f ps=0.74u w=0.15u l=0.13u
X2153 6ph_rosc_0.buff_d8$1_0.inv_d8$1_0.VIN 6ph_rosc_0.buff_d8$1_0.inv_d4$1_0.VIN VDD.t86 VDD.t85 sg13_lv_pmos ad=55.5f pd=0.74u as=0.1005p ps=1.34u w=0.15u l=0.13u
X2154 CTRL 6ph_rosc_0.PH1.t10 CTRL VDD.t82 sg13_lv_pmos ad=0.19p pd=1.38u as=0 ps=0 w=1u l=0.13u
X2155 6ph_rosc_0.psdiff_2.buff_d8$1_0.VIN.t2 VSS.t1966 VDD.t1349 VDD.t470 sg13_lv_pmos ad=55.5f pd=0.74u as=55.5f ps=0.74u w=0.15u l=0.13u
X2156 6ph_rosc_0.buff_d8$1_3.inv_d4$1_0.VIN 6ph_rosc_0.buff_d8$1_3.inv_d2$1_0.VIN VSS.t111 VSS.t110 sg13_lv_nmos ad=55.5f pd=0.74u as=0.1005p ps=1.34u w=0.15u l=0.13u
X2157 6to4_0.buff_PI_d32_3.inv_PI_d16$1_0.VIN.t37 6to4_0.buff_PI_d32_3.buff_PI_d16$1_0.inv_PI_d8$1_0.VOUT.t36 VDD.t1234 VDD.t99 sg13_lv_pmos ad=55.5f pd=0.74u as=55.5f ps=0.74u w=0.15u l=0.13u
X2158 VSS.t1741 6to4_0.buff_PI_d32_1.buff_PI_d16$1_0.inv_PI_d8$1_0.VOUT.t38 6to4_0.buff_PI_d32_1.inv_PI_d16$1_0.VIN VSS.t1740 sg13_lv_nmos ad=0.1005p pd=1.34u as=55.5f ps=0.74u w=0.15u l=0.13u
X2159 VSS.t344 6to4_0.buff_PI_d32_2.inv_PI_d32_0.VIN.t51 PH270.t11 VSS.t343 sg13_lv_nmos ad=0.1005p pd=1.34u as=55.5f ps=0.74u w=0.15u l=0.13u
X2160 6to4_0.buff_PI_d32_3.inv_PI_d16$1_0.VIN.t21 6to4_0.buff_PI_d32_3.buff_PI_d16$1_0.inv_PI_d8$1_0.VOUT.t31 VSS.t1817 VSS.t1816 sg13_lv_nmos ad=55.5f pd=0.74u as=0.1005p ps=1.34u w=0.15u l=0.13u
X2161 6ph_rosc_0.psdiff_2.buff_d8$1_0.VIN.t16 6ph_rosc_0.psdiff_2.CLKN VSS.t701 VSS.t700 sg13_lv_nmos ad=55.5f pd=0.74u as=55.5f ps=0.74u w=0.15u l=0.13u
X2162 CTRL 6ph_rosc_0.PH1.t10 CTRL VDD.t82 sg13_lv_pmos ad=0.19p pd=1.38u as=0 ps=0 w=1u l=0.13u
X2163 VDD.t692 6to4_0.buff_PI_d32_3.inv_PI_d32_0.VIN PH180.t48 VDD.t679 sg13_lv_pmos ad=55.5f pd=0.74u as=55.5f ps=0.74u w=0.15u l=0.13u
X2164 VSS.t1027 6to4_0.buff_PI_d32_3.inv_PI_d32_0.VIN PH180.t10 VSS.t1026 sg13_lv_nmos ad=0.1005p pd=1.34u as=55.5f ps=0.74u w=0.15u l=0.13u
X2165 6ph_rosc_0.psdiff_2.buff_d8$1_1.VIN.t28 a_6156_2338# VDD.t472 VDD.t470 sg13_lv_pmos ad=55.5f pd=0.74u as=55.5f ps=0.74u w=0.15u l=0.13u
X2166 PH180.t9 6to4_0.buff_PI_d32_3.inv_PI_d32_0.VIN VSS.t1025 VSS.t1024 sg13_lv_nmos ad=55.5f pd=0.74u as=0.1005p ps=1.34u w=0.15u l=0.13u
X2167 6to4_0.inv_PI_d2$1_2.VOUT 6to4_0.flywheel_clk_1.PH0 VSS.t53 VSS.t52 sg13_lv_nmos ad=55.5f pd=0.74u as=0.1005p ps=1.34u w=0.15u l=0.13u
X2168 VDD.t1390 VSS.t1967 6ph_rosc_0.psdiff_1.buff_d8$1_1.VIN.t3 VDD.t301 sg13_lv_pmos ad=55.5f pd=0.74u as=55.5f ps=0.74u w=0.15u l=0.13u
X2169 PH0.t50 6to4_0.buff_PI_d32_1.inv_PI_d32_0.VIN VDD.t567 VDD.t552 sg13_lv_pmos ad=0.1005p pd=1.34u as=55.5f ps=0.74u w=0.15u l=0.13u
X2170 CTRL 6ph_rosc_0.PH3.t11 CTRL VDD.t464 sg13_lv_pmos ad=0.19p pd=1.38u as=0 ps=0 w=1u l=0.13u
X2171 VSS.t1678 6ph_rosc_0.PH2.t13 6ph_rosc_0.PH5.t8 VSS.t1677 sg13_lv_nmos ad=0.1005p pd=1.34u as=55.5f ps=0.74u w=0.15u l=0.13u
X2172 VDD.t691 6to4_0.buff_PI_d32_3.inv_PI_d32_0.VIN PH180.t47 VDD.t679 sg13_lv_pmos ad=55.5f pd=0.74u as=0.1005p ps=1.34u w=0.15u l=0.13u
X2173 PH90.t48 6to4_0.buff_PI_d32_0.inv_PI_d32_0.VIN VDD.t360 VDD.t343 sg13_lv_pmos ad=55.5f pd=0.74u as=0.1005p ps=1.34u w=0.15u l=0.13u
X2174 VDD.t60 6to4_0.buff_PI_d32_0.buff_PI_d16$1_0.inv_PI_d4$1_0.VIN 6to4_0.buff_PI_d32_0.buff_PI_d16$1_0.inv_PI_d4$1_0.VOUT.t5 VDD.t5 sg13_lv_pmos ad=55.5f pd=0.74u as=55.5f ps=0.74u w=0.15u l=0.13u
X2175 6to4_0.buff_PI_d32_1.inv_PI_d32_0.VIN 6to4_0.buff_PI_d32_1.inv_PI_d16$1_0.VIN VDD.t1263 VDD.t173 sg13_lv_pmos ad=55.5f pd=0.74u as=0.1005p ps=1.34u w=0.15u l=0.13u
X2176 VDD.t19 6to4_0.buff_PI_d32_1.buff_PI_d16$1_0.inv_PI_d4$1_0.VIN 6to4_0.buff_PI_d32_1.buff_PI_d16$1_0.inv_PI_d4$1_0.VOUT.t5 VDD.t17 sg13_lv_pmos ad=55.5f pd=0.74u as=0.1005p ps=1.34u w=0.15u l=0.13u
X2177 PH180.t8 6to4_0.buff_PI_d32_3.inv_PI_d32_0.VIN VSS.t1023 VSS.t1022 sg13_lv_nmos ad=55.5f pd=0.74u as=0.1005p ps=1.34u w=0.15u l=0.13u
X2178 PH270.t48 6to4_0.buff_PI_d32_2.inv_PI_d32_0.VIN.t66 VDD.t255 VDD.t215 sg13_lv_pmos ad=0.1005p pd=1.34u as=55.5f ps=0.74u w=0.15u l=0.13u
X2179 6ph_rosc_0.psdiff_2.buff_d8$1_1.VIN.t27 a_6156_2338# VDD.t471 VDD.t470 sg13_lv_pmos ad=55.5f pd=0.74u as=55.5f ps=0.74u w=0.15u l=0.13u
X2180 VSS.t548 6to4_0.buff_PI_d32_0.inv_PI_d32_0.VIN PH90.t11 VSS.t547 sg13_lv_nmos ad=0.1005p pd=1.34u as=55.5f ps=0.74u w=0.15u l=0.13u
X2181 6ph_rosc_0.PH0.t0 6ph_rosc_0.buff_d8$1_5.inv_d8$1_0.VIN VSS.t69 VSS.t68 sg13_lv_nmos ad=55.5f pd=0.74u as=0.1005p ps=1.34u w=0.15u l=0.13u
X2182 VSS.t1494 6to4_0.buff_PI_d32_2.inv_PI_d16$1_0.VIN.t62 6to4_0.buff_PI_d32_2.inv_PI_d32_0.VIN.t42 VSS.t1493 sg13_lv_nmos ad=0.1005p pd=1.34u as=55.5f ps=0.74u w=0.15u l=0.13u
X2183 VDD.t264 6to4_0.buff_PI_d32_2.inv_PI_d32_0.VIN.t69 PH270.t47 VDD.t198 sg13_lv_pmos ad=55.5f pd=0.74u as=55.5f ps=0.74u w=0.15u l=0.13u
X2184 6ph_rosc_0.PH3.t6 6ph_rosc_0.buff_d8$1_4.inv_d8$1_0.VIN VDD.t484 VDD.t75 sg13_lv_pmos ad=55.5f pd=0.74u as=0.1005p ps=1.34u w=0.15u l=0.13u
X2185 CTRL 6ph_rosc_0.PH3.t11 CTRL VDD.t464 sg13_lv_pmos ad=0.19p pd=1.38u as=0 ps=0 w=1u l=0.13u
X2186 6to4_0.buff_PI_d32_1.inv_PI_d16$1_0.VIN 6to4_0.buff_PI_d32_1.buff_PI_d16$1_0.inv_PI_d8$1_0.VOUT.t28 VSS.t1739 VSS.t1738 sg13_lv_nmos ad=55.5f pd=0.74u as=0.1005p ps=1.34u w=0.15u l=0.13u
X2187 VSS.t1422 6to4_0.buff_PI_d32_0.inv_PI_d16$1_0.VIN.t60 6to4_0.buff_PI_d32_0.inv_PI_d32_0.VIN VSS.t1421 sg13_lv_nmos ad=0.1005p pd=1.34u as=55.5f ps=0.74u w=0.15u l=0.13u
X2188 6ph_rosc_0.psdiff_0.buff_d8$1_1.VIN.t10 CTRL a_10947_2194# VSS.t493 sg13_lv_nmos ad=0.1005p pd=1.34u as=55.5f ps=0.74u w=0.15u l=0.13u
X2189 VSS.t699 6ph_rosc_0.psdiff_2.CLKN 6ph_rosc_0.psdiff_2.buff_d8$1_0.VIN.t15 VSS.t697 sg13_lv_nmos ad=55.5f pd=0.74u as=55.5f ps=0.74u w=0.15u l=0.13u
X2190 PH90.t47 6to4_0.buff_PI_d32_0.inv_PI_d32_0.VIN VDD.t359 VDD.t347 sg13_lv_pmos ad=55.5f pd=0.74u as=55.5f ps=0.74u w=0.15u l=0.13u
X2191 6to4_0.buff_PI_d32_2.inv_PI_d16$1_0.VIN.t24 6to4_0.buff_PI_d32_2.buff_PI_d16$1_0.inv_PI_d8$1_0.VOUT.t38 VDD.t818 VDD.t198 sg13_lv_pmos ad=55.5f pd=0.74u as=0.1005p ps=1.34u w=0.15u l=0.13u
X2192 VDD.t530 6ph_rosc_0.psdiff_2.buff_d8$1_1.inv_d8$1_0.VIN 6ph_rosc_0.psdiff_2.VOUTDN VDD.t0 sg13_lv_pmos ad=0.1005p pd=1.34u as=55.5f ps=0.74u w=0.15u l=0.13u
X2193 6to4_0.buff_PI_d32_3.inv_PI_d32_0.VIN 6to4_0.buff_PI_d32_3.inv_PI_d16$1_0.VIN.t52 VDD.t875 VDD.t99 sg13_lv_pmos ad=55.5f pd=0.74u as=55.5f ps=0.74u w=0.15u l=0.13u
X2194 PH270.t10 6to4_0.buff_PI_d32_2.inv_PI_d32_0.VIN.t70 VSS.t420 VSS.t419 sg13_lv_nmos ad=55.5f pd=0.74u as=0.1005p ps=1.34u w=0.15u l=0.13u
X2195 VDD.t896 6to4_0.buff_PI_d32_3.inv_PI_d16$1_0.VIN.t59 6to4_0.buff_PI_d32_3.inv_PI_d32_0.VIN VDD.t99 sg13_lv_pmos ad=55.5f pd=0.74u as=55.5f ps=0.74u w=0.15u l=0.13u
X2196 VDD.t358 6to4_0.buff_PI_d32_0.inv_PI_d32_0.VIN PH90.t46 VDD.t343 sg13_lv_pmos ad=0.1005p pd=1.34u as=55.5f ps=0.74u w=0.15u l=0.13u
X2197 6to4_0.buff_PI_d32_3.inv_PI_d16$1_0.VIN.t30 6to4_0.buff_PI_d32_3.buff_PI_d16$1_0.inv_PI_d8$1_0.VOUT.t34 VSS.t1829 VSS.t1828 sg13_lv_nmos ad=55.5f pd=0.74u as=0.1005p ps=1.34u w=0.15u l=0.13u
X2198 6to4_0.buff_PI_d32_3.buff_PI_d16$1_0.inv_PI_d8$1_0.VOUT.t10 6to4_0.buff_PI_d32_3.buff_PI_d16$1_0.inv_PI_d4$1_0.VOUT.t19 VDD.t1025 VDD.t679 sg13_lv_pmos ad=55.5f pd=0.74u as=55.5f ps=0.74u w=0.15u l=0.13u
X2199 6to4_0.buff_PI_d32_1.buff_PI_d16$1_0.inv_PI_d4$1_0.VIN 6to4_0.flywheel_clk_1.PH0 VDD.t39 VDD.t17 sg13_lv_pmos ad=0.1005p pd=1.34u as=55.5f ps=0.74u w=0.15u l=0.13u
X2200 6ph_rosc_0.buff_d8$1_5.inv_d8$1_0.VIN 6ph_rosc_0.buff_d8$1_5.inv_d4$1_0.VIN VSS.t733 VSS.t732 sg13_lv_nmos ad=55.5f pd=0.74u as=0.1005p ps=1.34u w=0.15u l=0.13u
X2201 VDD.t566 6to4_0.buff_PI_d32_1.inv_PI_d32_0.VIN PH0.t49 VDD.t552 sg13_lv_pmos ad=0.1005p pd=1.34u as=55.5f ps=0.74u w=0.15u l=0.13u
X2202 CTRL 6ph_rosc_0.PH0.t10 CTRL VDD.t57 sg13_lv_pmos ad=0.19p pd=1.38u as=0 ps=0 w=1u l=0.13u
X2203 VSS.t1510 6to4_0.buff_PI_d32_3.buff_PI_d16$1_0.inv_PI_d4$1_0.VOUT.t18 6to4_0.buff_PI_d32_3.buff_PI_d16$1_0.inv_PI_d8$1_0.VOUT.t2 VSS.t1509 sg13_lv_nmos ad=0.1005p pd=1.34u as=55.5f ps=0.74u w=0.15u l=0.13u
X2204 6to4_0.buff_PI_d32_2.inv_PI_d32_0.VIN.t7 6to4_0.buff_PI_d32_2.inv_PI_d16$1_0.VIN.t50 VDD.t974 VDD.t126 sg13_lv_pmos ad=55.5f pd=0.74u as=55.5f ps=0.74u w=0.15u l=0.13u
X2205 PH0.t48 6to4_0.buff_PI_d32_1.inv_PI_d32_0.VIN VDD.t565 VDD.t552 sg13_lv_pmos ad=0.1005p pd=1.34u as=55.5f ps=0.74u w=0.15u l=0.13u
X2206 VSS.t514 6to4_0.inv_PI_d2$1_2.VOUT 6to4_0.buff_PI_d32_3.buff_PI_d16$1_0.inv_PI_d4$1_0.VIN VSS.t513 sg13_lv_nmos ad=0.1005p pd=1.34u as=55.5f ps=0.74u w=0.15u l=0.13u
X2207 6ph_rosc_0.buff_d8$1_4.inv_d8$1_0.VIN 6ph_rosc_0.buff_d8$1_4.inv_d4$1_0.VIN VSS.t688 VSS.t687 sg13_lv_nmos ad=55.5f pd=0.74u as=0.1005p ps=1.34u w=0.15u l=0.13u
X2208 VDD.t899 6to4_0.buff_PI_d32_3.inv_PI_d16$1_0.VIN.t60 6to4_0.buff_PI_d32_3.inv_PI_d32_0.VIN VDD.t99 sg13_lv_pmos ad=55.5f pd=0.74u as=0.1005p ps=1.34u w=0.15u l=0.13u
X2209 6to4_0.buff_PI_d32_3.buff_PI_d16$1_0.inv_PI_d8$1_0.VOUT.t9 6to4_0.buff_PI_d32_3.buff_PI_d16$1_0.inv_PI_d4$1_0.VOUT.t13 VDD.t1032 VDD.t679 sg13_lv_pmos ad=55.5f pd=0.74u as=0.1005p ps=1.34u w=0.15u l=0.13u
X2210 6to4_0.buff_PI_d32_0.buff_PI_d16$1_0.inv_PI_d8$1_0.VOUT.t1 6to4_0.buff_PI_d32_0.buff_PI_d16$1_0.inv_PI_d4$1_0.VOUT.t12 VDD.t834 VDD.t341 sg13_lv_pmos ad=55.5f pd=0.74u as=0.1005p ps=1.34u w=0.15u l=0.13u
X2211 PH270.t46 6to4_0.buff_PI_d32_2.inv_PI_d32_0.VIN.t76 VDD.t285 VDD.t126 sg13_lv_pmos ad=55.5f pd=0.74u as=55.5f ps=0.74u w=0.15u l=0.13u
X2212 VSS.t216 6ph_rosc_0.psdiff_2.VOUTDP 6ph_rosc_0.psdiff_1.buff_d8$1_0.VIN.t4 VSS.t208 sg13_lv_nmos ad=0.1005p pd=1.34u as=55.5f ps=0.74u w=0.15u l=0.13u
X2213 6ph_rosc_0.psdiff_2.VOUTDN 6ph_rosc_0.psdiff_2.buff_d8$1_1.inv_d8$1_0.VIN VDD.t529 VDD.t0 sg13_lv_pmos ad=55.5f pd=0.74u as=0.1005p ps=1.34u w=0.15u l=0.13u
X2214 PH180.t7 6to4_0.buff_PI_d32_3.inv_PI_d32_0.VIN VSS.t1021 VSS.t1020 sg13_lv_nmos ad=55.5f pd=0.74u as=0.1005p ps=1.34u w=0.15u l=0.13u
X2215 VDD.t1059 6to4_0.buff_PI_d32_2.buff_PI_d16$1_0.inv_PI_d4$1_0.VOUT.t18 6to4_0.buff_PI_d32_2.buff_PI_d16$1_0.inv_PI_d8$1_0.VOUT.t12 VDD.t198 sg13_lv_pmos ad=0.1005p pd=1.34u as=55.5f ps=0.74u w=0.15u l=0.13u
X2216 CTRL 6ph_rosc_0.PH5.t12 CTRL VDD.t85 sg13_lv_pmos ad=0.19p pd=1.38u as=0 ps=0 w=1u l=0.13u
X2217 VDD.t965 6to4_0.buff_PI_d32_0.inv_PI_d16$1_0.VIN.t63 6to4_0.buff_PI_d32_0.inv_PI_d32_0.VIN VDD.t341 sg13_lv_pmos ad=55.5f pd=0.74u as=55.5f ps=0.74u w=0.15u l=0.13u
X2218 VDD.t1348 VSS.t1966 6ph_rosc_0.psdiff_2.buff_d8$1_1.VIN.t17 VDD.t470 sg13_lv_pmos ad=55.5f pd=0.74u as=55.5f ps=0.74u w=0.15u l=0.13u
X2219 6ph_rosc_0.psdiff_2.VOUTDP 6ph_rosc_0.psdiff_2.buff_d8$1_0.inv_d8$1_0.VIN VSS.t193 VSS.t192 sg13_lv_nmos ad=55.5f pd=0.74u as=0.1005p ps=1.34u w=0.15u l=0.13u
X2220 VDD.t200 6to4_0.buff_PI_d32_2.inv_PI_d32_0.VIN.t48 PH270.t45 VDD.t198 sg13_lv_pmos ad=55.5f pd=0.74u as=0.1005p ps=1.34u w=0.15u l=0.13u
X2221 VDD.t324 6to4_0.inv_PI_d2$1_3.VOUT 6to4_0.inv_PI_d2$1_2.VOUT VDD.t99 sg13_lv_pmos ad=55.5f pd=0.74u as=55.5f ps=0.74u w=0.15u l=0.13u
X2222 6ph_rosc_0.PH3.t2 6ph_rosc_0.buff_d8$1_4.inv_d8$1_0.VIN VSS.t745 VSS.t744 sg13_lv_nmos ad=55.5f pd=0.74u as=0.1005p ps=1.34u w=0.15u l=0.13u
X2223 VDD.t357 6to4_0.buff_PI_d32_0.inv_PI_d32_0.VIN PH90.t45 VDD.t347 sg13_lv_pmos ad=55.5f pd=0.74u as=55.5f ps=0.74u w=0.15u l=0.13u
X2224 VDD.t483 6ph_rosc_0.buff_d8$1_4.inv_d8$1_0.VIN 6ph_rosc_0.PH3.t8 VDD.t75 sg13_lv_pmos ad=0.1005p pd=1.34u as=55.5f ps=0.74u w=0.15u l=0.13u
X2225 PH90.t44 6to4_0.buff_PI_d32_0.inv_PI_d32_0.VIN VDD.t356 VDD.t5 sg13_lv_pmos ad=55.5f pd=0.74u as=55.5f ps=0.74u w=0.15u l=0.13u
X2226 VDD.t807 6to4_0.buff_PI_d32_2.buff_PI_d16$1_0.inv_PI_d8$1_0.VOUT.t34 6to4_0.buff_PI_d32_2.inv_PI_d16$1_0.VIN.t23 VDD.t198 sg13_lv_pmos ad=55.5f pd=0.74u as=0.1005p ps=1.34u w=0.15u l=0.13u
X2227 PH0.t47 6to4_0.buff_PI_d32_1.inv_PI_d32_0.VIN VDD.t564 VDD.t17 sg13_lv_pmos ad=55.5f pd=0.74u as=0.1005p ps=1.34u w=0.15u l=0.13u
X2228 PH90.t10 6to4_0.buff_PI_d32_0.inv_PI_d32_0.VIN VSS.t546 VSS.t545 sg13_lv_nmos ad=55.5f pd=0.74u as=0.1005p ps=1.34u w=0.15u l=0.13u
X2229 VDD.t180 6to4_0.buff_PI_d32_1.buff_PI_d16$1_0.inv_PI_d4$1_0.VOUT.t14 6to4_0.buff_PI_d32_1.buff_PI_d16$1_0.inv_PI_d8$1_0.VOUT.t6 VDD.t173 sg13_lv_pmos ad=55.5f pd=0.74u as=55.5f ps=0.74u w=0.15u l=0.13u
X2230 VSS.t1873 6to4_0.buff_PI_d32_1.inv_PI_d16$1_0.VIN 6to4_0.buff_PI_d32_1.inv_PI_d32_0.VIN VSS.t1872 sg13_lv_nmos ad=0.1005p pd=1.34u as=55.5f ps=0.74u w=0.15u l=0.13u
X2231 6ph_rosc_0.psdiff_2.buff_d8$1_1.VIN.t2 6ph_rosc_0.psdiff_2.CLKP.t8 VSS.t1688 VSS.t1687 sg13_lv_nmos ad=55.5f pd=0.74u as=55.5f ps=0.74u w=0.15u l=0.13u
X2232 VSS.t1937 6ph_rosc_0.psdiff_1.VOUTDN 6ph_rosc_0.psdiff_0.buff_d8$1_1.VIN.t22 VSS.t1936 sg13_lv_nmos ad=55.5f pd=0.74u as=55.5f ps=0.74u w=0.15u l=0.13u
X2233 VSS.t1871 6to4_0.buff_PI_d32_1.inv_PI_d16$1_0.VIN 6to4_0.buff_PI_d32_1.inv_PI_d32_0.VIN VSS.t1870 sg13_lv_nmos ad=0.1005p pd=1.34u as=55.5f ps=0.74u w=0.15u l=0.13u
X2234 6to4_0.buff_PI_d32_3.inv_PI_d32_0.VIN 6to4_0.buff_PI_d32_3.inv_PI_d16$1_0.VIN.t55 VDD.t884 VDD.t99 sg13_lv_pmos ad=55.5f pd=0.74u as=0.1005p ps=1.34u w=0.15u l=0.13u
X2235 PH270.t9 6to4_0.buff_PI_d32_2.inv_PI_d32_0.VIN.t65 VSS.t400 VSS.t399 sg13_lv_nmos ad=55.5f pd=0.74u as=0.1005p ps=1.34u w=0.15u l=0.13u
X2236 VDD.t170 6ph_rosc_0.psdiff_0.buff_d8$1_1.inv_d2$1_0.VIN 6ph_rosc_0.psdiff_0.buff_d8$1_1.inv_d4$1_0.VIN VDD.t0 sg13_lv_pmos ad=0.1005p pd=1.34u as=55.5f ps=0.74u w=0.15u l=0.13u
X2237 VDD.t1004 6to4_0.buff_PI_d32_2.inv_PI_d16$1_0.VIN.t60 6to4_0.buff_PI_d32_2.inv_PI_d32_0.VIN.t37 VDD.t126 sg13_lv_pmos ad=55.5f pd=0.74u as=55.5f ps=0.74u w=0.15u l=0.13u
X2238 6ph_rosc_0.psdiff_0.buff_d8$1_0.inv_d4$1_0.VIN 6ph_rosc_0.psdiff_0.buff_d8$1_0.inv_d2$1_0.VIN VSS.t49 VSS.t48 sg13_lv_nmos ad=55.5f pd=0.74u as=0.1005p ps=1.34u w=0.15u l=0.13u
X2239 VDD.t1389 VSS.t1967 6ph_rosc_0.psdiff_1.buff_d8$1_1.VIN.t2 VDD.t301 sg13_lv_pmos ad=0.1005p pd=1.34u as=55.5f ps=0.74u w=0.15u l=0.13u
X2240 VDD.t1136 6ph_rosc_0.PH5.t13 6ph_rosc_0.PH2.t9 VDD.t1135 sg13_lv_pmos ad=0.1005p pd=1.34u as=55.5f ps=0.74u w=0.15u l=0.13u
X2241 6to4_0.buff_PI_d32_3.buff_PI_d16$1_0.inv_PI_d8$1_0.VOUT.t1 6to4_0.buff_PI_d32_3.buff_PI_d16$1_0.inv_PI_d4$1_0.VOUT.t16 VSS.t1502 VSS.t1501 sg13_lv_nmos ad=55.5f pd=0.74u as=0.1005p ps=1.34u w=0.15u l=0.13u
X2242 VDD.t1148 6ph_rosc_0.psdiff_2.CLKP.t9 6ph_rosc_0.buff_d8$1_0.inv_d2$1_0.VIN VDD.t87 sg13_lv_pmos ad=0.1005p pd=1.34u as=0.1005p ps=1.34u w=0.15u l=0.13u
X2243 VSS.t1825 6to4_0.buff_PI_d32_3.buff_PI_d16$1_0.inv_PI_d8$1_0.VOUT.t33 6to4_0.buff_PI_d32_3.inv_PI_d16$1_0.VIN.t27 VSS.t1824 sg13_lv_nmos ad=0.1005p pd=1.34u as=55.5f ps=0.74u w=0.15u l=0.13u
X2244 6to4_0.flywheel_clk_1.PH0 6to4_0.inv_PI_d2$1_1.VIN VSS.t763 VSS.t762 sg13_lv_nmos ad=55.5f pd=0.74u as=0.1005p ps=1.34u w=0.15u l=0.13u
X2245 6ph_rosc_0.PH5.t9 6ph_rosc_0.PH2.t14 VDD.t1146 VDD.t1135 sg13_lv_pmos ad=55.5f pd=0.74u as=0.1005p ps=1.34u w=0.15u l=0.13u
X2246 VDD.t690 6to4_0.buff_PI_d32_3.inv_PI_d32_0.VIN PH180.t46 VDD.t99 sg13_lv_pmos ad=55.5f pd=0.74u as=0.1005p ps=1.34u w=0.15u l=0.13u
X2247 VSS.t544 6to4_0.buff_PI_d32_0.inv_PI_d32_0.VIN PH90.t9 VSS.t543 sg13_lv_nmos ad=0.1005p pd=1.34u as=55.5f ps=0.74u w=0.15u l=0.13u
X2248 6to4_0.buff_PI_d32_3.inv_PI_d16$1_0.VIN.t17 6to4_0.buff_PI_d32_3.buff_PI_d16$1_0.inv_PI_d8$1_0.VOUT.t29 VDD.t1214 VDD.t679 sg13_lv_pmos ad=55.5f pd=0.74u as=0.1005p ps=1.34u w=0.15u l=0.13u
X2249 VDD.t852 6to4_0.buff_PI_d32_0.buff_PI_d16$1_0.inv_PI_d4$1_0.VOUT.t18 6to4_0.buff_PI_d32_0.buff_PI_d16$1_0.inv_PI_d8$1_0.VOUT.t19 VDD.t341 sg13_lv_pmos ad=55.5f pd=0.74u as=0.1005p ps=1.34u w=0.15u l=0.13u
X2250 VDD.t1210 6to4_0.buff_PI_d32_3.buff_PI_d16$1_0.inv_PI_d8$1_0.VOUT.t28 6to4_0.buff_PI_d32_3.inv_PI_d16$1_0.VIN.t13 VDD.t679 sg13_lv_pmos ad=55.5f pd=0.74u as=0.1005p ps=1.34u w=0.15u l=0.13u
X2251 VDD.t1262 6to4_0.buff_PI_d32_1.inv_PI_d16$1_0.VIN 6to4_0.buff_PI_d32_1.inv_PI_d32_0.VIN VDD.t17 sg13_lv_pmos ad=0.1005p pd=1.34u as=55.5f ps=0.74u w=0.15u l=0.13u
X2252 VSS.t1638 6to4_0.buff_PI_d32_0.buff_PI_d16$1_0.inv_PI_d8$1_0.VOUT.t35 6to4_0.buff_PI_d32_0.inv_PI_d16$1_0.VIN.t33 VSS.t1637 sg13_lv_nmos ad=0.1005p pd=1.34u as=55.5f ps=0.74u w=0.15u l=0.13u
X2253 VDD.t1388 VSS.t1967 6ph_rosc_0.psdiff_1.buff_d8$1_0.VIN.t18 VDD.t301 sg13_lv_pmos ad=55.5f pd=0.74u as=55.5f ps=0.74u w=0.15u l=0.13u
X2254 6ph_rosc_0.buff_d8$1_1.inv_d8$1_0.VIN 6ph_rosc_0.buff_d8$1_1.inv_d4$1_0.VIN VDD.t313 VDD.t75 sg13_lv_pmos ad=55.5f pd=0.74u as=0.1005p ps=1.34u w=0.15u l=0.13u
X2255 VSS.t368 6to4_0.buff_PI_d32_2.inv_PI_d32_0.VIN.t57 PH270.t8 VSS.t367 sg13_lv_nmos ad=0.1005p pd=1.34u as=55.5f ps=0.74u w=0.15u l=0.13u
X2256 CTRL 6ph_rosc_0.PH5.t12 CTRL VDD.t89 sg13_lv_pmos ad=0.19p pd=1.38u as=0 ps=0 w=1u l=0.13u
X2257 VDD.t355 6to4_0.buff_PI_d32_0.inv_PI_d32_0.VIN PH90.t43 VDD.t5 sg13_lv_pmos ad=55.5f pd=0.74u as=55.5f ps=0.74u w=0.15u l=0.13u
X2258 6to4_0.buff_PI_d32_0.buff_PI_d16$1_0.inv_PI_d8$1_0.VOUT.t16 6to4_0.buff_PI_d32_0.buff_PI_d16$1_0.inv_PI_d4$1_0.VOUT.t17 VDD.t849 VDD.t341 sg13_lv_pmos ad=0.1005p pd=1.34u as=55.5f ps=0.74u w=0.15u l=0.13u
X2259 6to4_0.buff_PI_d32_0.buff_PI_d16$1_0.inv_PI_d8$1_0.VOUT.t6 6to4_0.buff_PI_d32_0.buff_PI_d16$1_0.inv_PI_d4$1_0.VOUT.t14 VSS.t1264 VSS.t1263 sg13_lv_nmos ad=55.5f pd=0.74u as=0.1005p ps=1.34u w=0.15u l=0.13u
X2260 PH270.t7 6to4_0.buff_PI_d32_2.inv_PI_d32_0.VIN.t60 VSS.t380 VSS.t379 sg13_lv_nmos ad=55.5f pd=0.74u as=0.1005p ps=1.34u w=0.15u l=0.13u
X2261 6to4_0.buff_PI_d32_1.buff_PI_d16$1_0.inv_PI_d8$1_0.VOUT.t18 6to4_0.buff_PI_d32_1.buff_PI_d16$1_0.inv_PI_d4$1_0.VOUT.t18 VDD.t192 VDD.t173 sg13_lv_pmos ad=55.5f pd=0.74u as=55.5f ps=0.74u w=0.15u l=0.13u
X2262 VDD.t354 6to4_0.buff_PI_d32_0.inv_PI_d32_0.VIN PH90.t42 VDD.t347 sg13_lv_pmos ad=55.5f pd=0.74u as=0.1005p ps=1.34u w=0.15u l=0.13u
X2263 6ph_rosc_0.PH3.t7 6ph_rosc_0.buff_d8$1_4.inv_d8$1_0.VIN VDD.t482 VDD.t75 sg13_lv_pmos ad=55.5f pd=0.74u as=0.1005p ps=1.34u w=0.15u l=0.13u
X2264 PH180.t45 6to4_0.buff_PI_d32_3.inv_PI_d32_0.VIN VDD.t689 VDD.t99 sg13_lv_pmos ad=55.5f pd=0.74u as=0.1005p ps=1.34u w=0.15u l=0.13u
X2265 PH90.t8 6to4_0.buff_PI_d32_0.inv_PI_d32_0.VIN VSS.t542 VSS.t541 sg13_lv_nmos ad=55.5f pd=0.74u as=0.1005p ps=1.34u w=0.15u l=0.13u
X2266 CTRL 6ph_rosc_0.PH3.t11 CTRL VDD.t57 sg13_lv_pmos ad=0.19p pd=1.38u as=0 ps=0 w=1u l=0.13u
X2267 6to4_0.buff_PI_d32_0.inv_PI_d16$1_0.VIN.t46 6to4_0.buff_PI_d32_0.buff_PI_d16$1_0.inv_PI_d8$1_0.VOUT.t39 VDD.t1125 VDD.t5 sg13_lv_pmos ad=55.5f pd=0.74u as=0.1005p ps=1.34u w=0.15u l=0.13u
X2268 VDD.t304 a_7973_2194# 6ph_rosc_0.psdiff_1.buff_d8$1_0.VIN.t27 VDD.t301 sg13_lv_pmos ad=55.5f pd=0.74u as=55.5f ps=0.74u w=0.15u l=0.13u
X2269 VSS.t1737 6to4_0.buff_PI_d32_1.buff_PI_d16$1_0.inv_PI_d8$1_0.VOUT.t27 6to4_0.buff_PI_d32_1.inv_PI_d16$1_0.VIN VSS.t1736 sg13_lv_nmos ad=0.1005p pd=1.34u as=55.5f ps=0.74u w=0.15u l=0.13u
X2270 6to4_0.buff_PI_d32_3.inv_PI_d16$1_0.VIN.t45 6to4_0.buff_PI_d32_3.buff_PI_d16$1_0.inv_PI_d8$1_0.VOUT.t39 VSS.t1849 VSS.t1848 sg13_lv_nmos ad=55.5f pd=0.74u as=0.1005p ps=1.34u w=0.15u l=0.13u
X2271 6to4_0.buff_PI_d32_3.buff_PI_d16$1_0.inv_PI_d4$1_0.VOUT.t7 6to4_0.buff_PI_d32_3.buff_PI_d16$1_0.inv_PI_d4$1_0.VIN VDD.t103 VDD.t99 sg13_lv_pmos ad=55.5f pd=0.74u as=0.1005p ps=1.34u w=0.15u l=0.13u
X2272 VSS.t761 6to4_0.inv_PI_d2$1_1.VIN 6to4_0.flywheel_clk_1.PH0 VSS.t760 sg13_lv_nmos ad=0.1005p pd=1.34u as=55.5f ps=0.74u w=0.15u l=0.13u
X2273 VDD.t538 a_9130_2338# 6ph_rosc_0.psdiff_1.buff_d8$1_1.VIN.t14 VDD.t301 sg13_lv_pmos ad=55.5f pd=0.74u as=55.5f ps=0.74u w=0.15u l=0.13u
X2274 VSS.t869 6to4_0.buff_PI_d32_1.inv_PI_d32_0.VIN PH0.t11 VSS.t868 sg13_lv_nmos ad=0.1005p pd=1.34u as=55.5f ps=0.74u w=0.15u l=0.13u
X2275 CTRL 6ph_rosc_0.PH5.t12 CTRL VDD.t87 sg13_lv_pmos ad=0.19p pd=1.38u as=0 ps=0 w=1u l=0.13u
X2276 6to4_0.buff_PI_d32_1.inv_PI_d32_0.VIN 6to4_0.buff_PI_d32_1.inv_PI_d16$1_0.VIN VDD.t1261 VDD.t17 sg13_lv_pmos ad=0.1005p pd=1.34u as=55.5f ps=0.74u w=0.15u l=0.13u
X2277 VDD.t1309 VSS.t1965 6ph_rosc_0.psdiff_0.buff_d8$1_1.VIN.t3 VDD.t503 sg13_lv_pmos ad=55.5f pd=0.74u as=55.5f ps=0.74u w=0.15u l=0.13u
X2278 VDD.t806 6to4_0.buff_PI_d32_2.buff_PI_d16$1_0.inv_PI_d8$1_0.VOUT.t34 6to4_0.buff_PI_d32_2.inv_PI_d16$1_0.VIN.t22 VDD.t198 sg13_lv_pmos ad=0.1005p pd=1.34u as=55.5f ps=0.74u w=0.15u l=0.13u
X2279 VSS.t43 6ph_rosc_0.psdiff_2.buff_d8$1_1.inv_d4$1_0.VIN 6ph_rosc_0.psdiff_2.buff_d8$1_1.inv_d8$1_0.VIN VSS.t42 sg13_lv_nmos ad=0.1005p pd=1.34u as=55.5f ps=0.74u w=0.15u l=0.13u
X2280 VSS.t1143 6ph_rosc_0.psdiff_2.VOUTDN 6ph_rosc_0.buff_d8$1_5.inv_d2$1_0.VIN VSS.t1142 sg13_lv_nmos ad=0.1005p pd=1.34u as=0.1005p ps=1.34u w=0.15u l=0.13u
X2281 6ph_rosc_0.PH3.t0 6ph_rosc_0.PH0.t13 VSS.t1248 VSS.t1247 sg13_lv_nmos ad=55.5f pd=0.74u as=0.1005p ps=1.34u w=0.15u l=0.13u
X2282 VSS.t1234 6to4_0.buff_PI_d32_2.buff_PI_d16$1_0.inv_PI_d8$1_0.VOUT.t38 6to4_0.buff_PI_d32_2.inv_PI_d16$1_0.VIN.t6 VSS.t1233 sg13_lv_nmos ad=0.1005p pd=1.34u as=55.5f ps=0.74u w=0.15u l=0.13u
X2283 VDD.t18 6to4_0.buff_PI_d32_1.buff_PI_d16$1_0.inv_PI_d4$1_0.VIN 6to4_0.buff_PI_d32_1.buff_PI_d16$1_0.inv_PI_d4$1_0.VOUT.t4 VDD.t17 sg13_lv_pmos ad=55.5f pd=0.74u as=55.5f ps=0.74u w=0.15u l=0.13u
X2284 6ph_rosc_0.psdiff_1.buff_d8$1_1.VIN.t21 6ph_rosc_0.psdiff_2.VOUTDN VSS.t1141 VSS.t1140 sg13_lv_nmos ad=55.5f pd=0.74u as=55.5f ps=0.74u w=0.15u l=0.13u
X2285 PH90.t41 6to4_0.buff_PI_d32_0.inv_PI_d32_0.VIN VDD.t353 VDD.t341 sg13_lv_pmos ad=55.5f pd=0.74u as=0.1005p ps=1.34u w=0.15u l=0.13u
X2286 PH180.t44 6to4_0.buff_PI_d32_3.inv_PI_d32_0.VIN VDD.t688 VDD.t673 sg13_lv_pmos ad=55.5f pd=0.74u as=0.1005p ps=1.34u w=0.15u l=0.13u
X2287 VDD.t199 6to4_0.buff_PI_d32_2.inv_PI_d32_0.VIN.t48 PH270.t44 VDD.t198 sg13_lv_pmos ad=0.1005p pd=1.34u as=55.5f ps=0.74u w=0.15u l=0.13u
X2288 CTRL 6ph_rosc_0.PH5.t12 CTRL VDD.t85 sg13_lv_pmos ad=0.19p pd=1.38u as=0 ps=0 w=1u l=0.13u
X2289 PH270.t6 6to4_0.buff_PI_d32_2.inv_PI_d32_0.VIN.t77 VSS.t448 VSS.t447 sg13_lv_nmos ad=55.5f pd=0.74u as=0.1005p ps=1.34u w=0.15u l=0.13u
X2290 CTRL 6ph_rosc_0.PH4.t10 CTRL VDD.t451 sg13_lv_pmos ad=0.19p pd=1.38u as=0 ps=0 w=1u l=0.13u
X2291 VDD.t1308 VSS.t1965 6ph_rosc_0.psdiff_0.buff_d8$1_1.VIN.t2 VDD.t503 sg13_lv_pmos ad=55.5f pd=0.74u as=55.5f ps=0.74u w=0.15u l=0.13u
X2292 VDD.t528 6ph_rosc_0.psdiff_2.buff_d8$1_1.inv_d8$1_0.VIN 6ph_rosc_0.psdiff_2.VOUTDN VDD.t0 sg13_lv_pmos ad=0.1005p pd=1.34u as=55.5f ps=0.74u w=0.15u l=0.13u
X2293 VDD.t283 6to4_0.buff_PI_d32_2.inv_PI_d32_0.VIN.t75 PH270.t43 VDD.t215 sg13_lv_pmos ad=55.5f pd=0.74u as=0.1005p ps=1.34u w=0.15u l=0.13u
X2294 VDD.t102 6to4_0.buff_PI_d32_3.buff_PI_d16$1_0.inv_PI_d4$1_0.VIN 6to4_0.buff_PI_d32_3.buff_PI_d16$1_0.inv_PI_d4$1_0.VOUT.t6 VDD.t99 sg13_lv_pmos ad=55.5f pd=0.74u as=0.1005p ps=1.34u w=0.15u l=0.13u
X2295 VDD.t944 6to4_0.buff_PI_d32_0.inv_PI_d16$1_0.VIN.t56 6to4_0.buff_PI_d32_0.inv_PI_d32_0.VIN VDD.t5 sg13_lv_pmos ad=55.5f pd=0.74u as=0.1005p ps=1.34u w=0.15u l=0.13u
X2296 a_4999_2194# CTRL 6ph_rosc_0.psdiff_2.buff_d8$1_1.VIN.t25 VSS.t492 sg13_lv_nmos ad=55.5f pd=0.74u as=0.1005p ps=1.34u w=0.15u l=0.13u
X2297 6to4_0.buff_PI_d32_2.inv_PI_d16$1_0.VIN.t21 6to4_0.buff_PI_d32_2.buff_PI_d16$1_0.inv_PI_d8$1_0.VOUT.t36 VDD.t813 VDD.t126 sg13_lv_pmos ad=0.1005p pd=1.34u as=55.5f ps=0.74u w=0.15u l=0.13u
X2298 6to4_0.buff_PI_d32_1.buff_PI_d16$1_0.inv_PI_d8$1_0.VOUT.t9 6to4_0.buff_PI_d32_1.buff_PI_d16$1_0.inv_PI_d4$1_0.VOUT.t15 VDD.t184 VDD.t173 sg13_lv_pmos ad=55.5f pd=0.74u as=0.1005p ps=1.34u w=0.15u l=0.13u
X2299 6to4_0.buff_PI_d32_1.buff_PI_d16$1_0.inv_PI_d8$1_0.VOUT.t14 6to4_0.buff_PI_d32_1.buff_PI_d16$1_0.inv_PI_d4$1_0.VOUT.t16 VSS.t316 VSS.t315 sg13_lv_nmos ad=55.5f pd=0.74u as=0.1005p ps=1.34u w=0.15u l=0.13u
X2300 6ph_rosc_0.psdiff_1.buff_d8$1_1.VIN.t20 6ph_rosc_0.psdiff_2.VOUTDN VSS.t1139 VSS.t500 sg13_lv_nmos ad=55.5f pd=0.74u as=55.5f ps=0.74u w=0.15u l=0.13u
X2301 VSS.t266 6ph_rosc_0.psdiff_1.buff_d8$1_1.inv_d8$1_0.VIN 6ph_rosc_0.psdiff_1.VOUTDN VSS.t265 sg13_lv_nmos ad=0.1005p pd=1.34u as=55.5f ps=0.74u w=0.15u l=0.13u
X2302 VSS.t540 6to4_0.buff_PI_d32_0.inv_PI_d32_0.VIN PH90.t7 VSS.t539 sg13_lv_nmos ad=0.1005p pd=1.34u as=55.5f ps=0.74u w=0.15u l=0.13u
X2303 PH0.t10 6to4_0.buff_PI_d32_1.inv_PI_d32_0.VIN VSS.t867 VSS.t866 sg13_lv_nmos ad=55.5f pd=0.74u as=0.1005p ps=1.34u w=0.15u l=0.13u
X2304 VDD.t950 6to4_0.buff_PI_d32_0.inv_PI_d16$1_0.VIN.t58 6to4_0.buff_PI_d32_0.inv_PI_d32_0.VIN VDD.t341 sg13_lv_pmos ad=0.1005p pd=1.34u as=55.5f ps=0.74u w=0.15u l=0.13u
X2305 VDD.t1260 6to4_0.buff_PI_d32_1.inv_PI_d16$1_0.VIN 6to4_0.buff_PI_d32_1.inv_PI_d32_0.VIN VDD.t173 sg13_lv_pmos ad=55.5f pd=0.74u as=55.5f ps=0.74u w=0.15u l=0.13u
X2306 VDD.t1 6ph_rosc_0.psdiff_1.buff_d8$1_1.inv_d4$1_0.VIN 6ph_rosc_0.psdiff_1.buff_d8$1_1.inv_d8$1_0.VIN VDD.t0 sg13_lv_pmos ad=0.1005p pd=1.34u as=55.5f ps=0.74u w=0.15u l=0.13u
X2307 6ph_rosc_0.PH2.t0 6ph_rosc_0.buff_d8$1_0.inv_d8$1_0.VIN VSS.t654 VSS.t653 sg13_lv_nmos ad=55.5f pd=0.74u as=0.1005p ps=1.34u w=0.15u l=0.13u
X2308 CTRL 6ph_rosc_0.PH0.t10 CTRL VDD.t51 sg13_lv_pmos ad=0.19p pd=1.38u as=0 ps=0 w=1u l=0.13u
X2309 6ph_rosc_0.psdiff_0.buff_d8$1_0.VIN.t12 a_10947_2194# VDD.t516 VDD.t503 sg13_lv_pmos ad=55.5f pd=0.74u as=55.5f ps=0.74u w=0.15u l=0.13u
X2310 6ph_rosc_0.psdiff_0.buff_d8$1_0.VIN.t21 6ph_rosc_0.psdiff_1.VOUTDP VSS.t816 VSS.t815 sg13_lv_nmos ad=55.5f pd=0.74u as=55.5f ps=0.74u w=0.15u l=0.13u
X2311 6ph_rosc_0.psdiff_1.buff_d8$1_1.inv_d2$1_0.VIN 6ph_rosc_0.psdiff_1.buff_d8$1_1.VIN.t32 VDD.t1149 VDD.t0 sg13_lv_pmos ad=0.1005p pd=1.34u as=0.1005p ps=1.34u w=0.15u l=0.13u
X2312 VSS.t865 6to4_0.buff_PI_d32_1.inv_PI_d32_0.VIN PH0.t9 VSS.t864 sg13_lv_nmos ad=0.1005p pd=1.34u as=55.5f ps=0.74u w=0.15u l=0.13u
X2313 6to4_0.buff_PI_d32_2.inv_PI_d16$1_0.VIN.t20 6to4_0.buff_PI_d32_2.buff_PI_d16$1_0.inv_PI_d8$1_0.VOUT.t33 VDD.t803 VDD.t198 sg13_lv_pmos ad=0.1005p pd=1.34u as=55.5f ps=0.74u w=0.15u l=0.13u
X2314 VSS.t298 6ph_rosc_0.psdiff_2.buff_d8$1_0.VIN.t32 6ph_rosc_0.psdiff_2.buff_d8$1_0.inv_d2$1_0.VIN VSS.t297 sg13_lv_nmos ad=0.1005p pd=1.34u as=0.1005p ps=1.34u w=0.15u l=0.13u
X2315 CTRL 6ph_rosc_0.PH5.t12 CTRL VDD.t89 sg13_lv_pmos ad=0.19p pd=1.38u as=0 ps=0 w=1u l=0.13u
X2316 VSS.t1935 6ph_rosc_0.psdiff_1.VOUTDN 6ph_rosc_0.psdiff_0.buff_d8$1_1.VIN.t21 VSS.t1932 sg13_lv_nmos ad=55.5f pd=0.74u as=55.5f ps=0.74u w=0.15u l=0.13u
X2317 6to4_0.buff_PI_d32_1.inv_PI_d32_0.VIN 6to4_0.buff_PI_d32_1.inv_PI_d16$1_0.VIN VSS.t1869 VSS.t1868 sg13_lv_nmos ad=55.5f pd=0.74u as=0.1005p ps=1.34u w=0.15u l=0.13u
X2318 VSS.t1426 6to4_0.buff_PI_d32_0.inv_PI_d16$1_0.VIN.t61 6to4_0.buff_PI_d32_0.inv_PI_d32_0.VIN VSS.t1425 sg13_lv_nmos ad=0.1005p pd=1.34u as=55.5f ps=0.74u w=0.15u l=0.13u
X2319 6ph_rosc_0.psdiff_0.buff_d8$1_0.VIN.t20 6ph_rosc_0.psdiff_1.VOUTDP VSS.t814 VSS.t499 sg13_lv_nmos ad=55.5f pd=0.74u as=55.5f ps=0.74u w=0.15u l=0.13u
X2320 VSS.t286 6ph_rosc_0.buff_d8$1_3.inv_d4$1_0.VIN 6ph_rosc_0.buff_d8$1_3.inv_d8$1_0.VIN VSS.t285 sg13_lv_nmos ad=0.1005p pd=1.34u as=55.5f ps=0.74u w=0.15u l=0.13u
X2321 CTRL 6ph_rosc_0.PH0.t10 CTRL VDD.t51 sg13_lv_pmos ad=0.34p pd=2.68u as=0 ps=0 w=1u l=0.13u
X2322 6to4_0.buff_PI_d32_2.inv_PI_d32_0.VIN.t46 6to4_0.buff_PI_d32_2.inv_PI_d16$1_0.VIN.t63 VDD.t1013 VDD.t126 sg13_lv_pmos ad=55.5f pd=0.74u as=0.1005p ps=1.34u w=0.15u l=0.13u
X2323 6ph_rosc_0.psdiff_2.buff_d8$1_0.inv_d8$1_0.VIN 6ph_rosc_0.psdiff_2.buff_d8$1_0.inv_d4$1_0.VIN VSS.t153 VSS.t152 sg13_lv_nmos ad=55.5f pd=0.74u as=0.1005p ps=1.34u w=0.15u l=0.13u
X2324 6ph_rosc_0.psdiff_0.buff_d8$1_1.inv_d2$1_0.VIN 6ph_rosc_0.psdiff_0.buff_d8$1_1.VIN.t32 VSS.t1176 VSS.t1175 sg13_lv_nmos ad=0.1005p pd=1.34u as=0.1005p ps=1.34u w=0.15u l=0.13u
X2325 6ph_rosc_0.PH0.t9 6ph_rosc_0.PH3.t14 VDD.t1253 VDD.t824 sg13_lv_pmos ad=55.5f pd=0.74u as=0.1005p ps=1.34u w=0.15u l=0.13u
X2326 6to4_0.buff_PI_d32_2.buff_PI_d16$1_0.inv_PI_d4$1_0.VIN 6to4_0.buff_PI_d32_2.VIN VSS.t993 VSS.t992 sg13_lv_nmos ad=55.5f pd=0.74u as=0.1005p ps=1.34u w=0.15u l=0.13u
X2327 6ph_rosc_0.buff_d8$1_0.inv_d8$1_0.VIN 6ph_rosc_0.buff_d8$1_0.inv_d4$1_0.VIN VSS.t121 VSS.t120 sg13_lv_nmos ad=55.5f pd=0.74u as=0.1005p ps=1.34u w=0.15u l=0.13u
X2328 CTRL 6ph_rosc_0.PH4.t10 CTRL VDD.t451 sg13_lv_pmos ad=0.19p pd=1.38u as=0 ps=0 w=1u l=0.13u
X2329 6to4_0.PI_clk_0.inv_PI_d2$1_0.VOUT 6ph_rosc_0.PH1.t12 VSS.t1366 VSS.t1365 sg13_lv_nmos ad=55.5f pd=0.74u as=0.1005p ps=1.34u w=0.15u l=0.13u
X2330 VDD.t687 6to4_0.buff_PI_d32_3.inv_PI_d32_0.VIN PH180.t43 VDD.t677 sg13_lv_pmos ad=55.5f pd=0.74u as=55.5f ps=0.74u w=0.15u l=0.13u
X2331 VDD.t93 6to4_0.PI_clk_1.inv_PI_d2$1_0.VOUT 6to4_0.buff_PI_d32_2.VIN VDD.t92 sg13_lv_pmos ad=55.5f pd=0.74u as=0.1005p ps=1.34u w=0.15u l=0.13u
X2332 VSS.t1138 6ph_rosc_0.psdiff_2.VOUTDN 6ph_rosc_0.psdiff_1.buff_d8$1_1.VIN.t19 VSS.t1137 sg13_lv_nmos ad=55.5f pd=0.74u as=55.5f ps=0.74u w=0.15u l=0.13u
X2333 VSS.t1934 6ph_rosc_0.psdiff_1.VOUTDN 6ph_rosc_0.psdiff_0.buff_d8$1_1.VIN.t20 VSS.t1930 sg13_lv_nmos ad=55.5f pd=0.74u as=55.5f ps=0.74u w=0.15u l=0.13u
X2334 6ph_rosc_0.PH1.t1 6ph_rosc_0.buff_d8$1_3.inv_d8$1_0.VIN VSS.t252 VSS.t251 sg13_lv_nmos ad=55.5f pd=0.74u as=0.1005p ps=1.34u w=0.15u l=0.13u
X2335 VDD.t148 6ph_rosc_0.buff_d8$1_3.inv_d8$1_0.VIN 6ph_rosc_0.PH1.t4 VDD.t75 sg13_lv_pmos ad=0.1005p pd=1.34u as=55.5f ps=0.74u w=0.15u l=0.13u
X2336 6to4_0.buff_PI_d32_3.inv_PI_d32_0.VIN 6to4_0.buff_PI_d32_3.inv_PI_d16$1_0.VIN.t57 VSS.t1334 VSS.t1333 sg13_lv_nmos ad=55.5f pd=0.74u as=0.1005p ps=1.34u w=0.15u l=0.13u
X2337 6to4_0.buff_PI_d32_1.inv_PI_d32_0.VIN 6to4_0.buff_PI_d32_1.inv_PI_d16$1_0.VIN VDD.t1259 VDD.t17 sg13_lv_pmos ad=55.5f pd=0.74u as=55.5f ps=0.74u w=0.15u l=0.13u
X2338 6ph_rosc_0.psdiff_1.VOUTDP 6ph_rosc_0.psdiff_1.buff_d8$1_0.inv_d8$1_0.VIN VDD.t655 VDD.t34 sg13_lv_pmos ad=55.5f pd=0.74u as=0.1005p ps=1.34u w=0.15u l=0.13u
X2339 6ph_rosc_0.psdiff_2.CLKP.t5 6ph_rosc_0.psdiff_0.buff_d8$1_1.inv_d8$1_0.VIN VDD.t496 VDD.t0 sg13_lv_pmos ad=55.5f pd=0.74u as=0.1005p ps=1.34u w=0.15u l=0.13u
X2340 PH0.t46 6to4_0.buff_PI_d32_1.inv_PI_d32_0.VIN VDD.t563 VDD.t547 sg13_lv_pmos ad=55.5f pd=0.74u as=0.1005p ps=1.34u w=0.15u l=0.13u
X2341 VDD.t246 6to4_0.buff_PI_d32_2.inv_PI_d32_0.VIN.t63 PH270.t42 VDD.t202 sg13_lv_pmos ad=55.5f pd=0.74u as=0.1005p ps=1.34u w=0.15u l=0.13u
X2342 6ph_rosc_0.psdiff_1.buff_d8$1_1.VIN.t1 VSS.t1967 VDD.t1387 VDD.t301 sg13_lv_pmos ad=55.5f pd=0.74u as=55.5f ps=0.74u w=0.15u l=0.13u
X2343 PH180.t42 6to4_0.buff_PI_d32_3.inv_PI_d32_0.VIN VDD.t686 VDD.t673 sg13_lv_pmos ad=0.1005p pd=1.34u as=55.5f ps=0.74u w=0.15u l=0.13u
X2344 VSS.t863 6to4_0.buff_PI_d32_1.inv_PI_d32_0.VIN PH0.t8 VSS.t862 sg13_lv_nmos ad=0.1005p pd=1.34u as=55.5f ps=0.74u w=0.15u l=0.13u
X2345 6to4_0.buff_PI_d32_0.inv_PI_d16$1_0.VIN.t19 6to4_0.buff_PI_d32_0.buff_PI_d16$1_0.inv_PI_d8$1_0.VOUT.t30 VDD.t1098 VDD.t5 sg13_lv_pmos ad=55.5f pd=0.74u as=0.1005p ps=1.34u w=0.15u l=0.13u
X2346 VDD.t822 6to4_0.buff_PI_d32_2.buff_PI_d16$1_0.inv_PI_d8$1_0.VOUT.t39 6to4_0.buff_PI_d32_2.inv_PI_d16$1_0.VIN.t19 VDD.t126 sg13_lv_pmos ad=0.1005p pd=1.34u as=55.5f ps=0.74u w=0.15u l=0.13u
X2347 6to4_0.buff_PI_d32_0.inv_PI_d32_0.VIN 6to4_0.buff_PI_d32_0.inv_PI_d16$1_0.VIN.t59 VDD.t953 VDD.t341 sg13_lv_pmos ad=0.1005p pd=1.34u as=55.5f ps=0.74u w=0.15u l=0.13u
X2348 VDD.t685 6to4_0.buff_PI_d32_3.inv_PI_d32_0.VIN PH180.t41 VDD.t677 sg13_lv_pmos ad=55.5f pd=0.74u as=0.1005p ps=1.34u w=0.15u l=0.13u
X2349 6ph_rosc_0.psdiff_2.CLKN 6ph_rosc_0.psdiff_0.buff_d8$1_0.inv_d8$1_0.VIN VSS.t1578 VSS.t1577 sg13_lv_nmos ad=55.5f pd=0.74u as=0.1005p ps=1.34u w=0.15u l=0.13u
X2350 VDD.t1307 VSS.t1965 6ph_rosc_0.psdiff_0.buff_d8$1_0.VIN.t2 VDD.t503 sg13_lv_pmos ad=55.5f pd=0.74u as=55.5f ps=0.74u w=0.15u l=0.13u
X2351 VDD.t1219 6to4_0.buff_PI_d32_3.buff_PI_d16$1_0.inv_PI_d8$1_0.VOUT.t31 6to4_0.buff_PI_d32_3.inv_PI_d16$1_0.VIN.t22 VDD.t99 sg13_lv_pmos ad=0.1005p pd=1.34u as=55.5f ps=0.74u w=0.15u l=0.13u
X2352 6ph_rosc_0.psdiff_1.buff_d8$1_1.VIN.t0 VSS.t1967 VDD.t1386 VDD.t301 sg13_lv_pmos ad=55.5f pd=0.74u as=55.5f ps=0.74u w=0.15u l=0.13u
X2353 VDD.t1258 6to4_0.buff_PI_d32_1.inv_PI_d16$1_0.VIN 6to4_0.buff_PI_d32_1.inv_PI_d32_0.VIN VDD.t173 sg13_lv_pmos ad=55.5f pd=0.74u as=0.1005p ps=1.34u w=0.15u l=0.13u
X2354 CTRL 6ph_rosc_0.PH2.t10 CTRL VDD.t440 sg13_lv_pmos ad=0.19p pd=1.38u as=0 ps=0 w=1u l=0.13u
X2355 PH90.t40 6to4_0.buff_PI_d32_0.inv_PI_d32_0.VIN VDD.t352 VDD.t5 sg13_lv_pmos ad=55.5f pd=0.74u as=0.1005p ps=1.34u w=0.15u l=0.13u
X2356 VDD.t855 6to4_0.buff_PI_d32_0.buff_PI_d16$1_0.inv_PI_d4$1_0.VOUT.t19 6to4_0.buff_PI_d32_0.buff_PI_d16$1_0.inv_PI_d8$1_0.VOUT.t22 VDD.t341 sg13_lv_pmos ad=55.5f pd=0.74u as=55.5f ps=0.74u w=0.15u l=0.13u
X2357 6to4_0.buff_PI_d32_1.inv_PI_d16$1_0.VIN 6to4_0.buff_PI_d32_1.buff_PI_d16$1_0.inv_PI_d8$1_0.VOUT.t32 VSS.t1735 VSS.t1734 sg13_lv_nmos ad=55.5f pd=0.74u as=0.1005p ps=1.34u w=0.15u l=0.13u
X2358 6ph_rosc_0.psdiff_1.buff_d8$1_0.inv_d8$1_0.VIN 6ph_rosc_0.psdiff_1.buff_d8$1_0.inv_d4$1_0.VIN VDD.t71 VDD.t34 sg13_lv_pmos ad=55.5f pd=0.74u as=0.1005p ps=1.34u w=0.15u l=0.13u
X2359 VDD.t8 6to4_0.flywheel_clk_0.PH0 6to4_0.buff_PI_d32_0.buff_PI_d16$1_0.inv_PI_d4$1_0.VIN VDD.t5 sg13_lv_pmos ad=0.1005p pd=1.34u as=55.5f ps=0.74u w=0.15u l=0.13u
X2360 VDD.t195 6to4_0.buff_PI_d32_1.buff_PI_d16$1_0.inv_PI_d4$1_0.VOUT.t19 6to4_0.buff_PI_d32_1.buff_PI_d16$1_0.inv_PI_d8$1_0.VOUT.t22 VDD.t173 sg13_lv_pmos ad=55.5f pd=0.74u as=0.1005p ps=1.34u w=0.15u l=0.13u
X2361 VSS.t1454 6to4_0.buff_PI_d32_2.inv_PI_d16$1_0.VIN.t52 6to4_0.buff_PI_d32_2.inv_PI_d32_0.VIN.t12 VSS.t1453 sg13_lv_nmos ad=0.1005p pd=1.34u as=55.5f ps=0.74u w=0.15u l=0.13u
X2362 VSS.t991 6to4_0.buff_PI_d32_2.VIN 6to4_0.buff_PI_d32_2.buff_PI_d16$1_0.inv_PI_d4$1_0.VIN VSS.t990 sg13_lv_nmos ad=0.1005p pd=1.34u as=55.5f ps=0.74u w=0.15u l=0.13u
X2363 VSS.t813 6ph_rosc_0.psdiff_1.VOUTDP 6ph_rosc_0.psdiff_0.buff_d8$1_0.VIN.t19 VSS.t812 sg13_lv_nmos ad=55.5f pd=0.74u as=55.5f ps=0.74u w=0.15u l=0.13u
X2364 VDD.t1306 VSS.t1965 6ph_rosc_0.psdiff_0.buff_d8$1_0.VIN.t1 VDD.t503 sg13_lv_pmos ad=55.5f pd=0.74u as=55.5f ps=0.74u w=0.15u l=0.13u
X2365 6to4_0.buff_PI_d32_1.inv_PI_d32_0.VIN 6to4_0.buff_PI_d32_1.inv_PI_d16$1_0.VIN VSS.t1867 VSS.t1866 sg13_lv_nmos ad=55.5f pd=0.74u as=0.1005p ps=1.34u w=0.15u l=0.13u
X2366 VSS.t1646 6to4_0.buff_PI_d32_0.buff_PI_d16$1_0.inv_PI_d8$1_0.VOUT.t37 6to4_0.buff_PI_d32_0.inv_PI_d16$1_0.VIN.t39 VSS.t1645 sg13_lv_nmos ad=0.1005p pd=1.34u as=55.5f ps=0.74u w=0.15u l=0.13u
X2367 CTRL 6ph_rosc_0.PH2.t10 CTRL VDD.t440 sg13_lv_pmos ad=0.19p pd=1.38u as=0 ps=0 w=1u l=0.13u
X2368 VSS.t1434 6to4_0.buff_PI_d32_0.inv_PI_d16$1_0.VIN.t63 6to4_0.buff_PI_d32_0.inv_PI_d32_0.VIN VSS.t1433 sg13_lv_nmos ad=0.1005p pd=1.34u as=55.5f ps=0.74u w=0.15u l=0.13u
X2369 VSS.t1362 6ph_rosc_0.PH1.t11 6to4_0.PI_clk_0.inv_PI_d2$1_0.VOUT VSS.t1361 sg13_lv_nmos ad=0.1005p pd=1.34u as=55.5f ps=0.74u w=0.15u l=0.13u
X2370 PH0.t7 6to4_0.buff_PI_d32_1.inv_PI_d32_0.VIN VSS.t861 VSS.t860 sg13_lv_nmos ad=55.5f pd=0.74u as=0.1005p ps=1.34u w=0.15u l=0.13u
X2371 6to4_0.buff_PI_d32_2.buff_PI_d16$1_0.inv_PI_d8$1_0.VOUT.t2 6to4_0.buff_PI_d32_2.buff_PI_d16$1_0.inv_PI_d4$1_0.VOUT.t16 VSS.t1550 VSS.t1549 sg13_lv_nmos ad=55.5f pd=0.74u as=0.1005p ps=1.34u w=0.15u l=0.13u
X2372 VDD.t684 6to4_0.buff_PI_d32_3.inv_PI_d32_0.VIN PH180.t40 VDD.t673 sg13_lv_pmos ad=0.1005p pd=1.34u as=55.5f ps=0.74u w=0.15u l=0.13u
X2373 6to4_0.buff_PI_d32_3.inv_PI_d32_0.VIN 6to4_0.buff_PI_d32_3.inv_PI_d16$1_0.VIN.t63 VDD.t908 VDD.t679 sg13_lv_pmos ad=55.5f pd=0.74u as=55.5f ps=0.74u w=0.15u l=0.13u
X2374 VDD.t282 6to4_0.buff_PI_d32_2.inv_PI_d32_0.VIN.t75 PH270.t41 VDD.t215 sg13_lv_pmos ad=0.1005p pd=1.34u as=55.5f ps=0.74u w=0.15u l=0.13u
X2375 PH180.t39 6to4_0.buff_PI_d32_3.inv_PI_d32_0.VIN VDD.t683 VDD.t673 sg13_lv_pmos ad=0.1005p pd=1.34u as=55.5f ps=0.74u w=0.15u l=0.13u
X2376 VSS.t538 6to4_0.buff_PI_d32_0.inv_PI_d32_0.VIN PH90.t6 VSS.t537 sg13_lv_nmos ad=0.1005p pd=1.34u as=55.5f ps=0.74u w=0.15u l=0.13u
X2377 VDD.t562 6to4_0.buff_PI_d32_1.inv_PI_d32_0.VIN PH0.t45 VDD.t17 sg13_lv_pmos ad=55.5f pd=0.74u as=55.5f ps=0.74u w=0.15u l=0.13u
X2378 6to4_0.buff_PI_d32_1.buff_PI_d16$1_0.inv_PI_d8$1_0.VOUT.t10 6to4_0.buff_PI_d32_1.buff_PI_d16$1_0.inv_PI_d4$1_0.VOUT.t15 VDD.t183 VDD.t173 sg13_lv_pmos ad=0.1005p pd=1.34u as=55.5f ps=0.74u w=0.15u l=0.13u
X2379 VSS.t25 6to4_0.buff_PI_d32_1.buff_PI_d16$1_0.inv_PI_d4$1_0.VIN 6to4_0.buff_PI_d32_1.buff_PI_d16$1_0.inv_PI_d4$1_0.VOUT.t0 VSS.t24 sg13_lv_nmos ad=0.1005p pd=1.34u as=55.5f ps=0.74u w=0.15u l=0.13u
X2380 VSS.t811 6ph_rosc_0.psdiff_1.VOUTDP 6ph_rosc_0.psdiff_0.buff_d8$1_0.VIN.t18 VSS.t810 sg13_lv_nmos ad=55.5f pd=0.74u as=55.5f ps=0.74u w=0.15u l=0.13u
X2381 PH270.t40 6to4_0.buff_PI_d32_2.inv_PI_d32_0.VIN.t74 VDD.t279 VDD.t202 sg13_lv_pmos ad=55.5f pd=0.74u as=0.1005p ps=1.34u w=0.15u l=0.13u
X2382 VDD.t127 6to4_0.buff_PI_d32_2.buff_PI_d16$1_0.inv_PI_d4$1_0.VIN 6to4_0.buff_PI_d32_2.buff_PI_d16$1_0.inv_PI_d4$1_0.VOUT.t4 VDD.t126 sg13_lv_pmos ad=55.5f pd=0.74u as=55.5f ps=0.74u w=0.15u l=0.13u
X2383 VSS.t1019 6to4_0.buff_PI_d32_3.inv_PI_d32_0.VIN PH180.t6 VSS.t1018 sg13_lv_nmos ad=0.1005p pd=1.34u as=55.5f ps=0.74u w=0.15u l=0.13u
X2384 VDD.t1119 6to4_0.buff_PI_d32_0.buff_PI_d16$1_0.inv_PI_d8$1_0.VOUT.t37 6to4_0.buff_PI_d32_0.inv_PI_d16$1_0.VIN.t40 VDD.t5 sg13_lv_pmos ad=55.5f pd=0.74u as=0.1005p ps=1.34u w=0.15u l=0.13u
X2385 CTRL 6ph_rosc_0.PH4.t10 CTRL VDD.t451 sg13_lv_pmos ad=0.19p pd=1.38u as=0 ps=0 w=1u l=0.13u
X2386 6ph_rosc_0.psdiff_2.buff_d8$1_0.VIN.t10 CTRL a_6156_2338# VSS.t491 sg13_lv_nmos ad=0.1005p pd=1.34u as=55.5f ps=0.74u w=0.15u l=0.13u
X2387 VSS.t215 6ph_rosc_0.psdiff_2.VOUTDP 6ph_rosc_0.psdiff_1.buff_d8$1_0.VIN.t3 VSS.t214 sg13_lv_nmos ad=55.5f pd=0.74u as=55.5f ps=0.74u w=0.15u l=0.13u
X2388 6ph_rosc_0.PH5.t4 6ph_rosc_0.buff_d8$1_1.inv_d8$1_0.VIN VDD.t316 VDD.t75 sg13_lv_pmos ad=55.5f pd=0.74u as=0.1005p ps=1.34u w=0.15u l=0.13u
X2389 VSS.t115 6ph_rosc_0.buff_d8$1_2.inv_d4$1_0.VIN 6ph_rosc_0.buff_d8$1_2.inv_d8$1_0.VIN VSS.t114 sg13_lv_nmos ad=0.1005p pd=1.34u as=55.5f ps=0.74u w=0.15u l=0.13u
X2390 VDD.t1155 6to4_0.buff_PI_d32_1.buff_PI_d16$1_0.inv_PI_d8$1_0.VOUT.t39 6to4_0.buff_PI_d32_1.inv_PI_d16$1_0.VIN VDD.t17 sg13_lv_pmos ad=0.1005p pd=1.34u as=55.5f ps=0.74u w=0.15u l=0.13u
X2391 VDD.t140 6ph_rosc_0.psdiff_2.buff_d8$1_0.inv_d8$1_0.VIN 6ph_rosc_0.psdiff_2.VOUTDP VDD.t34 sg13_lv_pmos ad=0.1005p pd=1.34u as=55.5f ps=0.74u w=0.15u l=0.13u
X2392 CTRL 6ph_rosc_0.PH0.t10 CTRL VDD.t51 sg13_lv_pmos ad=0.19p pd=1.38u as=0 ps=0 w=1u l=0.13u
X2393 PH0.t6 6to4_0.buff_PI_d32_1.inv_PI_d32_0.VIN VSS.t859 VSS.t858 sg13_lv_nmos ad=55.5f pd=0.74u as=0.1005p ps=1.34u w=0.15u l=0.13u
X2394 VDD.t38 6to4_0.flywheel_clk_1.PH0 6to4_0.inv_PI_d2$1_2.VOUT VDD.t37 sg13_lv_pmos ad=0.1005p pd=1.34u as=55.5f ps=0.74u w=0.15u l=0.13u
X2395 VDD.t240 6to4_0.buff_PI_d32_2.inv_PI_d32_0.VIN.t61 PH270.t39 VDD.t202 sg13_lv_pmos ad=0.1005p pd=1.34u as=55.5f ps=0.74u w=0.15u l=0.13u
X2396 VSS.t1350 6to4_0.buff_PI_d32_3.inv_PI_d16$1_0.VIN.t61 6to4_0.buff_PI_d32_3.inv_PI_d32_0.VIN VSS.t1349 sg13_lv_nmos ad=0.1005p pd=1.34u as=55.5f ps=0.74u w=0.15u l=0.13u
X2397 VDD.t863 6to4_0.buff_PI_d32_3.inv_PI_d16$1_0.VIN.t48 6to4_0.buff_PI_d32_3.inv_PI_d32_0.VIN VDD.t679 sg13_lv_pmos ad=55.5f pd=0.74u as=55.5f ps=0.74u w=0.15u l=0.13u
X2398 6ph_rosc_0.psdiff_1.buff_d8$1_1.VIN.t18 6ph_rosc_0.psdiff_2.VOUTDN VSS.t1136 VSS.t1134 sg13_lv_nmos ad=55.5f pd=0.74u as=55.5f ps=0.74u w=0.15u l=0.13u
X2399 VSS.t1280 6to4_0.buff_PI_d32_0.buff_PI_d16$1_0.inv_PI_d4$1_0.VOUT.t18 6to4_0.buff_PI_d32_0.buff_PI_d16$1_0.inv_PI_d8$1_0.VOUT.t18 VSS.t1279 sg13_lv_nmos ad=0.1005p pd=1.34u as=55.5f ps=0.74u w=0.15u l=0.13u
X2400 6to4_0.buff_PI_d32_3.inv_PI_d32_0.VIN 6to4_0.buff_PI_d32_3.inv_PI_d16$1_0.VIN.t62 VSS.t1354 VSS.t1353 sg13_lv_nmos ad=55.5f pd=0.74u as=0.1005p ps=1.34u w=0.15u l=0.13u
X2401 VDD.t156 6ph_rosc_0.psdiff_1.buff_d8$1_1.inv_d8$1_0.VIN 6ph_rosc_0.psdiff_1.VOUTDN VDD.t0 sg13_lv_pmos ad=0.1005p pd=1.34u as=55.5f ps=0.74u w=0.15u l=0.13u
X2402 VSS.t1206 6to4_0.buff_PI_d32_2.buff_PI_d16$1_0.inv_PI_d8$1_0.VOUT.t31 6to4_0.buff_PI_d32_2.inv_PI_d16$1_0.VIN.t5 VSS.t1205 sg13_lv_nmos ad=0.1005p pd=1.34u as=55.5f ps=0.74u w=0.15u l=0.13u
X2403 CTRL 6ph_rosc_0.PH0.t10 CTRL VDD.t51 sg13_lv_pmos ad=0.34p pd=2.68u as=0 ps=0 w=1u l=0.13u
X2404 6to4_0.buff_PI_d32_0.inv_PI_d32_0.VIN 6to4_0.buff_PI_d32_0.inv_PI_d16$1_0.VIN.t53 VDD.t935 VDD.t341 sg13_lv_pmos ad=55.5f pd=0.74u as=55.5f ps=0.74u w=0.15u l=0.13u
X2405 PH0.t44 6to4_0.buff_PI_d32_1.inv_PI_d32_0.VIN VDD.t561 VDD.t173 sg13_lv_pmos ad=55.5f pd=0.74u as=0.1005p ps=1.34u w=0.15u l=0.13u
X2406 6to4_0.buff_PI_d32_2.VIN 6to4_0.flywheel_clk_0.PH0 VSS.t9 VSS.t8 sg13_lv_nmos ad=55.5f pd=0.74u as=0.1005p ps=1.34u w=0.15u l=0.13u
X2407 VSS.t1534 6to4_0.buff_PI_d32_2.buff_PI_d16$1_0.inv_PI_d4$1_0.VOUT.t12 6to4_0.buff_PI_d32_2.buff_PI_d16$1_0.inv_PI_d8$1_0.VOUT.t1 VSS.t1533 sg13_lv_nmos ad=0.1005p pd=1.34u as=55.5f ps=0.74u w=0.15u l=0.13u
X2408 PH180.t5 6to4_0.buff_PI_d32_3.inv_PI_d32_0.VIN VSS.t1017 VSS.t1016 sg13_lv_nmos ad=55.5f pd=0.74u as=0.1005p ps=1.34u w=0.15u l=0.13u
X2409 PH180.t38 6to4_0.buff_PI_d32_3.inv_PI_d32_0.VIN VDD.t682 VDD.t679 sg13_lv_pmos ad=55.5f pd=0.74u as=55.5f ps=0.74u w=0.15u l=0.13u
X2410 VSS.t1650 6to4_0.buff_PI_d32_0.buff_PI_d16$1_0.inv_PI_d8$1_0.VOUT.t38 6to4_0.buff_PI_d32_0.inv_PI_d16$1_0.VIN.t42 VSS.t1649 sg13_lv_nmos ad=0.1005p pd=1.34u as=55.5f ps=0.74u w=0.15u l=0.13u
X2411 VDD.t1132 6ph_rosc_0.PH5.t11 6to4_0.PI_clk_1.inv_PI_d2$1_0.VOUT VDD.t1128 sg13_lv_pmos ad=55.5f pd=0.74u as=55.5f ps=0.74u w=0.15u l=0.13u
X2412 VSS.t1865 6to4_0.buff_PI_d32_1.inv_PI_d16$1_0.VIN 6to4_0.buff_PI_d32_1.inv_PI_d32_0.VIN VSS.t1864 sg13_lv_nmos ad=0.1005p pd=1.34u as=55.5f ps=0.74u w=0.15u l=0.13u
X2413 6to4_0.buff_PI_d32_2.buff_PI_d16$1_0.inv_PI_d8$1_0.VOUT.t11 6to4_0.buff_PI_d32_2.buff_PI_d16$1_0.inv_PI_d4$1_0.VOUT.t17 VDD.t1055 VDD.t198 sg13_lv_pmos ad=55.5f pd=0.74u as=0.1005p ps=1.34u w=0.15u l=0.13u
X2414 VSS.t977 6ph_rosc_0.psdiff_1.buff_d8$1_0.inv_d8$1_0.VIN 6ph_rosc_0.psdiff_1.VOUTDP VSS.t976 sg13_lv_nmos ad=0.1005p pd=1.34u as=55.5f ps=0.74u w=0.15u l=0.13u
X2415 VSS.t364 6to4_0.buff_PI_d32_2.inv_PI_d32_0.VIN.t56 PH270.t5 VSS.t363 sg13_lv_nmos ad=0.1005p pd=1.34u as=55.5f ps=0.74u w=0.15u l=0.13u
X2416 VDD.t1007 6to4_0.buff_PI_d32_2.inv_PI_d16$1_0.VIN.t61 6to4_0.buff_PI_d32_2.inv_PI_d32_0.VIN.t40 VDD.t198 sg13_lv_pmos ad=55.5f pd=0.74u as=55.5f ps=0.74u w=0.15u l=0.13u
X2417 6to4_0.buff_PI_d32_2.inv_PI_d32_0.VIN.t3 6to4_0.buff_PI_d32_2.inv_PI_d16$1_0.VIN.t49 VSS.t1442 VSS.t1441 sg13_lv_nmos ad=55.5f pd=0.74u as=0.1005p ps=1.34u w=0.15u l=0.13u
X2418 6ph_rosc_0.PH4.t2 6ph_rosc_0.buff_d8$1_2.inv_d8$1_0.VIN VSS.t670 VSS.t669 sg13_lv_nmos ad=55.5f pd=0.74u as=0.1005p ps=1.34u w=0.15u l=0.13u
X2419 PH0.t43 6to4_0.buff_PI_d32_1.inv_PI_d32_0.VIN VDD.t560 VDD.t547 sg13_lv_pmos ad=0.1005p pd=1.34u as=55.5f ps=0.74u w=0.15u l=0.13u
X2420 6to4_0.buff_PI_d32_0.inv_PI_d32_0.VIN 6to4_0.buff_PI_d32_0.inv_PI_d16$1_0.VIN.t55 VSS.t1402 VSS.t1401 sg13_lv_nmos ad=55.5f pd=0.74u as=0.1005p ps=1.34u w=0.15u l=0.13u
X2421 VDD.t559 6to4_0.buff_PI_d32_1.inv_PI_d32_0.VIN PH0.t42 VDD.t547 sg13_lv_pmos ad=0.1005p pd=1.34u as=55.5f ps=0.74u w=0.15u l=0.13u
X2422 VDD.t646 a_4999_2194# 6ph_rosc_0.psdiff_2.buff_d8$1_0.VIN.t28 VDD.t470 sg13_lv_pmos ad=55.5f pd=0.74u as=55.5f ps=0.74u w=0.15u l=0.13u
X2423 6ph_rosc_0.psdiff_1.buff_d8$1_0.VIN.t2 6ph_rosc_0.psdiff_2.VOUTDP VSS.t213 VSS.t212 sg13_lv_nmos ad=55.5f pd=0.74u as=55.5f ps=0.74u w=0.15u l=0.13u
X2424 6ph_rosc_0.psdiff_1.buff_d8$1_0.VIN.t17 VSS.t1967 VDD.t1385 VDD.t301 sg13_lv_pmos ad=55.5f pd=0.74u as=55.5f ps=0.74u w=0.15u l=0.13u
X2425 CTRL 6ph_rosc_0.PH1.t10 CTRL VDD.t80 sg13_lv_pmos ad=0.19p pd=1.38u as=0 ps=0 w=1u l=0.13u
X2426 VDD.t1257 6to4_0.buff_PI_d32_1.inv_PI_d16$1_0.VIN 6to4_0.buff_PI_d32_1.inv_PI_d32_0.VIN VDD.t173 sg13_lv_pmos ad=0.1005p pd=1.34u as=55.5f ps=0.74u w=0.15u l=0.13u
X2427 VSS.t103 6ph_rosc_0.psdiff_1.buff_d8$1_0.inv_d4$1_0.VIN 6ph_rosc_0.psdiff_1.buff_d8$1_0.inv_d8$1_0.VIN VSS.t102 sg13_lv_nmos ad=0.1005p pd=1.34u as=55.5f ps=0.74u w=0.15u l=0.13u
X2428 6to4_0.buff_PI_d32_1.inv_PI_d16$1_0.VIN 6to4_0.buff_PI_d32_1.buff_PI_d16$1_0.inv_PI_d8$1_0.VOUT.t31 VDD.t1154 VDD.t17 sg13_lv_pmos ad=0.1005p pd=1.34u as=55.5f ps=0.74u w=0.15u l=0.13u
X2429 PH270.t38 6to4_0.buff_PI_d32_2.inv_PI_d32_0.VIN.t65 VDD.t252 VDD.t126 sg13_lv_pmos ad=55.5f pd=0.74u as=55.5f ps=0.74u w=0.15u l=0.13u
X2430 VDD.t645 a_4999_2194# 6ph_rosc_0.psdiff_2.buff_d8$1_0.VIN.t27 VDD.t470 sg13_lv_pmos ad=55.5f pd=0.74u as=55.5f ps=0.74u w=0.15u l=0.13u
X2431 VSS.t698 6ph_rosc_0.psdiff_2.CLKN 6ph_rosc_0.psdiff_2.buff_d8$1_0.VIN.t14 VSS.t697 sg13_lv_nmos ad=55.5f pd=0.74u as=55.5f ps=0.74u w=0.15u l=0.13u
X2432 CTRL 6ph_rosc_0.PH2.t10 CTRL VDD.t440 sg13_lv_pmos ad=0.19p pd=1.38u as=0 ps=0 w=1u l=0.13u
X2433 PH180.t4 6to4_0.buff_PI_d32_3.inv_PI_d32_0.VIN VSS.t1015 VSS.t1014 sg13_lv_nmos ad=55.5f pd=0.74u as=0.1005p ps=1.34u w=0.15u l=0.13u
X2434 6ph_rosc_0.psdiff_1.buff_d8$1_0.VIN.t1 6ph_rosc_0.psdiff_2.VOUTDP VSS.t211 VSS.t210 sg13_lv_nmos ad=55.5f pd=0.74u as=55.5f ps=0.74u w=0.15u l=0.13u
X2435 6ph_rosc_0.psdiff_0.buff_d8$1_0.VIN.t17 6ph_rosc_0.psdiff_1.VOUTDP VSS.t809 VSS.t808 sg13_lv_nmos ad=55.5f pd=0.74u as=55.5f ps=0.74u w=0.15u l=0.13u
X2436 6to4_0.PI_clk_0.inv_PI_d2$1_0.VOUT 6ph_rosc_0.PH2.t11 VDD.t1140 VDD.t1138 sg13_lv_pmos ad=55.5f pd=0.74u as=0.1005p ps=1.34u w=0.15u l=0.13u
X2437 PH180.t3 6to4_0.buff_PI_d32_3.inv_PI_d32_0.VIN VSS.t1013 VSS.t1012 sg13_lv_nmos ad=55.5f pd=0.74u as=0.1005p ps=1.34u w=0.15u l=0.13u
X2438 6to4_0.PI_clk_0.inv_PI_d2$1_0.VOUT 6ph_rosc_0.PH2.t12 VSS.t1674 VSS.t1673 sg13_lv_nmos ad=55.5f pd=0.74u as=0.1005p ps=1.34u w=0.15u l=0.13u
X2439 6ph_rosc_0.psdiff_2.buff_d8$1_1.VIN.t1 6ph_rosc_0.psdiff_2.CLKP.t8 VSS.t1686 VSS.t1685 sg13_lv_nmos ad=55.5f pd=0.74u as=0.1005p ps=1.34u w=0.15u l=0.13u
X2440 PH0.t41 6to4_0.buff_PI_d32_1.inv_PI_d32_0.VIN VDD.t558 VDD.t17 sg13_lv_pmos ad=0.1005p pd=1.34u as=55.5f ps=0.74u w=0.15u l=0.13u
X2441 VDD.t351 6to4_0.buff_PI_d32_0.inv_PI_d32_0.VIN PH90.t39 VDD.t341 sg13_lv_pmos ad=55.5f pd=0.74u as=55.5f ps=0.74u w=0.15u l=0.13u
X2442 PH90.t5 6to4_0.buff_PI_d32_0.inv_PI_d32_0.VIN VSS.t536 VSS.t535 sg13_lv_nmos ad=55.5f pd=0.74u as=0.1005p ps=1.34u w=0.15u l=0.13u
X2443 6to4_0.PI_clk_1.inv_PI_d2$1_0.VOUT 6ph_rosc_0.PH5.t10 VDD.t1129 VDD.t1128 sg13_lv_pmos ad=55.5f pd=0.74u as=55.5f ps=0.74u w=0.15u l=0.13u
X2444 VSS.t304 6to4_0.buff_PI_d32_1.buff_PI_d16$1_0.inv_PI_d4$1_0.VOUT.t13 6to4_0.buff_PI_d32_1.buff_PI_d16$1_0.inv_PI_d8$1_0.VOUT.t5 VSS.t303 sg13_lv_nmos ad=0.1005p pd=1.34u as=55.5f ps=0.74u w=0.15u l=0.13u
X2445 CTRL 6ph_rosc_0.PH2.t10 CTRL VDD.t440 sg13_lv_pmos ad=0.19p pd=1.38u as=0 ps=0 w=1u l=0.13u
X2446 6to4_0.buff_PI_d32_0.inv_PI_d16$1_0.VIN.t21 6to4_0.buff_PI_d32_0.buff_PI_d16$1_0.inv_PI_d8$1_0.VOUT.t31 VSS.t1622 VSS.t1621 sg13_lv_nmos ad=55.5f pd=0.74u as=0.1005p ps=1.34u w=0.15u l=0.13u
X2447 6ph_rosc_0.psdiff_2.buff_d8$1_1.VIN.t0 6ph_rosc_0.psdiff_2.CLKP.t8 VSS.t1684 VSS.t498 sg13_lv_nmos ad=55.5f pd=0.74u as=55.5f ps=0.74u w=0.15u l=0.13u
X2448 VSS.t1342 6to4_0.buff_PI_d32_3.inv_PI_d16$1_0.VIN.t59 6to4_0.buff_PI_d32_3.inv_PI_d32_0.VIN VSS.t1341 sg13_lv_nmos ad=0.1005p pd=1.34u as=55.5f ps=0.74u w=0.15u l=0.13u
X2449 VDD.t1058 6to4_0.buff_PI_d32_2.buff_PI_d16$1_0.inv_PI_d4$1_0.VOUT.t18 6to4_0.buff_PI_d32_2.buff_PI_d16$1_0.inv_PI_d8$1_0.VOUT.t10 VDD.t198 sg13_lv_pmos ad=55.5f pd=0.74u as=0.1005p ps=1.34u w=0.15u l=0.13u
X2450 PH270.t37 6to4_0.buff_PI_d32_2.inv_PI_d32_0.VIN.t59 VDD.t234 VDD.t215 sg13_lv_pmos ad=55.5f pd=0.74u as=55.5f ps=0.74u w=0.15u l=0.13u
X2451 6ph_rosc_0.psdiff_2.CLKP.t4 6ph_rosc_0.psdiff_0.buff_d8$1_1.inv_d8$1_0.VIN VDD.t495 VDD.t0 sg13_lv_pmos ad=55.5f pd=0.74u as=0.1005p ps=1.34u w=0.15u l=0.13u
X2452 PH180.t2 6to4_0.buff_PI_d32_3.inv_PI_d32_0.VIN VSS.t1011 VSS.t1010 sg13_lv_nmos ad=55.5f pd=0.74u as=0.1005p ps=1.34u w=0.15u l=0.13u
X2453 6to4_0.buff_PI_d32_3.inv_PI_d32_0.VIN 6to4_0.buff_PI_d32_3.inv_PI_d16$1_0.VIN.t53 VDD.t878 VDD.t679 sg13_lv_pmos ad=55.5f pd=0.74u as=0.1005p ps=1.34u w=0.15u l=0.13u
X2454 VSS.t1733 6to4_0.buff_PI_d32_1.buff_PI_d16$1_0.inv_PI_d8$1_0.VOUT.t24 6to4_0.buff_PI_d32_1.inv_PI_d16$1_0.VIN VSS.t1732 sg13_lv_nmos ad=0.1005p pd=1.34u as=55.5f ps=0.74u w=0.15u l=0.13u
X2455 6to4_0.buff_PI_d32_0.buff_PI_d16$1_0.inv_PI_d4$1_0.VOUT.t4 6to4_0.buff_PI_d32_0.buff_PI_d16$1_0.inv_PI_d4$1_0.VIN VDD.t59 VDD.t5 sg13_lv_pmos ad=55.5f pd=0.74u as=55.5f ps=0.74u w=0.15u l=0.13u
X2456 6to4_0.buff_PI_d32_0.inv_PI_d16$1_0.VIN.t27 6to4_0.buff_PI_d32_0.buff_PI_d16$1_0.inv_PI_d8$1_0.VOUT.t33 VSS.t1630 VSS.t1629 sg13_lv_nmos ad=55.5f pd=0.74u as=0.1005p ps=1.34u w=0.15u l=0.13u
X2457 VSS.t209 6ph_rosc_0.psdiff_2.VOUTDP 6ph_rosc_0.psdiff_1.buff_d8$1_0.VIN.t0 VSS.t208 sg13_lv_nmos ad=0.1005p pd=1.34u as=55.5f ps=0.74u w=0.15u l=0.13u
X2458 6ph_rosc_0.psdiff_1.VOUTDP 6ph_rosc_0.psdiff_1.buff_d8$1_0.inv_d8$1_0.VIN VSS.t975 VSS.t974 sg13_lv_nmos ad=55.5f pd=0.74u as=0.1005p ps=1.34u w=0.15u l=0.13u
X2459 6to4_0.buff_PI_d32_2.inv_PI_d32_0.VIN.t18 6to4_0.buff_PI_d32_2.inv_PI_d16$1_0.VIN.t54 VSS.t1462 VSS.t1461 sg13_lv_nmos ad=55.5f pd=0.74u as=0.1005p ps=1.34u w=0.15u l=0.13u
X2460 6to4_0.buff_PI_d32_2.inv_PI_d32_0.VIN.t27 6to4_0.buff_PI_d32_2.inv_PI_d16$1_0.VIN.t57 VSS.t1474 VSS.t1473 sg13_lv_nmos ad=55.5f pd=0.74u as=0.1005p ps=1.34u w=0.15u l=0.13u
X2461 VSS.t250 6ph_rosc_0.buff_d8$1_3.inv_d8$1_0.VIN 6ph_rosc_0.PH1.t0 VSS.t249 sg13_lv_nmos ad=0.1005p pd=1.34u as=55.5f ps=0.74u w=0.15u l=0.13u
X2462 6ph_rosc_0.buff_d8$1_2.inv_d8$1_0.VIN 6ph_rosc_0.buff_d8$1_2.inv_d4$1_0.VIN VDD.t79 VDD.t78 sg13_lv_pmos ad=55.5f pd=0.74u as=0.1005p ps=1.34u w=0.15u l=0.13u
X2463 VDD.t1110 6to4_0.buff_PI_d32_0.buff_PI_d16$1_0.inv_PI_d8$1_0.VOUT.t34 6to4_0.buff_PI_d32_0.inv_PI_d16$1_0.VIN.t31 VDD.t341 sg13_lv_pmos ad=0.1005p pd=1.34u as=55.5f ps=0.74u w=0.15u l=0.13u
X2464 6to4_0.buff_PI_d32_2.buff_PI_d16$1_0.inv_PI_d4$1_0.VOUT.t0 6to4_0.buff_PI_d32_2.buff_PI_d16$1_0.inv_PI_d4$1_0.VIN VSS.t177 VSS.t176 sg13_lv_nmos ad=55.5f pd=0.74u as=0.1005p ps=1.34u w=0.15u l=0.13u
X2465 VDD.t1153 6to4_0.buff_PI_d32_1.buff_PI_d16$1_0.inv_PI_d8$1_0.VOUT.t36 6to4_0.buff_PI_d32_1.inv_PI_d16$1_0.VIN VDD.t173 sg13_lv_pmos ad=55.5f pd=0.74u as=55.5f ps=0.74u w=0.15u l=0.13u
X2466 6to4_0.buff_PI_d32_0.inv_PI_d32_0.VIN 6to4_0.buff_PI_d32_0.inv_PI_d16$1_0.VIN.t62 VSS.t1430 VSS.t1429 sg13_lv_nmos ad=55.5f pd=0.74u as=0.1005p ps=1.34u w=0.15u l=0.13u
X2467 6ph_rosc_0.psdiff_0.buff_d8$1_1.VIN.t1 VSS.t1965 VDD.t1305 VDD.t503 sg13_lv_pmos ad=55.5f pd=0.74u as=55.5f ps=0.74u w=0.15u l=0.13u
X2468 VSS.t857 6to4_0.buff_PI_d32_1.inv_PI_d32_0.VIN PH0.t5 VSS.t856 sg13_lv_nmos ad=0.1005p pd=1.34u as=55.5f ps=0.74u w=0.15u l=0.13u
X2469 6to4_0.buff_PI_d32_1.inv_PI_d32_0.VIN 6to4_0.buff_PI_d32_1.inv_PI_d16$1_0.VIN VDD.t1256 VDD.t173 sg13_lv_pmos ad=0.1005p pd=1.34u as=55.5f ps=0.74u w=0.15u l=0.13u
X2470 VDD.t291 6to4_0.buff_PI_d32_2.inv_PI_d32_0.VIN.t78 PH270.t36 VDD.t126 sg13_lv_pmos ad=55.5f pd=0.74u as=55.5f ps=0.74u w=0.15u l=0.13u
X2471 6ph_rosc_0.psdiff_2.buff_d8$1_0.VIN.t1 VSS.t1966 VDD.t1347 VDD.t470 sg13_lv_pmos ad=55.5f pd=0.74u as=0.1005p ps=1.34u w=0.15u l=0.13u
X2472 VDD.t869 6to4_0.buff_PI_d32_3.inv_PI_d16$1_0.VIN.t50 6to4_0.buff_PI_d32_3.inv_PI_d32_0.VIN VDD.t99 sg13_lv_pmos ad=55.5f pd=0.74u as=55.5f ps=0.74u w=0.15u l=0.13u
X2473 6to4_0.buff_PI_d32_2.buff_PI_d16$1_0.inv_PI_d8$1_0.VOUT.t9 6to4_0.buff_PI_d32_2.buff_PI_d16$1_0.inv_PI_d4$1_0.VOUT.t13 VDD.t1043 VDD.t198 sg13_lv_pmos ad=0.1005p pd=1.34u as=55.5f ps=0.74u w=0.15u l=0.13u
X2474 PH90.t38 6to4_0.buff_PI_d32_0.inv_PI_d32_0.VIN VDD.t350 VDD.t343 sg13_lv_pmos ad=0.1005p pd=1.34u as=55.5f ps=0.74u w=0.15u l=0.13u
X2475 6to4_0.buff_PI_d32_1.inv_PI_d16$1_0.VIN 6to4_0.buff_PI_d32_1.buff_PI_d16$1_0.inv_PI_d8$1_0.VOUT.t25 VSS.t1731 VSS.t1730 sg13_lv_nmos ad=55.5f pd=0.74u as=0.1005p ps=1.34u w=0.15u l=0.13u
X2476 VSS.t1514 6to4_0.buff_PI_d32_3.buff_PI_d16$1_0.inv_PI_d4$1_0.VOUT.t19 6to4_0.buff_PI_d32_3.buff_PI_d16$1_0.inv_PI_d8$1_0.VOUT.t0 VSS.t1513 sg13_lv_nmos ad=0.1005p pd=1.34u as=55.5f ps=0.74u w=0.15u l=0.13u
X2477 6ph_rosc_0.psdiff_2.buff_d8$1_0.VIN.t0 VSS.t1966 VDD.t1344 VDD.t470 sg13_lv_pmos ad=55.5f pd=0.74u as=55.5f ps=0.74u w=0.15u l=0.13u
X2478 PH0.t40 6to4_0.buff_PI_d32_1.inv_PI_d32_0.VIN VDD.t557 VDD.t552 sg13_lv_pmos ad=0.1005p pd=1.34u as=55.5f ps=0.74u w=0.15u l=0.13u
X2479 VSS.t85 6to4_0.buff_PI_d32_0.buff_PI_d16$1_0.inv_PI_d4$1_0.VIN 6to4_0.buff_PI_d32_0.buff_PI_d16$1_0.inv_PI_d4$1_0.VOUT.t0 VSS.t84 sg13_lv_nmos ad=0.1005p pd=1.34u as=55.5f ps=0.74u w=0.15u l=0.13u
X2480 VDD.t489 6to4_0.inv_PI_d2$1_1.VIN 6to4_0.flywheel_clk_1.PH0 VDD.t17 sg13_lv_pmos ad=0.1005p pd=1.34u as=55.5f ps=0.74u w=0.15u l=0.13u
X2481 6to4_0.buff_PI_d32_2.inv_PI_d16$1_0.VIN.t18 6to4_0.buff_PI_d32_2.buff_PI_d16$1_0.inv_PI_d8$1_0.VOUT.t36 VDD.t812 VDD.t126 sg13_lv_pmos ad=55.5f pd=0.74u as=0.1005p ps=1.34u w=0.15u l=0.13u
X2482 VSS.t502 6to4_0.inv_PI_d2$1_3.VOUT 6to4_0.inv_PI_d2$1_2.VOUT VSS.t501 sg13_lv_nmos ad=0.1005p pd=1.34u as=55.5f ps=0.74u w=0.15u l=0.13u
X2483 PH270.t4 6to4_0.buff_PI_d32_2.inv_PI_d32_0.VIN.t50 VSS.t340 VSS.t339 sg13_lv_nmos ad=55.5f pd=0.74u as=0.1005p ps=1.34u w=0.15u l=0.13u
X2484 CTRL 6ph_rosc_0.PH1.t10 CTRL VDD.t82 sg13_lv_pmos ad=0.19p pd=1.38u as=0 ps=0 w=1u l=0.13u
X2485 VSS.t1574 6ph_rosc_0.PH4.t14 6to4_0.PI_clk_1.inv_PI_d2$1_0.VOUT VSS.t1573 sg13_lv_nmos ad=0.1005p pd=1.34u as=55.5f ps=0.74u w=0.15u l=0.13u
X2486 VDD.t881 6to4_0.buff_PI_d32_3.inv_PI_d16$1_0.VIN.t54 6to4_0.buff_PI_d32_3.inv_PI_d32_0.VIN VDD.t99 sg13_lv_pmos ad=55.5f pd=0.74u as=0.1005p ps=1.34u w=0.15u l=0.13u
X2487 VDD.t556 6to4_0.buff_PI_d32_1.inv_PI_d32_0.VIN PH0.t39 VDD.t17 sg13_lv_pmos ad=0.1005p pd=1.34u as=55.5f ps=0.74u w=0.15u l=0.13u
X2488 6to4_0.buff_PI_d32_1.inv_PI_d16$1_0.VIN 6to4_0.buff_PI_d32_1.buff_PI_d16$1_0.inv_PI_d8$1_0.VOUT.t26 VSS.t1729 VSS.t1728 sg13_lv_nmos ad=55.5f pd=0.74u as=0.1005p ps=1.34u w=0.15u l=0.13u
X2489 6to4_0.buff_PI_d32_2.inv_PI_d16$1_0.VIN.t4 6to4_0.buff_PI_d32_2.buff_PI_d16$1_0.inv_PI_d8$1_0.VOUT.t32 VSS.t1210 VSS.t1209 sg13_lv_nmos ad=55.5f pd=0.74u as=0.1005p ps=1.34u w=0.15u l=0.13u
X2490 CTRL 6ph_rosc_0.PH1.t10 CTRL VDD.t78 sg13_lv_pmos ad=0.19p pd=1.38u as=0 ps=0 w=1u l=0.13u
X2491 6to4_0.buff_PI_d32_0.buff_PI_d16$1_0.inv_PI_d4$1_0.VIN 6to4_0.flywheel_clk_0.PH0 VDD.t7 VDD.t5 sg13_lv_pmos ad=55.5f pd=0.74u as=0.1005p ps=1.34u w=0.15u l=0.13u
X2492 VDD.t49 6ph_rosc_0.buff_d8$1_5.inv_d8$1_0.VIN 6ph_rosc_0.PH0.t4 VDD.t48 sg13_lv_pmos ad=0.1005p pd=1.34u as=55.5f ps=0.74u w=0.15u l=0.13u
X2493 VSS.t1009 6to4_0.buff_PI_d32_3.inv_PI_d32_0.VIN PH180.t1 VSS.t1008 sg13_lv_nmos ad=0.1005p pd=1.34u as=55.5f ps=0.74u w=0.15u l=0.13u
X2494 6to4_0.buff_PI_d32_0.inv_PI_d16$1_0.VIN.t37 6to4_0.buff_PI_d32_0.buff_PI_d16$1_0.inv_PI_d8$1_0.VOUT.t36 VDD.t1116 VDD.t341 sg13_lv_pmos ad=0.1005p pd=1.34u as=55.5f ps=0.74u w=0.15u l=0.13u
X2495 6to4_0.buff_PI_d32_0.inv_PI_d16$1_0.VIN.t30 6to4_0.buff_PI_d32_0.buff_PI_d16$1_0.inv_PI_d8$1_0.VOUT.t34 VSS.t1634 VSS.t1633 sg13_lv_nmos ad=55.5f pd=0.74u as=0.1005p ps=1.34u w=0.15u l=0.13u
X2496 6to4_0.buff_PI_d32_1.inv_PI_d16$1_0.VIN 6to4_0.buff_PI_d32_1.buff_PI_d16$1_0.inv_PI_d8$1_0.VOUT.t33 VDD.t1152 VDD.t173 sg13_lv_pmos ad=55.5f pd=0.74u as=55.5f ps=0.74u w=0.15u l=0.13u
X2497 6to4_0.buff_PI_d32_2.inv_PI_d32_0.VIN.t9 6to4_0.buff_PI_d32_2.inv_PI_d16$1_0.VIN.t51 VSS.t1450 VSS.t1449 sg13_lv_nmos ad=55.5f pd=0.74u as=0.1005p ps=1.34u w=0.15u l=0.13u
X2498 PH270.t35 6to4_0.buff_PI_d32_2.inv_PI_d32_0.VIN.t67 VDD.t258 VDD.t198 sg13_lv_pmos ad=55.5f pd=0.74u as=0.1005p ps=1.34u w=0.15u l=0.13u
X2499 6ph_rosc_0.buff_d8$1_1.inv_d4$1_0.VIN 6ph_rosc_0.buff_d8$1_1.inv_d2$1_0.VIN VDD.t468 VDD.t75 sg13_lv_pmos ad=55.5f pd=0.74u as=0.1005p ps=1.34u w=0.15u l=0.13u
X2500 VDD.t139 6ph_rosc_0.psdiff_2.buff_d8$1_0.inv_d8$1_0.VIN 6ph_rosc_0.psdiff_2.VOUTDP VDD.t34 sg13_lv_pmos ad=0.1005p pd=1.34u as=55.5f ps=0.74u w=0.15u l=0.13u
X2501 6ph_rosc_0.buff_d8$1_2.inv_d8$1_0.VIN 6ph_rosc_0.buff_d8$1_2.inv_d4$1_0.VIN VSS.t113 VSS.t112 sg13_lv_nmos ad=55.5f pd=0.74u as=0.1005p ps=1.34u w=0.15u l=0.13u
X2502 VDD.t998 6to4_0.buff_PI_d32_2.inv_PI_d16$1_0.VIN.t58 6to4_0.buff_PI_d32_2.inv_PI_d32_0.VIN.t31 VDD.t126 sg13_lv_pmos ad=55.5f pd=0.74u as=0.1005p ps=1.34u w=0.15u l=0.13u
X2503 VSS.t1727 6to4_0.buff_PI_d32_1.buff_PI_d16$1_0.inv_PI_d8$1_0.VOUT.t39 6to4_0.buff_PI_d32_1.inv_PI_d16$1_0.VIN VSS.t1726 sg13_lv_nmos ad=0.1005p pd=1.34u as=55.5f ps=0.74u w=0.15u l=0.13u
X2504 CTRL 6ph_rosc_0.PH3.t11 CTRL VDD.t57 sg13_lv_pmos ad=0.19p pd=1.38u as=0 ps=0 w=1u l=0.13u
X2505 VDD.t1222 6to4_0.buff_PI_d32_3.buff_PI_d16$1_0.inv_PI_d8$1_0.VOUT.t32 6to4_0.buff_PI_d32_3.inv_PI_d16$1_0.VIN.t25 VDD.t99 sg13_lv_pmos ad=55.5f pd=0.74u as=0.1005p ps=1.34u w=0.15u l=0.13u
X2506 PH90.t37 6to4_0.buff_PI_d32_0.inv_PI_d32_0.VIN VDD.t349 VDD.t341 sg13_lv_pmos ad=0.1005p pd=1.34u as=55.5f ps=0.74u w=0.15u l=0.13u
X2507 6ph_rosc_0.PH2.t8 6ph_rosc_0.PH5.t14 VSS.t1668 VSS.t1667 sg13_lv_nmos ad=55.5f pd=0.74u as=0.1005p ps=1.34u w=0.15u l=0.13u
X2508 VSS.t1554 6to4_0.buff_PI_d32_2.buff_PI_d16$1_0.inv_PI_d4$1_0.VOUT.t17 6to4_0.buff_PI_d32_2.buff_PI_d16$1_0.inv_PI_d8$1_0.VOUT.t0 VSS.t1553 sg13_lv_nmos ad=0.1005p pd=1.34u as=55.5f ps=0.74u w=0.15u l=0.13u
X2509 6to4_0.PI_clk_0.inv_PI_d2$1_0.VOUT 6ph_rosc_0.PH2.t11 VDD.t1139 VDD.t1138 sg13_lv_pmos ad=0.1005p pd=1.34u as=55.5f ps=0.74u w=0.15u l=0.13u
X2510 6ph_rosc_0.psdiff_2.buff_d8$1_1.inv_d8$1_0.VIN 6ph_rosc_0.psdiff_2.buff_d8$1_1.inv_d4$1_0.VIN VSS.t41 VSS.t40 sg13_lv_nmos ad=55.5f pd=0.74u as=0.1005p ps=1.34u w=0.15u l=0.13u
X2511 CTRL 6ph_rosc_0.PH1.t10 CTRL VDD.t80 sg13_lv_pmos ad=0.19p pd=1.38u as=0 ps=0 w=1u l=0.13u
X2512 VDD.t830 6ph_rosc_0.PH0.t14 6to4_0.inv_PI_d2$1_1.VIN VDD.t17 sg13_lv_pmos ad=55.5f pd=0.74u as=55.5f ps=0.74u w=0.15u l=0.13u
X2513 VSS.t1284 6to4_0.buff_PI_d32_0.buff_PI_d16$1_0.inv_PI_d4$1_0.VOUT.t19 6to4_0.buff_PI_d32_0.buff_PI_d16$1_0.inv_PI_d8$1_0.VOUT.t21 VSS.t1283 sg13_lv_nmos ad=0.1005p pd=1.34u as=55.5f ps=0.74u w=0.15u l=0.13u
X2514 VDD.t1010 6to4_0.buff_PI_d32_2.inv_PI_d16$1_0.VIN.t62 6to4_0.buff_PI_d32_2.inv_PI_d32_0.VIN.t43 VDD.t198 sg13_lv_pmos ad=0.1005p pd=1.34u as=55.5f ps=0.74u w=0.15u l=0.13u
X2515 VDD.t112 6ph_rosc_0.psdiff_2.buff_d8$1_0.inv_d4$1_0.VIN 6ph_rosc_0.psdiff_2.buff_d8$1_0.inv_d8$1_0.VIN VDD.t34 sg13_lv_pmos ad=0.1005p pd=1.34u as=55.5f ps=0.74u w=0.15u l=0.13u
X2516 PH180.t37 6to4_0.buff_PI_d32_3.inv_PI_d32_0.VIN VDD.t681 VDD.t99 sg13_lv_pmos ad=55.5f pd=0.74u as=0.1005p ps=1.34u w=0.15u l=0.13u
X2517 CTRL 6ph_rosc_0.PH5.t12 CTRL VDD.t87 sg13_lv_pmos ad=0.19p pd=1.38u as=0 ps=0 w=1u l=0.13u
X2518 VDD.t1207 6to4_0.buff_PI_d32_3.buff_PI_d16$1_0.inv_PI_d8$1_0.VOUT.t27 6to4_0.buff_PI_d32_3.inv_PI_d16$1_0.VIN.t10 VDD.t679 sg13_lv_pmos ad=55.5f pd=0.74u as=0.1005p ps=1.34u w=0.15u l=0.13u
X2519 PH0.t38 6to4_0.buff_PI_d32_1.inv_PI_d32_0.VIN VDD.t555 VDD.t552 sg13_lv_pmos ad=55.5f pd=0.74u as=55.5f ps=0.74u w=0.15u l=0.13u
X2520 VSS.t855 6to4_0.buff_PI_d32_1.inv_PI_d32_0.VIN PH0.t4 VSS.t854 sg13_lv_nmos ad=0.1005p pd=1.34u as=55.5f ps=0.74u w=0.15u l=0.13u
X2521 6to4_0.buff_PI_d32_3.inv_PI_d16$1_0.VIN.t12 6to4_0.buff_PI_d32_3.buff_PI_d16$1_0.inv_PI_d8$1_0.VOUT.t28 VSS.t1805 VSS.t1804 sg13_lv_nmos ad=55.5f pd=0.74u as=0.1005p ps=1.34u w=0.15u l=0.13u
X2522 VDD.t833 6ph_rosc_0.psdiff_1.buff_d8$1_0.VIN.t32 6ph_rosc_0.psdiff_1.buff_d8$1_0.inv_d2$1_0.VIN VDD.t34 sg13_lv_pmos ad=0.1005p pd=1.34u as=0.1005p ps=1.34u w=0.15u l=0.13u
X2523 VDD.t554 6to4_0.buff_PI_d32_1.inv_PI_d32_0.VIN PH0.t37 VDD.t552 sg13_lv_pmos ad=55.5f pd=0.74u as=55.5f ps=0.74u w=0.15u l=0.13u
X2524 VSS.t696 6ph_rosc_0.psdiff_2.CLKN 6ph_rosc_0.psdiff_2.buff_d8$1_0.VIN.t13 VSS.t695 sg13_lv_nmos ad=55.5f pd=0.74u as=55.5f ps=0.74u w=0.15u l=0.13u
X2525 6ph_rosc_0.psdiff_2.VOUTDN 6ph_rosc_0.psdiff_2.buff_d8$1_1.inv_d8$1_0.VIN VSS.t795 VSS.t794 sg13_lv_nmos ad=55.5f pd=0.74u as=0.1005p ps=1.34u w=0.15u l=0.13u
X2526 6to4_0.buff_PI_d32_3.buff_PI_d16$1_0.inv_PI_d4$1_0.VOUT.t0 6to4_0.buff_PI_d32_3.buff_PI_d16$1_0.inv_PI_d4$1_0.VIN VSS.t137 VSS.t136 sg13_lv_nmos ad=55.5f pd=0.74u as=0.1005p ps=1.34u w=0.15u l=0.13u
X2527 VDD.t6 6to4_0.flywheel_clk_0.PH0 6to4_0.buff_PI_d32_0.buff_PI_d16$1_0.inv_PI_d4$1_0.VIN VDD.t5 sg13_lv_pmos ad=55.5f pd=0.74u as=0.1005p ps=1.34u w=0.15u l=0.13u
X2528 VDD.t680 6to4_0.buff_PI_d32_3.inv_PI_d32_0.VIN PH180.t36 VDD.t679 sg13_lv_pmos ad=0.1005p pd=1.34u as=55.5f ps=0.74u w=0.15u l=0.13u
X2529 6ph_rosc_0.psdiff_1.buff_d8$1_0.VIN.t26 a_7973_2194# VDD.t303 VDD.t301 sg13_lv_pmos ad=55.5f pd=0.74u as=55.5f ps=0.74u w=0.15u l=0.13u
X2530 VSS.t534 6to4_0.buff_PI_d32_0.inv_PI_d32_0.VIN PH90.t4 VSS.t533 sg13_lv_nmos ad=0.1005p pd=1.34u as=55.5f ps=0.74u w=0.15u l=0.13u
X2531 VDD.t442 6ph_rosc_0.buff_d8$1_0.inv_d8$1_0.VIN 6ph_rosc_0.PH2.t5 VDD.t80 sg13_lv_pmos ad=0.1005p pd=1.34u as=55.5f ps=0.74u w=0.15u l=0.13u
X2532 VDD.t118 6ph_rosc_0.buff_d8$1_2.inv_d2$1_0.VIN 6ph_rosc_0.buff_d8$1_2.inv_d4$1_0.VIN VDD.t80 sg13_lv_pmos ad=0.1005p pd=1.34u as=55.5f ps=0.74u w=0.15u l=0.13u
X2533 VSS.t686 6ph_rosc_0.buff_d8$1_4.inv_d4$1_0.VIN 6ph_rosc_0.buff_d8$1_4.inv_d8$1_0.VIN VSS.t685 sg13_lv_nmos ad=0.1005p pd=1.34u as=55.5f ps=0.74u w=0.15u l=0.13u
X2534 CTRL 6ph_rosc_0.PH5.t12 CTRL VDD.t85 sg13_lv_pmos ad=0.19p pd=1.38u as=0 ps=0 w=1u l=0.13u
X2535 VSS.t722 6ph_rosc_0.psdiff_2.CLKP.t8 6ph_rosc_0.psdiff_2.buff_d8$1_1.VIN.t0 VSS.t1683 sg13_lv_nmos ad=55.5f pd=0.74u as=55.5f ps=0.74u w=0.15u l=0.13u
X2536 VDD.t553 6to4_0.buff_PI_d32_1.inv_PI_d32_0.VIN PH0.t36 VDD.t552 sg13_lv_pmos ad=55.5f pd=0.74u as=0.1005p ps=1.34u w=0.15u l=0.13u
X2537 6to4_0.buff_PI_d32_1.inv_PI_d16$1_0.VIN 6to4_0.buff_PI_d32_1.buff_PI_d16$1_0.inv_PI_d8$1_0.VOUT.t34 VSS.t1725 VSS.t1724 sg13_lv_nmos ad=55.5f pd=0.74u as=0.1005p ps=1.34u w=0.15u l=0.13u
X2538 VDD.t840 6to4_0.buff_PI_d32_0.buff_PI_d16$1_0.inv_PI_d4$1_0.VOUT.t14 6to4_0.buff_PI_d32_0.buff_PI_d16$1_0.inv_PI_d8$1_0.VOUT.t7 VDD.t341 sg13_lv_pmos ad=0.1005p pd=1.34u as=55.5f ps=0.74u w=0.15u l=0.13u
X2539 PH90.t36 6to4_0.buff_PI_d32_0.inv_PI_d32_0.VIN VDD.t348 VDD.t347 sg13_lv_pmos ad=55.5f pd=0.74u as=0.1005p ps=1.34u w=0.15u l=0.13u
X2540 VDD.t947 6to4_0.buff_PI_d32_0.inv_PI_d16$1_0.VIN.t57 6to4_0.buff_PI_d32_0.inv_PI_d32_0.VIN VDD.t5 sg13_lv_pmos ad=55.5f pd=0.74u as=0.1005p ps=1.34u w=0.15u l=0.13u
X2541 VSS.t694 6ph_rosc_0.psdiff_2.CLKN 6ph_rosc_0.psdiff_2.buff_d8$1_0.VIN.t12 VSS.t693 sg13_lv_nmos ad=55.5f pd=0.74u as=55.5f ps=0.74u w=0.15u l=0.13u
X2542 6ph_rosc_0.psdiff_1.buff_d8$1_0.inv_d8$1_0.VIN 6ph_rosc_0.psdiff_1.buff_d8$1_0.inv_d4$1_0.VIN VSS.t101 VSS.t100 sg13_lv_nmos ad=55.5f pd=0.74u as=0.1005p ps=1.34u w=0.15u l=0.13u
X2543 6ph_rosc_0.psdiff_0.buff_d8$1_0.VIN.t0 VSS.t1965 VDD.t1304 VDD.t503 sg13_lv_pmos ad=55.5f pd=0.74u as=55.5f ps=0.74u w=0.15u l=0.13u
X2544 VSS.t432 6to4_0.buff_PI_d32_2.inv_PI_d32_0.VIN.t73 PH270.t3 VSS.t431 sg13_lv_nmos ad=0.1005p pd=1.34u as=55.5f ps=0.74u w=0.15u l=0.13u
X2545 VDD.t346 6to4_0.buff_PI_d32_0.inv_PI_d32_0.VIN PH90.t35 VDD.t341 sg13_lv_pmos ad=0.1005p pd=1.34u as=55.5f ps=0.74u w=0.15u l=0.13u
X2546 VDD.t551 6to4_0.buff_PI_d32_1.inv_PI_d32_0.VIN PH0.t35 VDD.t173 sg13_lv_pmos ad=55.5f pd=0.74u as=55.5f ps=0.74u w=0.15u l=0.13u
X2547 6to4_0.inv_PI_d2$1_1.VIN 6ph_rosc_0.PH0.t12 VDD.t826 VDD.t17 sg13_lv_pmos ad=55.5f pd=0.74u as=55.5f ps=0.74u w=0.15u l=0.13u
X2548 6to4_0.buff_PI_d32_2.inv_PI_d16$1_0.VIN.t17 6to4_0.buff_PI_d32_2.buff_PI_d16$1_0.inv_PI_d8$1_0.VOUT.t27 VDD.t785 VDD.t126 sg13_lv_pmos ad=55.5f pd=0.74u as=0.1005p ps=1.34u w=0.15u l=0.13u
X2549 6to4_0.buff_PI_d32_2.inv_PI_d32_0.VIN.t22 6to4_0.buff_PI_d32_2.inv_PI_d16$1_0.VIN.t55 VDD.t989 VDD.t198 sg13_lv_pmos ad=0.1005p pd=1.34u as=55.5f ps=0.74u w=0.15u l=0.13u
X2550 6to4_0.buff_PI_d32_1.inv_PI_d16$1_0.VIN 6to4_0.buff_PI_d32_1.buff_PI_d16$1_0.inv_PI_d8$1_0.VOUT.t28 VDD.t1151 VDD.t173 sg13_lv_pmos ad=55.5f pd=0.74u as=0.1005p ps=1.34u w=0.15u l=0.13u
X2551 VDD.t1346 VSS.t1966 6ph_rosc_0.psdiff_2.buff_d8$1_1.VIN.t16 VDD.t470 sg13_lv_pmos ad=55.5f pd=0.74u as=55.5f ps=0.74u w=0.15u l=0.13u
X2552 PH0.t3 6to4_0.buff_PI_d32_1.inv_PI_d32_0.VIN VSS.t853 VSS.t852 sg13_lv_nmos ad=55.5f pd=0.74u as=0.1005p ps=1.34u w=0.15u l=0.13u
X2553 VSS.t532 6to4_0.buff_PI_d32_0.inv_PI_d32_0.VIN PH90.t3 VSS.t531 sg13_lv_nmos ad=0.1005p pd=1.34u as=55.5f ps=0.74u w=0.15u l=0.13u
X2554 VSS.t320 6to4_0.buff_PI_d32_1.buff_PI_d16$1_0.inv_PI_d4$1_0.VOUT.t17 6to4_0.buff_PI_d32_1.buff_PI_d16$1_0.inv_PI_d8$1_0.VOUT.t17 VSS.t319 sg13_lv_nmos ad=0.1005p pd=1.34u as=55.5f ps=0.74u w=0.15u l=0.13u
X2555 VSS.t1007 6to4_0.buff_PI_d32_3.inv_PI_d32_0.VIN PH180.t0 VSS.t1006 sg13_lv_nmos ad=0.1005p pd=1.34u as=55.5f ps=0.74u w=0.15u l=0.13u
X2556 6to4_0.buff_PI_d32_2.inv_PI_d16$1_0.VIN.t3 6to4_0.buff_PI_d32_2.buff_PI_d16$1_0.inv_PI_d8$1_0.VOUT.t29 VSS.t1198 VSS.t1197 sg13_lv_nmos ad=55.5f pd=0.74u as=0.1005p ps=1.34u w=0.15u l=0.13u
X2557 PH270.t34 6to4_0.buff_PI_d32_2.inv_PI_d32_0.VIN.t70 VDD.t267 VDD.t126 sg13_lv_pmos ad=55.5f pd=0.74u as=0.1005p ps=1.34u w=0.15u l=0.13u
X2558 CTRL 6ph_rosc_0.PH5.t12 CTRL VDD.t89 sg13_lv_pmos ad=0.19p pd=1.38u as=0 ps=0 w=1u l=0.13u
X2559 6to4_0.buff_PI_d32_3.buff_PI_d16$1_0.inv_PI_d8$1_0.VOUT.t8 6to4_0.buff_PI_d32_3.buff_PI_d16$1_0.inv_PI_d4$1_0.VOUT.t13 VDD.t1031 VDD.t679 sg13_lv_pmos ad=0.1005p pd=1.34u as=55.5f ps=0.74u w=0.15u l=0.13u
X2560 VDD.t1061 6to4_0.buff_PI_d32_2.buff_PI_d16$1_0.inv_PI_d4$1_0.VOUT.t19 6to4_0.buff_PI_d32_2.buff_PI_d16$1_0.inv_PI_d8$1_0.VOUT.t8 VDD.t198 sg13_lv_pmos ad=55.5f pd=0.74u as=55.5f ps=0.74u w=0.15u l=0.13u
X2561 VDD.t1345 VSS.t1966 6ph_rosc_0.psdiff_2.buff_d8$1_0.VIN.t0 VDD.t470 sg13_lv_pmos ad=55.5f pd=0.74u as=55.5f ps=0.74u w=0.15u l=0.13u
X2562 6to4_0.buff_PI_d32_1.inv_PI_d32_0.VIN 6to4_0.buff_PI_d32_1.inv_PI_d16$1_0.VIN VDD.t1255 VDD.t17 sg13_lv_pmos ad=55.5f pd=0.74u as=55.5f ps=0.74u w=0.15u l=0.13u
X2563 VDD.t663 6to4_0.buff_PI_d32_2.VIN 6to4_0.buff_PI_d32_2.buff_PI_d16$1_0.inv_PI_d4$1_0.VIN VDD.t126 sg13_lv_pmos ad=0.1005p pd=1.34u as=55.5f ps=0.74u w=0.15u l=0.13u
X2564 VSS.t1498 6to4_0.buff_PI_d32_2.inv_PI_d16$1_0.VIN.t63 6to4_0.buff_PI_d32_2.inv_PI_d32_0.VIN.t45 VSS.t1497 sg13_lv_nmos ad=0.1005p pd=1.34u as=55.5f ps=0.74u w=0.15u l=0.13u
X2565 6ph_rosc_0.psdiff_0.buff_d8$1_1.VIN.t12 a_12104_2338# VDD.t504 VDD.t503 sg13_lv_pmos ad=55.5f pd=0.74u as=55.5f ps=0.74u w=0.15u l=0.13u
X2566 6to4_0.buff_PI_d32_0.inv_PI_d16$1_0.VIN.t45 6to4_0.buff_PI_d32_0.buff_PI_d16$1_0.inv_PI_d8$1_0.VOUT.t39 VSS.t1654 VSS.t1653 sg13_lv_nmos ad=55.5f pd=0.74u as=0.1005p ps=1.34u w=0.15u l=0.13u
X2567 PH90.t2 6to4_0.buff_PI_d32_0.inv_PI_d32_0.VIN VSS.t530 VSS.t529 sg13_lv_nmos ad=55.5f pd=0.74u as=0.1005p ps=1.34u w=0.15u l=0.13u
X2568 CTRL 6ph_rosc_0.PH4.t10 CTRL VDD.t451 sg13_lv_pmos ad=0.19p pd=1.38u as=0 ps=0 w=1u l=0.13u
X2569 VSS.t1933 6ph_rosc_0.psdiff_1.VOUTDN 6ph_rosc_0.psdiff_0.buff_d8$1_1.VIN.t19 VSS.t1932 sg13_lv_nmos ad=55.5f pd=0.74u as=55.5f ps=0.74u w=0.15u l=0.13u
X2570 VDD.t1343 VSS.t1966 6ph_rosc_0.psdiff_2.buff_d8$1_1.VIN.t15 VDD.t470 sg13_lv_pmos ad=55.5f pd=0.74u as=55.5f ps=0.74u w=0.15u l=0.13u
X2571 PH90.t34 6to4_0.buff_PI_d32_0.inv_PI_d32_0.VIN VDD.t345 VDD.t5 sg13_lv_pmos ad=0.1005p pd=1.34u as=55.5f ps=0.74u w=0.15u l=0.13u
X2572 PH0.t34 6to4_0.buff_PI_d32_1.inv_PI_d32_0.VIN VDD.t550 VDD.t17 sg13_lv_pmos ad=55.5f pd=0.74u as=55.5f ps=0.74u w=0.15u l=0.13u
X2573 VDD.t177 6to4_0.buff_PI_d32_1.buff_PI_d16$1_0.inv_PI_d4$1_0.VOUT.t13 6to4_0.buff_PI_d32_1.buff_PI_d16$1_0.inv_PI_d8$1_0.VOUT.t3 VDD.t173 sg13_lv_pmos ad=0.1005p pd=1.34u as=55.5f ps=0.74u w=0.15u l=0.13u
X2574 CTRL 6ph_rosc_0.PH4.t10 CTRL VDD.t78 sg13_lv_pmos ad=0.19p pd=1.38u as=0 ps=0 w=1u l=0.13u
X2575 6to4_0.buff_PI_d32_0.inv_PI_d32_0.VIN 6to4_0.buff_PI_d32_0.inv_PI_d16$1_0.VIN.t52 VDD.t932 VDD.t5 sg13_lv_pmos ad=55.5f pd=0.74u as=0.1005p ps=1.34u w=0.15u l=0.13u
X2576 VSS.t1931 6ph_rosc_0.psdiff_1.VOUTDN 6ph_rosc_0.psdiff_0.buff_d8$1_1.VIN.t18 VSS.t1930 sg13_lv_nmos ad=55.5f pd=0.74u as=55.5f ps=0.74u w=0.15u l=0.13u
X2577 PH180.t35 6to4_0.buff_PI_d32_3.inv_PI_d32_0.VIN VDD.t678 VDD.t677 sg13_lv_pmos ad=55.5f pd=0.74u as=55.5f ps=0.74u w=0.15u l=0.13u
X2578 VDD.t549 6to4_0.buff_PI_d32_1.inv_PI_d32_0.VIN PH0.t33 VDD.t173 sg13_lv_pmos ad=55.5f pd=0.74u as=0.1005p ps=1.34u w=0.15u l=0.13u
X2579 CTRL 6ph_rosc_0.PH3.t11 CTRL VDD.t57 sg13_lv_pmos ad=0.19p pd=1.38u as=0 ps=0 w=1u l=0.13u
X2580 VDD.t821 6to4_0.buff_PI_d32_2.buff_PI_d16$1_0.inv_PI_d8$1_0.VOUT.t39 6to4_0.buff_PI_d32_2.inv_PI_d16$1_0.VIN.t16 VDD.t126 sg13_lv_pmos ad=55.5f pd=0.74u as=0.1005p ps=1.34u w=0.15u l=0.13u
X2581 VDD.t312 6ph_rosc_0.buff_d8$1_1.inv_d4$1_0.VIN 6ph_rosc_0.buff_d8$1_1.inv_d8$1_0.VIN VDD.t75 sg13_lv_pmos ad=0.1005p pd=1.34u as=55.5f ps=0.74u w=0.15u l=0.13u
X2582 VDD.t1150 6to4_0.buff_PI_d32_1.buff_PI_d16$1_0.inv_PI_d8$1_0.VOUT.t24 6to4_0.buff_PI_d32_1.inv_PI_d16$1_0.VIN VDD.t173 sg13_lv_pmos ad=55.5f pd=0.74u as=0.1005p ps=1.34u w=0.15u l=0.13u
X2583 VSS.t109 6ph_rosc_0.buff_d8$1_3.inv_d2$1_0.VIN 6ph_rosc_0.buff_d8$1_3.inv_d4$1_0.VIN VSS.t108 sg13_lv_nmos ad=0.1005p pd=1.34u as=55.5f ps=0.74u w=0.15u l=0.13u
X2584 PH180.t34 6to4_0.buff_PI_d32_3.inv_PI_d32_0.VIN VDD.t676 VDD.t99 sg13_lv_pmos ad=0.1005p pd=1.34u as=55.5f ps=0.74u w=0.15u l=0.13u
X2585 VDD.t344 6to4_0.buff_PI_d32_0.inv_PI_d32_0.VIN PH90.t33 VDD.t343 sg13_lv_pmos ad=55.5f pd=0.74u as=0.1005p ps=1.34u w=0.15u l=0.13u
X2586 PH0.t2 6to4_0.buff_PI_d32_1.inv_PI_d32_0.VIN VSS.t851 VSS.t850 sg13_lv_nmos ad=55.5f pd=0.74u as=0.1005p ps=1.34u w=0.15u l=0.13u
X2587 VSS.t408 6to4_0.buff_PI_d32_2.inv_PI_d32_0.VIN.t67 PH270.t2 VSS.t407 sg13_lv_nmos ad=0.1005p pd=1.34u as=55.5f ps=0.74u w=0.15u l=0.13u
X2588 VDD.t675 6to4_0.buff_PI_d32_3.inv_PI_d32_0.VIN PH180.t33 VDD.t99 sg13_lv_pmos ad=0.1005p pd=1.34u as=55.5f ps=0.74u w=0.15u l=0.13u
X2589 PH0.t1 6to4_0.buff_PI_d32_1.inv_PI_d32_0.VIN VSS.t849 VSS.t848 sg13_lv_nmos ad=55.5f pd=0.74u as=0.1005p ps=1.34u w=0.15u l=0.13u
X2590 VDD.t962 6to4_0.buff_PI_d32_0.inv_PI_d16$1_0.VIN.t62 6to4_0.buff_PI_d32_0.inv_PI_d32_0.VIN VDD.t5 sg13_lv_pmos ad=0.1005p pd=1.34u as=55.5f ps=0.74u w=0.15u l=0.13u
X2591 VSS.t1230 6to4_0.buff_PI_d32_2.buff_PI_d16$1_0.inv_PI_d8$1_0.VOUT.t37 6to4_0.buff_PI_d32_2.inv_PI_d16$1_0.VIN.t2 VSS.t1229 sg13_lv_nmos ad=0.1005p pd=1.34u as=55.5f ps=0.74u w=0.15u l=0.13u
X2592 CTRL 6ph_rosc_0.PH5.t12 CTRL VDD.t87 sg13_lv_pmos ad=0.19p pd=1.38u as=0 ps=0 w=1u l=0.13u
X2593 6to4_0.buff_PI_d32_3.inv_PI_d16$1_0.VIN.t16 6to4_0.buff_PI_d32_3.buff_PI_d16$1_0.inv_PI_d8$1_0.VOUT.t29 VDD.t1213 VDD.t679 sg13_lv_pmos ad=0.1005p pd=1.34u as=55.5f ps=0.74u w=0.15u l=0.13u
X2594 VDD.t1254 6to4_0.buff_PI_d32_1.inv_PI_d16$1_0.VIN 6to4_0.buff_PI_d32_1.inv_PI_d32_0.VIN VDD.t17 sg13_lv_pmos ad=55.5f pd=0.74u as=55.5f ps=0.74u w=0.15u l=0.13u
X2595 VSS.t528 6to4_0.buff_PI_d32_0.inv_PI_d32_0.VIN PH90.t1 VSS.t527 sg13_lv_nmos ad=0.1005p pd=1.34u as=55.5f ps=0.74u w=0.15u l=0.13u
X2596 VSS.t1626 6to4_0.buff_PI_d32_0.buff_PI_d16$1_0.inv_PI_d8$1_0.VOUT.t32 6to4_0.buff_PI_d32_0.inv_PI_d16$1_0.VIN.t24 VSS.t1625 sg13_lv_nmos ad=0.1005p pd=1.34u as=55.5f ps=0.74u w=0.15u l=0.13u
X2597 VDD.t1384 VSS.t1967 6ph_rosc_0.psdiff_1.buff_d8$1_0.VIN.t16 VDD.t301 sg13_lv_pmos ad=55.5f pd=0.74u as=55.5f ps=0.74u w=0.15u l=0.13u
X2598 6to4_0.buff_PI_d32_2.inv_PI_d16$1_0.VIN.t1 6to4_0.buff_PI_d32_2.buff_PI_d16$1_0.inv_PI_d8$1_0.VOUT.t30 VSS.t1202 VSS.t1201 sg13_lv_nmos ad=55.5f pd=0.74u as=0.1005p ps=1.34u w=0.15u l=0.13u
X2599 VSS.t424 6to4_0.buff_PI_d32_2.inv_PI_d32_0.VIN.t71 PH270.t1 VSS.t423 sg13_lv_nmos ad=0.1005p pd=1.34u as=55.5f ps=0.74u w=0.15u l=0.13u
X2600 6to4_0.buff_PI_d32_2.inv_PI_d32_0.VIN.t34 6to4_0.buff_PI_d32_2.inv_PI_d16$1_0.VIN.t59 VDD.t1001 VDD.t198 sg13_lv_pmos ad=55.5f pd=0.74u as=55.5f ps=0.74u w=0.15u l=0.13u
X2601 CTRL 6ph_rosc_0.PH5.t12 CTRL VDD.t85 sg13_lv_pmos ad=0.19p pd=1.38u as=0 ps=0 w=1u l=0.13u
X2602 VDD.t1383 VSS.t1967 6ph_rosc_0.psdiff_1.buff_d8$1_0.VIN.t15 VDD.t301 sg13_lv_pmos ad=55.5f pd=0.74u as=55.5f ps=0.74u w=0.15u l=0.13u
X2603 PH0.t32 6to4_0.buff_PI_d32_1.inv_PI_d32_0.VIN VDD.t548 VDD.t547 sg13_lv_pmos ad=55.5f pd=0.74u as=0.1005p ps=1.34u w=0.15u l=0.13u
X2604 VSS.t526 6to4_0.buff_PI_d32_0.inv_PI_d32_0.VIN PH90.t0 VSS.t525 sg13_lv_nmos ad=0.1005p pd=1.34u as=55.5f ps=0.74u w=0.15u l=0.13u
X2605 VDD.t481 6ph_rosc_0.buff_d8$1_4.inv_d8$1_0.VIN 6ph_rosc_0.PH3.t6 VDD.t75 sg13_lv_pmos ad=0.1005p pd=1.34u as=55.5f ps=0.74u w=0.15u l=0.13u
X2606 VDD.t463 6ph_rosc_0.buff_d8$1_5.inv_d4$1_0.VIN 6ph_rosc_0.buff_d8$1_5.inv_d8$1_0.VIN VDD.t330 sg13_lv_pmos ad=0.1005p pd=1.34u as=55.5f ps=0.74u w=0.15u l=0.13u
X2607 CTRL 6ph_rosc_0.PH4.t10 CTRL VDD.t451 sg13_lv_pmos ad=0.19p pd=1.38u as=0 ps=0 w=1u l=0.13u
X2608 6ph_rosc_0.psdiff_0.buff_d8$1_1.VIN.t17 6ph_rosc_0.psdiff_1.VOUTDN VSS.t1929 VSS.t1928 sg13_lv_nmos ad=55.5f pd=0.74u as=55.5f ps=0.74u w=0.15u l=0.13u
X2609 VDD.t101 6to4_0.buff_PI_d32_3.buff_PI_d16$1_0.inv_PI_d4$1_0.VIN 6to4_0.buff_PI_d32_3.buff_PI_d16$1_0.inv_PI_d4$1_0.VOUT.t5 VDD.t99 sg13_lv_pmos ad=0.1005p pd=1.34u as=55.5f ps=0.74u w=0.15u l=0.13u
X2610 VDD.t537 a_9130_2338# 6ph_rosc_0.psdiff_1.buff_d8$1_1.VIN.t13 VDD.t301 sg13_lv_pmos ad=55.5f pd=0.74u as=55.5f ps=0.74u w=0.15u l=0.13u
X2611 6to4_0.buff_PI_d32_3.buff_PI_d16$1_0.inv_PI_d4$1_0.VOUT.t4 6to4_0.buff_PI_d32_3.buff_PI_d16$1_0.inv_PI_d4$1_0.VIN VDD.t100 VDD.t99 sg13_lv_pmos ad=0.1005p pd=1.34u as=55.5f ps=0.74u w=0.15u l=0.13u
X2612 6to4_0.buff_PI_d32_0.inv_PI_d32_0.VIN 6to4_0.buff_PI_d32_0.inv_PI_d16$1_0.VIN.t54 VDD.t938 VDD.t341 sg13_lv_pmos ad=55.5f pd=0.74u as=55.5f ps=0.74u w=0.15u l=0.13u
X2613 PH270.t33 6to4_0.buff_PI_d32_2.inv_PI_d32_0.VIN.t77 VDD.t288 VDD.t215 sg13_lv_pmos ad=0.1005p pd=1.34u as=55.5f ps=0.74u w=0.15u l=0.13u
X2614 VDD.t1072 6ph_rosc_0.psdiff_0.buff_d8$1_0.inv_d8$1_0.VIN 6ph_rosc_0.psdiff_2.CLKN VDD.t34 sg13_lv_pmos ad=0.1005p pd=1.34u as=55.5f ps=0.74u w=0.15u l=0.13u
X2615 6ph_rosc_0.psdiff_2.VOUTDN 6ph_rosc_0.psdiff_2.buff_d8$1_1.inv_d8$1_0.VIN VSS.t793 VSS.t792 sg13_lv_nmos ad=55.5f pd=0.74u as=0.1005p ps=1.34u w=0.15u l=0.13u
X2616 VDD.t1303 VSS.t1965 6ph_rosc_0.psdiff_0.buff_d8$1_1.VIN.t0 VDD.t503 sg13_lv_pmos ad=55.5f pd=0.74u as=55.5f ps=0.74u w=0.15u l=0.13u
X2617 PH90.t32 6to4_0.buff_PI_d32_0.inv_PI_d32_0.VIN VDD.t342 VDD.t341 sg13_lv_pmos ad=55.5f pd=0.74u as=55.5f ps=0.74u w=0.15u l=0.13u
X2618 VSS.t1178 6to4_0.buff_PI_d32_2.buff_PI_d16$1_0.inv_PI_d8$1_0.VOUT.t24 6to4_0.buff_PI_d32_2.inv_PI_d16$1_0.VIN.t0 VSS.t1177 sg13_lv_nmos ad=0.1005p pd=1.34u as=55.5f ps=0.74u w=0.15u l=0.13u
X2619 CTRL 6ph_rosc_0.PH5.t12 CTRL VDD.t89 sg13_lv_pmos ad=0.19p pd=1.38u as=0 ps=0 w=1u l=0.13u
X2620 VSS.t1414 6to4_0.buff_PI_d32_0.inv_PI_d16$1_0.VIN.t58 6to4_0.buff_PI_d32_0.inv_PI_d32_0.VIN VSS.t1413 sg13_lv_nmos ad=0.1005p pd=1.34u as=55.5f ps=0.74u w=0.15u l=0.13u
X2621 VDD.t536 a_9130_2338# 6ph_rosc_0.psdiff_1.buff_d8$1_1.VIN.t12 VDD.t301 sg13_lv_pmos ad=55.5f pd=0.74u as=55.5f ps=0.74u w=0.15u l=0.13u
X2622 VDD.t441 6ph_rosc_0.buff_d8$1_0.inv_d8$1_0.VIN 6ph_rosc_0.PH2.t4 VDD.t440 sg13_lv_pmos ad=0.1005p pd=1.34u as=55.5f ps=0.74u w=0.15u l=0.13u
X2623 VSS.t847 6to4_0.buff_PI_d32_1.inv_PI_d32_0.VIN PH0.t0 VSS.t846 sg13_lv_nmos ad=0.1005p pd=1.34u as=55.5f ps=0.74u w=0.15u l=0.13u
X2624 6ph_rosc_0.psdiff_1.buff_d8$1_1.VIN.t17 6ph_rosc_0.psdiff_2.VOUTDN VSS.t1135 VSS.t1134 sg13_lv_nmos ad=55.5f pd=0.74u as=55.5f ps=0.74u w=0.15u l=0.13u
X2625 PH270.t0 6to4_0.buff_PI_d32_2.inv_PI_d32_0.VIN.t58 VSS.t372 VSS.t371 sg13_lv_nmos ad=55.5f pd=0.74u as=0.1005p ps=1.34u w=0.15u l=0.13u
X2626 CTRL 6ph_rosc_0.PH4.t10 CTRL VDD.t451 sg13_lv_pmos ad=0.19p pd=1.38u as=0 ps=0 w=1u l=0.13u
X2627 VDD.t294 6to4_0.buff_PI_d32_2.inv_PI_d32_0.VIN.t79 PH270.t32 VDD.t198 sg13_lv_pmos ad=55.5f pd=0.74u as=55.5f ps=0.74u w=0.15u l=0.13u
X2628 PH180.t32 6to4_0.buff_PI_d32_3.inv_PI_d32_0.VIN VDD.t674 VDD.t673 sg13_lv_pmos ad=0.1005p pd=1.34u as=55.5f ps=0.74u w=0.15u l=0.13u
X2629 VDD.t1113 6to4_0.buff_PI_d32_0.buff_PI_d16$1_0.inv_PI_d8$1_0.VOUT.t35 6to4_0.buff_PI_d32_0.inv_PI_d16$1_0.VIN.t34 VDD.t5 sg13_lv_pmos ad=55.5f pd=0.74u as=55.5f ps=0.74u w=0.15u l=0.13u
X2630 6ph_rosc_0.psdiff_1.buff_d8$1_0.VIN.t25 a_7973_2194# VDD.t302 VDD.t301 sg13_lv_pmos ad=55.5f pd=0.74u as=0.1005p ps=1.34u w=0.15u l=0.13u
X2631 VSS.t1358 6to4_0.buff_PI_d32_3.inv_PI_d16$1_0.VIN.t63 6to4_0.buff_PI_d32_3.inv_PI_d32_0.VIN VSS.t1357 sg13_lv_nmos ad=0.1005p pd=1.34u as=55.5f ps=0.74u w=0.15u l=0.13u
R0 6to4_0.buff_PI_d32_1.buff_PI_d16$1_0.inv_PI_d8$1_0.VOUT.n35 6to4_0.buff_PI_d32_1.buff_PI_d16$1_0.inv_PI_d8$1_0.VOUT.t11 17.6089
R1 6to4_0.buff_PI_d32_1.buff_PI_d16$1_0.inv_PI_d8$1_0.VOUT.n38 6to4_0.buff_PI_d32_1.buff_PI_d16$1_0.inv_PI_d8$1_0.VOUT.t14 17.6089
R2 6to4_0.buff_PI_d32_1.buff_PI_d16$1_0.inv_PI_d8$1_0.VOUT.n41 6to4_0.buff_PI_d32_1.buff_PI_d16$1_0.inv_PI_d8$1_0.VOUT.t8 17.6089
R3 6to4_0.buff_PI_d32_1.buff_PI_d16$1_0.inv_PI_d8$1_0.VOUT.n44 6to4_0.buff_PI_d32_1.buff_PI_d16$1_0.inv_PI_d8$1_0.VOUT.t20 17.6089
R4 6to4_0.buff_PI_d32_1.buff_PI_d16$1_0.inv_PI_d8$1_0.VOUT.n47 6to4_0.buff_PI_d32_1.buff_PI_d16$1_0.inv_PI_d8$1_0.VOUT.t17 17.6089
R5 6to4_0.buff_PI_d32_1.buff_PI_d16$1_0.inv_PI_d8$1_0.VOUT.n50 6to4_0.buff_PI_d32_1.buff_PI_d16$1_0.inv_PI_d8$1_0.VOUT.t23 17.6089
R6 6to4_0.buff_PI_d32_1.buff_PI_d16$1_0.inv_PI_d8$1_0.VOUT.n53 6to4_0.buff_PI_d32_1.buff_PI_d16$1_0.inv_PI_d8$1_0.VOUT.t2 17.6089
R7 6to4_0.buff_PI_d32_1.buff_PI_d16$1_0.inv_PI_d8$1_0.VOUT.n56 6to4_0.buff_PI_d32_1.buff_PI_d16$1_0.inv_PI_d8$1_0.VOUT.t5 17.6089
R8 6to4_0.buff_PI_d32_1.buff_PI_d16$1_0.inv_PI_d8$1_0.inv_PI_d4$1_1.inv_PI_d2$1_1.inv_PI$1_1.VOUT 6to4_0.buff_PI_d32_1.buff_PI_d16$1_0.inv_PI_d8$1_0.VOUT.t9 17.5436
R9 6to4_0.buff_PI_d32_1.buff_PI_d16$1_0.inv_PI_d8$1_0.VOUT.n34 6to4_0.buff_PI_d32_1.buff_PI_d16$1_0.inv_PI_d8$1_0.VOUT.t3 17.2136
R10 6to4_0.buff_PI_d32_1.buff_PI_d16$1_0.inv_PI_d8$1_0.VOUT.n55 6to4_0.buff_PI_d32_1.buff_PI_d16$1_0.inv_PI_d8$1_0.VOUT.t4 17.2136
R11 6to4_0.buff_PI_d32_1.buff_PI_d16$1_0.inv_PI_d8$1_0.VOUT.n54 6to4_0.buff_PI_d32_1.buff_PI_d16$1_0.inv_PI_d8$1_0.VOUT.t1 17.2136
R12 6to4_0.buff_PI_d32_1.buff_PI_d16$1_0.inv_PI_d8$1_0.VOUT.n51 6to4_0.buff_PI_d32_1.buff_PI_d16$1_0.inv_PI_d8$1_0.VOUT.t21 17.2136
R13 6to4_0.buff_PI_d32_1.buff_PI_d16$1_0.inv_PI_d8$1_0.VOUT.n49 6to4_0.buff_PI_d32_1.buff_PI_d16$1_0.inv_PI_d8$1_0.VOUT.t22 17.2136
R14 6to4_0.buff_PI_d32_1.buff_PI_d16$1_0.inv_PI_d8$1_0.VOUT.n48 6to4_0.buff_PI_d32_1.buff_PI_d16$1_0.inv_PI_d8$1_0.VOUT.t15 17.2136
R15 6to4_0.buff_PI_d32_1.buff_PI_d16$1_0.inv_PI_d8$1_0.VOUT.n46 6to4_0.buff_PI_d32_1.buff_PI_d16$1_0.inv_PI_d8$1_0.VOUT.t16 17.2136
R16 6to4_0.buff_PI_d32_1.buff_PI_d16$1_0.inv_PI_d8$1_0.VOUT.n45 6to4_0.buff_PI_d32_1.buff_PI_d16$1_0.inv_PI_d8$1_0.VOUT.t18 17.2136
R17 6to4_0.buff_PI_d32_1.buff_PI_d16$1_0.inv_PI_d8$1_0.VOUT.n43 6to4_0.buff_PI_d32_1.buff_PI_d16$1_0.inv_PI_d8$1_0.VOUT.t19 17.2136
R18 6to4_0.buff_PI_d32_1.buff_PI_d16$1_0.inv_PI_d8$1_0.VOUT.n42 6to4_0.buff_PI_d32_1.buff_PI_d16$1_0.inv_PI_d8$1_0.VOUT.t7 17.2136
R19 6to4_0.buff_PI_d32_1.buff_PI_d16$1_0.inv_PI_d8$1_0.VOUT.n40 6to4_0.buff_PI_d32_1.buff_PI_d16$1_0.inv_PI_d8$1_0.VOUT.t6 17.2136
R20 6to4_0.buff_PI_d32_1.buff_PI_d16$1_0.inv_PI_d8$1_0.VOUT.n39 6to4_0.buff_PI_d32_1.buff_PI_d16$1_0.inv_PI_d8$1_0.VOUT.t12 17.2136
R21 6to4_0.buff_PI_d32_1.buff_PI_d16$1_0.inv_PI_d8$1_0.VOUT.n37 6to4_0.buff_PI_d32_1.buff_PI_d16$1_0.inv_PI_d8$1_0.VOUT.t13 17.2136
R22 6to4_0.buff_PI_d32_1.buff_PI_d16$1_0.inv_PI_d8$1_0.VOUT.n36 6to4_0.buff_PI_d32_1.buff_PI_d16$1_0.inv_PI_d8$1_0.VOUT.t10 17.2136
R23 6to4_0.buff_PI_d32_1.buff_PI_d16$1_0.inv_PI_d8$1_0.VOUT.n52 6to4_0.buff_PI_d32_1.buff_PI_d16$1_0.inv_PI_d8$1_0.VOUT.t0 17.2136
R24 6to4_0.buff_PI_d32_1.buff_PI_d16$1_0.inv_PI_d8$1_0.VOUT.n31 6to4_0.buff_PI_d32_1.buff_PI_d16$1_0.inv_PI_d8$1_0.VOUT.t34 15.0005
R25 6to4_0.buff_PI_d32_1.buff_PI_d16$1_0.inv_PI_d8$1_0.VOUT.n27 6to4_0.buff_PI_d32_1.buff_PI_d16$1_0.inv_PI_d8$1_0.VOUT.t31 15.0005
R26 6to4_0.buff_PI_d32_1.buff_PI_d16$1_0.inv_PI_d8$1_0.VOUT.n25 6to4_0.buff_PI_d32_1.buff_PI_d16$1_0.inv_PI_d8$1_0.VOUT.t32 15.0005
R27 6to4_0.buff_PI_d32_1.buff_PI_d16$1_0.inv_PI_d8$1_0.VOUT.n21 6to4_0.buff_PI_d32_1.buff_PI_d16$1_0.inv_PI_d8$1_0.VOUT.t28 15.0005
R28 6to4_0.buff_PI_d32_1.buff_PI_d16$1_0.inv_PI_d8$1_0.VOUT.n19 6to4_0.buff_PI_d32_1.buff_PI_d16$1_0.inv_PI_d8$1_0.VOUT.t24 15.0005
R29 6to4_0.buff_PI_d32_1.buff_PI_d16$1_0.inv_PI_d8$1_0.VOUT.n10 6to4_0.buff_PI_d32_1.buff_PI_d16$1_0.inv_PI_d8$1_0.VOUT.t26 15.0005
R30 6to4_0.buff_PI_d32_1.buff_PI_d16$1_0.inv_PI_d8$1_0.VOUT.n9 6to4_0.buff_PI_d32_1.buff_PI_d16$1_0.inv_PI_d8$1_0.VOUT.t29 15.0005
R31 6to4_0.buff_PI_d32_1.buff_PI_d16$1_0.inv_PI_d8$1_0.VOUT.n15 6to4_0.buff_PI_d32_1.buff_PI_d16$1_0.inv_PI_d8$1_0.VOUT.t30 15.0005
R32 6to4_0.buff_PI_d32_1.buff_PI_d16$1_0.inv_PI_d8$1_0.VOUT.n14 6to4_0.buff_PI_d32_1.buff_PI_d16$1_0.inv_PI_d8$1_0.VOUT.t27 15.0005
R33 6to4_0.buff_PI_d32_1.buff_PI_d16$1_0.inv_PI_d8$1_0.VOUT.n5 6to4_0.buff_PI_d32_1.buff_PI_d16$1_0.inv_PI_d8$1_0.VOUT.t38 15.0005
R34 6to4_0.buff_PI_d32_1.buff_PI_d16$1_0.inv_PI_d8$1_0.VOUT.n12 6to4_0.buff_PI_d32_1.buff_PI_d16$1_0.inv_PI_d8$1_0.VOUT.t35 15.0005
R35 6to4_0.buff_PI_d32_1.buff_PI_d16$1_0.inv_PI_d8$1_0.VOUT.n0 6to4_0.buff_PI_d32_1.buff_PI_d16$1_0.inv_PI_d8$1_0.VOUT.t36 15.0005
R36 6to4_0.buff_PI_d32_1.buff_PI_d16$1_0.inv_PI_d8$1_0.VOUT.n7 6to4_0.buff_PI_d32_1.buff_PI_d16$1_0.inv_PI_d8$1_0.VOUT.t33 15.0005
R37 6to4_0.buff_PI_d32_1.buff_PI_d16$1_0.inv_PI_d8$1_0.VOUT.n2 6to4_0.buff_PI_d32_1.buff_PI_d16$1_0.inv_PI_d8$1_0.VOUT.t25 15.0005
R38 6to4_0.buff_PI_d32_1.buff_PI_d16$1_0.inv_PI_d8$1_0.VOUT.n3 6to4_0.buff_PI_d32_1.buff_PI_d16$1_0.inv_PI_d8$1_0.VOUT.t39 15.0005
R39 6to4_0.buff_PI_d32_1.buff_PI_d16$1_0.inv_PI_d8$1_0.VOUT.n33 6to4_0.buff_PI_d32_1.buff_PI_d16$1_0.inv_PI_d8$1_0.VOUT.t37 15.0005
R40 6to4_0.buff_PI_d32_1.buff_PI_d16$1_0.inv_PI_d8$1_0.VOUT.n11 6to4_0.buff_PI_d32_1.buff_PI_d16$1_0.inv_PI_d8$1_0.VOUT.n9 10.3469
R41 6to4_0.buff_PI_d32_1.buff_PI_d16$1_0.inv_PI_d8$1_0.VOUT.n16 6to4_0.buff_PI_d32_1.buff_PI_d16$1_0.inv_PI_d8$1_0.VOUT.n14 10.3469
R42 6to4_0.buff_PI_d32_1.buff_PI_d16$1_0.inv_PI_d8$1_0.VOUT.n4 6to4_0.buff_PI_d32_1.buff_PI_d16$1_0.inv_PI_d8$1_0.VOUT.n2 10.3469
R43 6to4_0.buff_PI_d32_1.buff_PI_d16$1_0.inv_PI_d8$1_0.VOUT.n33 6to4_0.buff_PI_d32_1.buff_PI_d16$1_0.inv_PI_d8$1_0.VOUT.n32 10.3469
R44 6to4_0.buff_PI_d32_1.buff_PI_d16$1_0.inv_PI_d8$1_0.VOUT.n11 6to4_0.buff_PI_d32_1.buff_PI_d16$1_0.inv_PI_d8$1_0.VOUT.n10 9.0005
R45 6to4_0.buff_PI_d32_1.buff_PI_d16$1_0.inv_PI_d8$1_0.VOUT.n13 6to4_0.buff_PI_d32_1.buff_PI_d16$1_0.inv_PI_d8$1_0.VOUT.n12 9.0005
R46 6to4_0.buff_PI_d32_1.buff_PI_d16$1_0.inv_PI_d8$1_0.VOUT.n6 6to4_0.buff_PI_d32_1.buff_PI_d16$1_0.inv_PI_d8$1_0.VOUT.n5 9.0005
R47 6to4_0.buff_PI_d32_1.buff_PI_d16$1_0.inv_PI_d8$1_0.VOUT.n16 6to4_0.buff_PI_d32_1.buff_PI_d16$1_0.inv_PI_d8$1_0.VOUT.n15 9.0005
R48 6to4_0.buff_PI_d32_1.buff_PI_d16$1_0.inv_PI_d8$1_0.VOUT.n8 6to4_0.buff_PI_d32_1.buff_PI_d16$1_0.inv_PI_d8$1_0.VOUT.n7 9.0005
R49 6to4_0.buff_PI_d32_1.buff_PI_d16$1_0.inv_PI_d8$1_0.VOUT.n1 6to4_0.buff_PI_d32_1.buff_PI_d16$1_0.inv_PI_d8$1_0.VOUT.n0 9.0005
R50 6to4_0.buff_PI_d32_1.buff_PI_d16$1_0.inv_PI_d8$1_0.VOUT.n20 6to4_0.buff_PI_d32_1.buff_PI_d16$1_0.inv_PI_d8$1_0.VOUT.n19 9.0005
R51 6to4_0.buff_PI_d32_1.buff_PI_d16$1_0.inv_PI_d8$1_0.VOUT.n22 6to4_0.buff_PI_d32_1.buff_PI_d16$1_0.inv_PI_d8$1_0.VOUT.n21 9.0005
R52 6to4_0.buff_PI_d32_1.buff_PI_d16$1_0.inv_PI_d8$1_0.VOUT.n4 6to4_0.buff_PI_d32_1.buff_PI_d16$1_0.inv_PI_d8$1_0.VOUT.n3 9.0005
R53 6to4_0.buff_PI_d32_1.buff_PI_d16$1_0.inv_PI_d8$1_0.VOUT.n26 6to4_0.buff_PI_d32_1.buff_PI_d16$1_0.inv_PI_d8$1_0.VOUT.n25 9.0005
R54 6to4_0.buff_PI_d32_1.buff_PI_d16$1_0.inv_PI_d8$1_0.VOUT.n28 6to4_0.buff_PI_d32_1.buff_PI_d16$1_0.inv_PI_d8$1_0.VOUT.n27 9.0005
R55 6to4_0.buff_PI_d32_1.buff_PI_d16$1_0.inv_PI_d8$1_0.VOUT.n32 6to4_0.buff_PI_d32_1.buff_PI_d16$1_0.inv_PI_d8$1_0.VOUT.n31 9.0005
R56 6to4_0.buff_PI_d32_1.buff_PI_d16$1_0.inv_PI_d8$1_0.VOUT.n34 6to4_0.buff_PI_d32_1.buff_PI_d16$1_0.inv_PI_d16$1_0.inv_PI_d8$1_1.inv_PI_d4$1_1.inv_PI_d2$1_1.inv_PI$1_1.VIN 1.53363
R57 6to4_0.buff_PI_d32_1.buff_PI_d16$1_0.inv_PI_d8$1_0.VOUT.n52 6to4_0.buff_PI_d32_1.buff_PI_d16$1_0.inv_PI_d8$1_0.VOUT.n51 1.41675
R58 6to4_0.buff_PI_d32_1.buff_PI_d16$1_0.inv_PI_d8$1_0.VOUT.n46 6to4_0.buff_PI_d32_1.buff_PI_d16$1_0.inv_PI_d8$1_0.VOUT.n45 1.41675
R59 6to4_0.buff_PI_d32_1.buff_PI_d16$1_0.inv_PI_d8$1_0.VOUT.n40 6to4_0.buff_PI_d32_1.buff_PI_d16$1_0.inv_PI_d8$1_0.VOUT.n39 1.41675
R60 6to4_0.buff_PI_d32_1.buff_PI_d16$1_0.inv_PI_d8$1_0.VOUT.n13 6to4_0.buff_PI_d32_1.buff_PI_d16$1_0.inv_PI_d8$1_0.VOUT.n6 1.3469
R61 6to4_0.buff_PI_d32_1.buff_PI_d16$1_0.inv_PI_d8$1_0.VOUT.n8 6to4_0.buff_PI_d32_1.buff_PI_d16$1_0.inv_PI_d8$1_0.VOUT.n1 1.3469
R62 6to4_0.buff_PI_d32_1.buff_PI_d16$1_0.inv_PI_d8$1_0.VOUT.n22 6to4_0.buff_PI_d32_1.buff_PI_d16$1_0.inv_PI_d8$1_0.VOUT.n20 1.3469
R63 6to4_0.buff_PI_d32_1.buff_PI_d16$1_0.inv_PI_d8$1_0.VOUT.n28 6to4_0.buff_PI_d32_1.buff_PI_d16$1_0.inv_PI_d8$1_0.VOUT.n26 1.3469
R64 6to4_0.buff_PI_d32_1.buff_PI_d16$1_0.inv_PI_d8$1_0.VOUT.n18 6to4_0.buff_PI_d32_1.buff_PI_d16$1_0.inv_PI_d8$1_0.VOUT.n17 0.67839
R65 6to4_0.buff_PI_d32_1.buff_PI_d16$1_0.inv_PI_d8$1_0.VOUT.n24 6to4_0.buff_PI_d32_1.buff_PI_d16$1_0.inv_PI_d8$1_0.VOUT.n23 0.67839
R66 6to4_0.buff_PI_d32_1.buff_PI_d16$1_0.inv_PI_d8$1_0.VOUT.n55 6to4_0.buff_PI_d32_1.buff_PI_d16$1_0.inv_PI_d8$1_0.VOUT.n54 0.633
R67 6to4_0.buff_PI_d32_1.buff_PI_d16$1_0.inv_PI_d8$1_0.VOUT.n49 6to4_0.buff_PI_d32_1.buff_PI_d16$1_0.inv_PI_d8$1_0.VOUT.n48 0.633
R68 6to4_0.buff_PI_d32_1.buff_PI_d16$1_0.inv_PI_d8$1_0.VOUT.n43 6to4_0.buff_PI_d32_1.buff_PI_d16$1_0.inv_PI_d8$1_0.VOUT.n42 0.633
R69 6to4_0.buff_PI_d32_1.buff_PI_d16$1_0.inv_PI_d8$1_0.VOUT.n37 6to4_0.buff_PI_d32_1.buff_PI_d16$1_0.inv_PI_d8$1_0.VOUT.n36 0.633
R70 6to4_0.buff_PI_d32_1.buff_PI_d16$1_0.inv_PI_d8$1_0.VOUT.n54 6to4_0.buff_PI_d32_1.buff_PI_d16$1_0.inv_PI_d8$1_0.VOUT.n53 0.392375
R71 6to4_0.buff_PI_d32_1.buff_PI_d16$1_0.inv_PI_d8$1_0.VOUT.n48 6to4_0.buff_PI_d32_1.buff_PI_d16$1_0.inv_PI_d8$1_0.VOUT.n47 0.392375
R72 6to4_0.buff_PI_d32_1.buff_PI_d16$1_0.inv_PI_d8$1_0.VOUT.n42 6to4_0.buff_PI_d32_1.buff_PI_d16$1_0.inv_PI_d8$1_0.VOUT.n41 0.392375
R73 6to4_0.buff_PI_d32_1.buff_PI_d16$1_0.inv_PI_d8$1_0.VOUT.n36 6to4_0.buff_PI_d32_1.buff_PI_d16$1_0.inv_PI_d8$1_0.VOUT.n35 0.392375
R74 6to4_0.buff_PI_d32_1.buff_PI_d16$1_0.inv_PI_d8$1_0.VOUT.n18 6to4_0.buff_PI_d32_1.buff_PI_d16$1_0.inv_PI_d8$1_0.VOUT.n11 0.3855
R75 6to4_0.buff_PI_d32_1.buff_PI_d16$1_0.inv_PI_d8$1_0.VOUT.n24 6to4_0.buff_PI_d32_1.buff_PI_d16$1_0.inv_PI_d8$1_0.VOUT.n6 0.3855
R76 6to4_0.buff_PI_d32_1.buff_PI_d16$1_0.inv_PI_d8$1_0.VOUT.n17 6to4_0.buff_PI_d32_1.buff_PI_d16$1_0.inv_PI_d8$1_0.VOUT.n16 0.3855
R77 6to4_0.buff_PI_d32_1.buff_PI_d16$1_0.inv_PI_d8$1_0.VOUT.n30 6to4_0.buff_PI_d32_1.buff_PI_d16$1_0.inv_PI_d8$1_0.VOUT.n1 0.3855
R78 6to4_0.buff_PI_d32_1.buff_PI_d16$1_0.inv_PI_d8$1_0.VOUT.n23 6to4_0.buff_PI_d32_1.buff_PI_d16$1_0.inv_PI_d8$1_0.VOUT.n22 0.3855
R79 6to4_0.buff_PI_d32_1.buff_PI_d16$1_0.inv_PI_d8$1_0.VOUT.n29 6to4_0.buff_PI_d32_1.buff_PI_d16$1_0.inv_PI_d8$1_0.VOUT.n28 0.3855
R80 6to4_0.buff_PI_d32_1.buff_PI_d16$1_0.inv_PI_d8$1_0.VOUT.n17 6to4_0.buff_PI_d32_1.buff_PI_d16$1_0.inv_PI_d8$1_0.VOUT.n13 0.3833
R81 6to4_0.buff_PI_d32_1.buff_PI_d16$1_0.inv_PI_d8$1_0.VOUT.n23 6to4_0.buff_PI_d32_1.buff_PI_d16$1_0.inv_PI_d8$1_0.VOUT.n8 0.3833
R82 6to4_0.buff_PI_d32_1.buff_PI_d16$1_0.inv_PI_d8$1_0.VOUT.n20 6to4_0.buff_PI_d32_1.buff_PI_d16$1_0.inv_PI_d8$1_0.VOUT.n18 0.3833
R83 6to4_0.buff_PI_d32_1.buff_PI_d16$1_0.inv_PI_d8$1_0.VOUT.n29 6to4_0.buff_PI_d32_1.buff_PI_d16$1_0.inv_PI_d8$1_0.VOUT.n4 0.3833
R84 6to4_0.buff_PI_d32_1.buff_PI_d16$1_0.inv_PI_d8$1_0.VOUT.n26 6to4_0.buff_PI_d32_1.buff_PI_d16$1_0.inv_PI_d8$1_0.VOUT.n24 0.3833
R85 6to4_0.buff_PI_d32_1.buff_PI_d16$1_0.inv_PI_d8$1_0.VOUT.n32 6to4_0.buff_PI_d32_1.buff_PI_d16$1_0.inv_PI_d8$1_0.VOUT.n30 0.3833
R86 6to4_0.buff_PI_d32_1.buff_PI_d16$1_0.inv_PI_d8$1_0.VOUT.n56 6to4_0.buff_PI_d32_1.buff_PI_d16$1_0.inv_PI_d8$1_0.inv_PI_d4$1_0.inv_PI_d2$1_0.VOUT 0.358
R87 6to4_0.buff_PI_d32_1.buff_PI_d16$1_0.inv_PI_d8$1_0.VOUT.n50 6to4_0.buff_PI_d32_1.buff_PI_d16$1_0.inv_PI_d8$1_0.inv_PI_d4$1_0.inv_PI_d2$1_1.VOUT 0.358
R88 6to4_0.buff_PI_d32_1.buff_PI_d16$1_0.inv_PI_d8$1_0.VOUT.n44 6to4_0.buff_PI_d32_1.buff_PI_d16$1_0.inv_PI_d8$1_0.inv_PI_d4$1_1.inv_PI_d2$1_0.VOUT 0.358
R89 6to4_0.buff_PI_d32_1.buff_PI_d16$1_0.inv_PI_d8$1_0.VOUT.n38 6to4_0.buff_PI_d32_1.buff_PI_d16$1_0.inv_PI_d8$1_0.inv_PI_d4$1_1.inv_PI_d2$1_1.VOUT 0.358
R90 6to4_0.buff_PI_d32_1.buff_PI_d16$1_0.inv_PI_d8$1_0.inv_PI_d4$1_0.inv_PI_d2$1_0.inv_PI$1_1.VOUT 6to4_0.buff_PI_d32_1.buff_PI_d16$1_0.inv_PI_d8$1_0.VOUT.n52 0.3305
R91 6to4_0.buff_PI_d32_1.buff_PI_d16$1_0.inv_PI_d8$1_0.VOUT.n51 6to4_0.buff_PI_d32_1.buff_PI_d16$1_0.inv_PI_d8$1_0.inv_PI_d4$1_0.inv_PI_d2$1_1.inv_PI$1_0.VOUT 0.3305
R92 6to4_0.buff_PI_d32_1.buff_PI_d16$1_0.inv_PI_d8$1_0.inv_PI_d4$1_0.inv_PI_d2$1_1.inv_PI$1_1.VOUT 6to4_0.buff_PI_d32_1.buff_PI_d16$1_0.inv_PI_d8$1_0.VOUT.n46 0.3305
R93 6to4_0.buff_PI_d32_1.buff_PI_d16$1_0.inv_PI_d8$1_0.inv_PI_d4$1_1.inv_PI_d2$1_0.inv_PI$1_1.VOUT 6to4_0.buff_PI_d32_1.buff_PI_d16$1_0.inv_PI_d8$1_0.VOUT.n40 0.3305
R94 6to4_0.buff_PI_d32_1.buff_PI_d16$1_0.inv_PI_d8$1_0.VOUT.n39 6to4_0.buff_PI_d32_1.buff_PI_d16$1_0.inv_PI_d8$1_0.inv_PI_d4$1_1.inv_PI_d2$1_1.inv_PI$1_0.VOUT 0.3305
R95 6to4_0.buff_PI_d32_1.buff_PI_d16$1_0.inv_PI_d8$1_0.inv_PI_d4$1_0.VOUT 6to4_0.buff_PI_d32_1.buff_PI_d16$1_0.inv_PI_d8$1_0.inv_PI_d4$1_0.inv_PI_d2$1_0.inv_PI$1_0.VOUT 0.217062
R96 6to4_0.buff_PI_d32_1.buff_PI_d16$1_0.inv_PI_d8$1_0.inv_PI_d4$1_1.VOUT 6to4_0.buff_PI_d32_1.buff_PI_d16$1_0.inv_PI_d8$1_0.inv_PI_d4$1_1.inv_PI_d2$1_0.inv_PI$1_0.VOUT 0.217062
R97 6to4_0.buff_PI_d32_1.buff_PI_d16$1_0.inv_PI_d8$1_0.inv_PI_d4$1_0.VOUT 6to4_0.buff_PI_d32_1.buff_PI_d16$1_0.inv_PI_d8$1_0.VOUT.n34 0.113938
R98 6to4_0.buff_PI_d32_1.buff_PI_d16$1_0.inv_PI_d8$1_0.VOUT.n45 6to4_0.buff_PI_d32_1.buff_PI_d16$1_0.inv_PI_d8$1_0.inv_PI_d4$1_1.VOUT 0.113938
R99 6to4_0.buff_PI_d32_1.buff_PI_d16$1_0.inv_PI_d16$1_0.VIN 6to4_0.buff_PI_d32_1.buff_PI_d16$1_0.inv_PI_d8$1_0.VOUT.n29 0.0662582
R100 6to4_0.buff_PI_d32_1.buff_PI_d16$1_0.inv_PI_d8$1_0.inv_PI_d4$1_0.inv_PI_d2$1_0.inv_PI$1_0.VOUT 6to4_0.buff_PI_d32_1.buff_PI_d16$1_0.inv_PI_d8$1_0.VOUT.n56 0.062375
R101 6to4_0.buff_PI_d32_1.buff_PI_d16$1_0.inv_PI_d8$1_0.VOUT.n53 6to4_0.buff_PI_d32_1.buff_PI_d16$1_0.inv_PI_d8$1_0.inv_PI_d4$1_0.inv_PI_d2$1_0.inv_PI$1_1.VOUT 0.062375
R102 6to4_0.buff_PI_d32_1.buff_PI_d16$1_0.inv_PI_d8$1_0.inv_PI_d4$1_0.inv_PI_d2$1_1.inv_PI$1_0.VOUT 6to4_0.buff_PI_d32_1.buff_PI_d16$1_0.inv_PI_d8$1_0.VOUT.n50 0.062375
R103 6to4_0.buff_PI_d32_1.buff_PI_d16$1_0.inv_PI_d8$1_0.VOUT.n47 6to4_0.buff_PI_d32_1.buff_PI_d16$1_0.inv_PI_d8$1_0.inv_PI_d4$1_0.inv_PI_d2$1_1.inv_PI$1_1.VOUT 0.062375
R104 6to4_0.buff_PI_d32_1.buff_PI_d16$1_0.inv_PI_d8$1_0.inv_PI_d4$1_1.inv_PI_d2$1_0.inv_PI$1_0.VOUT 6to4_0.buff_PI_d32_1.buff_PI_d16$1_0.inv_PI_d8$1_0.VOUT.n44 0.062375
R105 6to4_0.buff_PI_d32_1.buff_PI_d16$1_0.inv_PI_d8$1_0.VOUT.n41 6to4_0.buff_PI_d32_1.buff_PI_d16$1_0.inv_PI_d8$1_0.inv_PI_d4$1_1.inv_PI_d2$1_0.inv_PI$1_1.VOUT 0.062375
R106 6to4_0.buff_PI_d32_1.buff_PI_d16$1_0.inv_PI_d8$1_0.inv_PI_d4$1_1.inv_PI_d2$1_1.inv_PI$1_0.VOUT 6to4_0.buff_PI_d32_1.buff_PI_d16$1_0.inv_PI_d8$1_0.VOUT.n38 0.062375
R107 6to4_0.buff_PI_d32_1.buff_PI_d16$1_0.inv_PI_d8$1_0.VOUT.n35 6to4_0.buff_PI_d32_1.buff_PI_d16$1_0.inv_PI_d8$1_0.inv_PI_d4$1_1.inv_PI_d2$1_1.inv_PI$1_1.VOUT 0.062375
R108 6to4_0.buff_PI_d32_1.buff_PI_d16$1_0.inv_PI_d8$1_0.VOUT.n30 6to4_0.buff_PI_d32_1.buff_PI_d16$1_0.inv_PI_d16$1_0.VIN 0.059489
R109 6to4_0.buff_PI_d32_1.buff_PI_d16$1_0.inv_PI_d8$1_0.VOUT.n31 6to4_0.buff_PI_d32_1.buff_PI_d16$1_0.inv_PI_d16$1_0.inv_PI_d8$1_1.inv_PI_d4$1_1.inv_PI_d2$1_1.inv_PI$1_0.VIN 0.0555
R110 6to4_0.buff_PI_d32_1.buff_PI_d16$1_0.inv_PI_d8$1_0.VOUT.n25 6to4_0.buff_PI_d32_1.buff_PI_d16$1_0.inv_PI_d16$1_0.inv_PI_d8$1_0.inv_PI_d4$1_1.inv_PI_d2$1_0.inv_PI$1_0.VIN 0.0555
R111 6to4_0.buff_PI_d32_1.buff_PI_d16$1_0.inv_PI_d8$1_0.VOUT.n19 6to4_0.buff_PI_d32_1.buff_PI_d16$1_0.inv_PI_d16$1_0.inv_PI_d8$1_1.inv_PI_d4$1_0.inv_PI_d2$1_1.inv_PI$1_0.VIN 0.0555
R112 6to4_0.buff_PI_d32_1.buff_PI_d16$1_0.inv_PI_d8$1_0.VOUT.n9 6to4_0.buff_PI_d32_1.buff_PI_d16$1_0.inv_PI_d16$1_0.inv_PI_d8$1_1.inv_PI_d4$1_0.inv_PI_d2$1_0.inv_PI$1_0.VIN 0.0555
R113 6to4_0.buff_PI_d32_1.buff_PI_d16$1_0.inv_PI_d8$1_0.VOUT.n14 6to4_0.buff_PI_d32_1.buff_PI_d16$1_0.inv_PI_d16$1_0.inv_PI_d8$1_0.inv_PI_d4$1_0.inv_PI_d2$1_0.inv_PI$1_0.VIN 0.0555
R114 6to4_0.buff_PI_d32_1.buff_PI_d16$1_0.inv_PI_d8$1_0.VOUT.n12 6to4_0.buff_PI_d32_1.buff_PI_d16$1_0.inv_PI_d16$1_0.inv_PI_d8$1_0.inv_PI_d4$1_0.inv_PI_d2$1_1.inv_PI$1_0.VIN 0.0555
R115 6to4_0.buff_PI_d32_1.buff_PI_d16$1_0.inv_PI_d8$1_0.VOUT.n7 6to4_0.buff_PI_d32_1.buff_PI_d16$1_0.inv_PI_d16$1_0.inv_PI_d8$1_1.inv_PI_d4$1_1.inv_PI_d2$1_0.inv_PI$1_0.VIN 0.0555
R116 6to4_0.buff_PI_d32_1.buff_PI_d16$1_0.inv_PI_d8$1_0.VOUT.n3 6to4_0.buff_PI_d32_1.buff_PI_d16$1_0.inv_PI_d16$1_0.inv_PI_d8$1_0.inv_PI_d4$1_1.inv_PI_d2$1_1.inv_PI$1_0.VIN 0.0555
R117 6to4_0.buff_PI_d32_1.buff_PI_d16$1_0.inv_PI_d16$1_0.inv_PI_d8$1_0.inv_PI_d4$1_1.inv_PI_d2$1_0.VIN 6to4_0.buff_PI_d32_1.buff_PI_d16$1_0.inv_PI_d16$1_0.inv_PI_d8$1_0.inv_PI_d4$1_1.inv_PI_d2$1_0.inv_PI$1_1.VIN 0.0445
R118 6to4_0.buff_PI_d32_1.buff_PI_d16$1_0.inv_PI_d16$1_0.inv_PI_d8$1_1.inv_PI_d4$1_0.inv_PI_d2$1_0.VIN 6to4_0.buff_PI_d32_1.buff_PI_d16$1_0.inv_PI_d16$1_0.inv_PI_d8$1_1.inv_PI_d4$1_0.inv_PI_d2$1_0.inv_PI$1_1.VIN 0.0445
R119 6to4_0.buff_PI_d32_1.buff_PI_d16$1_0.inv_PI_d16$1_0.inv_PI_d8$1_0.inv_PI_d4$1_0.inv_PI_d2$1_0.VIN 6to4_0.buff_PI_d32_1.buff_PI_d16$1_0.inv_PI_d16$1_0.inv_PI_d8$1_0.inv_PI_d4$1_0.inv_PI_d2$1_0.inv_PI$1_1.VIN 0.0445
R120 6to4_0.buff_PI_d32_1.buff_PI_d16$1_0.inv_PI_d16$1_0.inv_PI_d8$1_1.inv_PI_d4$1_1.inv_PI_d2$1_0.VIN 6to4_0.buff_PI_d32_1.buff_PI_d16$1_0.inv_PI_d16$1_0.inv_PI_d8$1_1.inv_PI_d4$1_1.inv_PI_d2$1_0.inv_PI$1_1.VIN 0.0445
R121 6to4_0.buff_PI_d32_1.buff_PI_d16$1_0.inv_PI_d16$1_0.inv_PI_d8$1_1.inv_PI_d4$1_0.VIN 6to4_0.buff_PI_d32_1.buff_PI_d16$1_0.inv_PI_d16$1_0.inv_PI_d8$1_1.inv_PI_d4$1_0.inv_PI_d2$1_1.inv_PI$1_1.VIN 0.0371667
R122 6to4_0.buff_PI_d32_1.buff_PI_d16$1_0.inv_PI_d16$1_0.inv_PI_d8$1_0.inv_PI_d4$1_0.VIN 6to4_0.buff_PI_d32_1.buff_PI_d16$1_0.inv_PI_d16$1_0.inv_PI_d8$1_0.inv_PI_d4$1_0.inv_PI_d2$1_1.inv_PI$1_1.VIN 0.0371667
R123 6to4_0.buff_PI_d32_1.buff_PI_d16$1_0.inv_PI_d16$1_0.inv_PI_d8$1_0.inv_PI_d4$1_1.VIN 6to4_0.buff_PI_d32_1.buff_PI_d16$1_0.inv_PI_d16$1_0.inv_PI_d8$1_0.inv_PI_d4$1_1.inv_PI_d2$1_1.inv_PI$1_1.VIN 0.0371667
R124 6to4_0.buff_PI_d32_1.buff_PI_d16$1_0.inv_PI_d16$1_0.inv_PI_d8$1_1.inv_PI_d4$1_1.inv_PI_d2$1_1.inv_PI$1_1.VIN 6to4_0.buff_PI_d32_1.buff_PI_d16$1_0.inv_PI_d16$1_0.inv_PI_d8$1_1.inv_PI_d4$1_1.VIN 0.0371667
R125 6to4_0.buff_PI_d32_1.buff_PI_d16$1_0.inv_PI_d8$1_0.inv_PI_d4$1_0.inv_PI_d2$1_0.VOUT 6to4_0.buff_PI_d32_1.buff_PI_d16$1_0.inv_PI_d8$1_0.VOUT.n55 0.034875
R126 6to4_0.buff_PI_d32_1.buff_PI_d16$1_0.inv_PI_d8$1_0.inv_PI_d4$1_0.inv_PI_d2$1_1.VOUT 6to4_0.buff_PI_d32_1.buff_PI_d16$1_0.inv_PI_d8$1_0.VOUT.n49 0.034875
R127 6to4_0.buff_PI_d32_1.buff_PI_d16$1_0.inv_PI_d8$1_0.inv_PI_d4$1_1.inv_PI_d2$1_0.VOUT 6to4_0.buff_PI_d32_1.buff_PI_d16$1_0.inv_PI_d8$1_0.VOUT.n43 0.034875
R128 6to4_0.buff_PI_d32_1.buff_PI_d16$1_0.inv_PI_d8$1_0.inv_PI_d4$1_1.inv_PI_d2$1_1.VOUT 6to4_0.buff_PI_d32_1.buff_PI_d16$1_0.inv_PI_d8$1_0.VOUT.n37 0.034875
R129 6to4_0.buff_PI_d32_1.buff_PI_d16$1_0.inv_PI_d8$1_0.VOUT.n27 6to4_0.buff_PI_d32_1.buff_PI_d16$1_0.inv_PI_d16$1_0.inv_PI_d8$1_0.inv_PI_d4$1_1.inv_PI_d2$1_0.VIN 0.0115
R130 6to4_0.buff_PI_d32_1.buff_PI_d16$1_0.inv_PI_d8$1_0.VOUT.n21 6to4_0.buff_PI_d32_1.buff_PI_d16$1_0.inv_PI_d16$1_0.inv_PI_d8$1_1.inv_PI_d4$1_0.inv_PI_d2$1_1.VIN 0.0115
R131 6to4_0.buff_PI_d32_1.buff_PI_d16$1_0.inv_PI_d8$1_0.VOUT.n10 6to4_0.buff_PI_d32_1.buff_PI_d16$1_0.inv_PI_d16$1_0.inv_PI_d8$1_1.inv_PI_d4$1_0.inv_PI_d2$1_0.VIN 0.0115
R132 6to4_0.buff_PI_d32_1.buff_PI_d16$1_0.inv_PI_d8$1_0.VOUT.n15 6to4_0.buff_PI_d32_1.buff_PI_d16$1_0.inv_PI_d16$1_0.inv_PI_d8$1_0.inv_PI_d4$1_0.inv_PI_d2$1_0.VIN 0.0115
R133 6to4_0.buff_PI_d32_1.buff_PI_d16$1_0.inv_PI_d8$1_0.VOUT.n5 6to4_0.buff_PI_d32_1.buff_PI_d16$1_0.inv_PI_d16$1_0.inv_PI_d8$1_0.inv_PI_d4$1_0.inv_PI_d2$1_1.VIN 0.0115
R134 6to4_0.buff_PI_d32_1.buff_PI_d16$1_0.inv_PI_d8$1_0.VOUT.n0 6to4_0.buff_PI_d32_1.buff_PI_d16$1_0.inv_PI_d16$1_0.inv_PI_d8$1_1.inv_PI_d4$1_1.inv_PI_d2$1_0.VIN 0.0115
R135 6to4_0.buff_PI_d32_1.buff_PI_d16$1_0.inv_PI_d8$1_0.VOUT.n2 6to4_0.buff_PI_d32_1.buff_PI_d16$1_0.inv_PI_d16$1_0.inv_PI_d8$1_0.inv_PI_d4$1_1.inv_PI_d2$1_1.VIN 0.0115
R136 6to4_0.buff_PI_d32_1.buff_PI_d16$1_0.inv_PI_d16$1_0.inv_PI_d8$1_1.inv_PI_d4$1_1.inv_PI_d2$1_1.VIN 6to4_0.buff_PI_d32_1.buff_PI_d16$1_0.inv_PI_d8$1_0.VOUT.n33 0.0115
R137 6to4_0.buff_PI_d32_1.buff_PI_d16$1_0.inv_PI_d16$1_0.inv_PI_d8$1_1.inv_PI_d4$1_0.inv_PI_d2$1_1.VIN 6to4_0.buff_PI_d32_1.buff_PI_d16$1_0.inv_PI_d16$1_0.inv_PI_d8$1_1.inv_PI_d4$1_0.VIN 0.00783333
R138 6to4_0.buff_PI_d32_1.buff_PI_d16$1_0.inv_PI_d16$1_0.inv_PI_d8$1_0.inv_PI_d4$1_0.inv_PI_d2$1_1.VIN 6to4_0.buff_PI_d32_1.buff_PI_d16$1_0.inv_PI_d16$1_0.inv_PI_d8$1_0.inv_PI_d4$1_0.VIN 0.00783333
R139 6to4_0.buff_PI_d32_1.buff_PI_d16$1_0.inv_PI_d16$1_0.inv_PI_d8$1_0.inv_PI_d4$1_1.inv_PI_d2$1_1.VIN 6to4_0.buff_PI_d32_1.buff_PI_d16$1_0.inv_PI_d16$1_0.inv_PI_d8$1_0.inv_PI_d4$1_1.VIN 0.00783333
R140 6to4_0.buff_PI_d32_1.buff_PI_d16$1_0.inv_PI_d16$1_0.inv_PI_d8$1_1.inv_PI_d4$1_1.VIN 6to4_0.buff_PI_d32_1.buff_PI_d16$1_0.inv_PI_d16$1_0.inv_PI_d8$1_1.inv_PI_d4$1_1.inv_PI_d2$1_1.VIN 0.00783333
R141 VDD.n455 VDD.n454 18.4411
R142 VDD.n445 VDD.n444 18.4411
R143 VDD.n435 VDD.n434 18.4411
R144 VDD.n425 VDD.n424 18.4411
R145 VDD.n415 VDD.n414 18.4411
R146 VDD.n405 VDD.n404 18.4411
R147 VDD.n395 VDD.n394 18.4411
R148 VDD.n385 VDD.n384 18.4411
R149 VDD.n375 VDD.n374 18.4411
R150 VDD.n365 VDD.n364 18.4411
R151 VDD.n355 VDD.n354 18.4411
R152 VDD.n775 VDD.n774 18.4411
R153 VDD.n765 VDD.n764 18.4411
R154 VDD.n755 VDD.n754 18.4411
R155 VDD.n745 VDD.n744 18.4411
R156 VDD.n735 VDD.n734 18.4411
R157 VDD.n725 VDD.n724 18.4411
R158 VDD.n715 VDD.n714 18.4411
R159 VDD.n705 VDD.n704 18.4411
R160 VDD.n695 VDD.n694 18.4411
R161 VDD.n685 VDD.n684 18.4411
R162 VDD.n1596 VDD.n1595 18.4411
R163 VDD.n1586 VDD.n1585 18.4411
R164 VDD.n1576 VDD.n1575 18.4411
R165 VDD.n1566 VDD.n1565 18.4411
R166 VDD.n1556 VDD.n1555 18.4411
R167 VDD.n1546 VDD.n1545 18.4411
R168 VDD.n1536 VDD.n1535 18.4411
R169 VDD.n1526 VDD.n1525 18.4411
R170 VDD.n1516 VDD.n1515 18.4411
R171 VDD.n985 VDD.n984 18.4411
R172 VDD.n1692 VDD.n1691 18.4411
R173 VDD.n1714 VDD.n1713 18.4411
R174 VDD.n1736 VDD.n1735 18.4411
R175 VDD.n1758 VDD.n1757 18.4411
R176 VDD.n1780 VDD.n1779 18.4411
R177 VDD.n1791 VDD.n1790 18.4411
R178 VDD.n1769 VDD.n1768 18.4411
R179 VDD.n1747 VDD.n1746 18.4411
R180 VDD.n1725 VDD.n1724 18.4411
R181 VDD.n1703 VDD.n1702 18.4411
R182 VDD.n1681 VDD.n1680 18.4411
R183 VDD.n1327 VDD.t473 17.6227
R184 VDD.n1324 VDD.t477 17.6227
R185 VDD.n1320 VDD.t471 17.6227
R186 VDD.n1276 VDD.t474 17.6227
R187 VDD.n1278 VDD.t472 17.6227
R188 VDD.n1316 VDD.t475 17.6227
R189 VDD.n1303 VDD.t647 17.6227
R190 VDD.n1299 VDD.t646 17.6227
R191 VDD.n1296 VDD.t648 17.6227
R192 VDD.n1285 VDD.t645 17.6227
R193 VDD.n1282 VDD.t654 17.6227
R194 VDD.n1385 VDD.t544 17.6227
R195 VDD.n1382 VDD.t538 17.6227
R196 VDD.n1378 VDD.t536 17.6227
R197 VDD.n1454 VDD.t513 17.6227
R198 VDD.n1451 VDD.t506 17.6227
R199 VDD.n1447 VDD.t505 17.6227
R200 VDD.n1442 VDD.t507 17.6227
R201 VDD.n1438 VDD.t508 17.6227
R202 VDD.n1434 VDD.t504 17.6227
R203 VDD.n1121 VDD.t518 17.6227
R204 VDD.n1124 VDD.t519 17.6227
R205 VDD.n1429 VDD.t517 17.6227
R206 VDD.n1130 VDD.t516 17.6227
R207 VDD.n1127 VDD.t521 17.6227
R208 VDD.n1241 VDD.t541 17.6227
R209 VDD.n1243 VDD.t537 17.6227
R210 VDD.n1374 VDD.t304 17.6227
R211 VDD.n1268 VDD.t307 17.6227
R212 VDD.n1264 VDD.t305 17.6227
R213 VDD.n1261 VDD.t306 17.6227
R214 VDD.n1250 VDD.t303 17.6227
R215 VDD.n1247 VDD.t302 17.6227
R216 VDD.n145 VDD.t396 17.3751
R217 VDD.n2064 VDD.t417 17.3751
R218 VDD.n28 VDD.t1144 17.3751
R219 VDD.n1861 VDD.t752 17.3751
R220 VDD.n1621 VDD.t733 17.3751
R221 VDD.n1888 VDD.t715 17.3751
R222 VDD.n1904 VDD.t759 17.3751
R223 VDD.n149 VDD.t439 17.3751
R224 VDD.n2036 VDD.t371 17.3751
R225 VDD.n304 VDD.t286 17.3751
R226 VDD.n335 VDD.t94 17.3751
R227 VDD.n326 VDD.t1131 17.3751
R228 VDD.n2020 VDD.t237 17.3751
R229 VDD.n1992 VDD.t204 17.3751
R230 VDD.n1976 VDD.t282 17.3751
R231 VDD.n1948 VDD.t607 17.3751
R232 VDD.n520 VDD.t587 17.3751
R233 VDD.n1932 VDD.t595 17.3751
R234 VDD.n821 VDD.t611 17.3751
R235 VDD.n1665 VDD.t838 17.3167
R236 VDD.n1667 VDD.t837 17.3167
R237 VDD.n1670 VDD.t841 17.3167
R238 VDD.n1672 VDD.t840 17.3167
R239 VDD.n1673 VDD.t851 17.3167
R240 VDD.n1675 VDD.t849 17.3167
R241 VDD.n1678 VDD.t843 17.3167
R242 VDD.n1689 VDD.t846 17.3167
R243 VDD.n1694 VDD.t847 17.3167
R244 VDD.n1695 VDD.t834 17.3167
R245 VDD.n1697 VDD.t835 17.3167
R246 VDD.n1700 VDD.t852 17.3167
R247 VDD.n1711 VDD.t1111 17.3167
R248 VDD.n1716 VDD.t1110 17.3167
R249 VDD.n1717 VDD.t1118 17.3167
R250 VDD.n1719 VDD.t1116 17.3167
R251 VDD.n1722 VDD.t1095 17.3167
R252 VDD.n1733 VDD.t1123 17.3167
R253 VDD.n1738 VDD.t1122 17.3167
R254 VDD.n1739 VDD.t1103 17.3167
R255 VDD.n1741 VDD.t1101 17.3167
R256 VDD.n1744 VDD.t1089 17.3167
R257 VDD.n1755 VDD.t938 17.3167
R258 VDD.n1760 VDD.t940 17.3167
R259 VDD.n1761 VDD.t920 17.3167
R260 VDD.n1763 VDD.t921 17.3167
R261 VDD.n1766 VDD.t957 17.3167
R262 VDD.n1777 VDD.t951 17.3167
R263 VDD.n1782 VDD.t950 17.3167
R264 VDD.n1783 VDD.t955 17.3167
R265 VDD.n1785 VDD.t953 17.3167
R266 VDD.n1788 VDD.t935 17.3167
R267 VDD.n1799 VDD.t380 17.3167
R268 VDD.n1663 VDD.t411 17.3167
R269 VDD.n1662 VDD.t353 17.3167
R270 VDD.n1660 VDD.t384 17.3167
R271 VDD.n1657 VDD.t364 17.3167
R272 VDD.n2 VDD.t392 17.3167
R273 VDD.n2072 VDD.t346 17.3167
R274 VDD.n2073 VDD.t412 17.3167
R275 VDD.n2075 VDD.t366 17.3167
R276 VDD.n146 VDD.t342 17.3167
R277 VDD.n1651 VDD.t349 17.3167
R278 VDD.n1653 VDD.t428 17.3167
R279 VDD.n1654 VDD.t363 17.3167
R280 VDD.n1796 VDD.t351 17.3167
R281 VDD.n1794 VDD.t372 17.3167
R282 VDD.n1793 VDD.t936 17.3167
R283 VDD.n1774 VDD.t926 17.3167
R284 VDD.n1772 VDD.t928 17.3167
R285 VDD.n1771 VDD.t956 17.3167
R286 VDD.n1752 VDD.t965 17.3167
R287 VDD.n1750 VDD.t966 17.3167
R288 VDD.n1749 VDD.t1091 17.3167
R289 VDD.n1730 VDD.t1087 17.3167
R290 VDD.n1728 VDD.t1086 17.3167
R291 VDD.n1727 VDD.t1097 17.3167
R292 VDD.n1708 VDD.t1083 17.3167
R293 VDD.n1706 VDD.t1084 17.3167
R294 VDD.n1705 VDD.t853 17.3167
R295 VDD.n1686 VDD.t855 17.3167
R296 VDD.n1684 VDD.t857 17.3167
R297 VDD.n1683 VDD.t845 17.3167
R298 VDD.n50 VDD.t667 17.3167
R299 VDD.n49 VDD.t668 17.3167
R300 VDD.n48 VDD.t10 17.3167
R301 VDD.n39 VDD.t15 17.3167
R302 VDD.n46 VDD.t16 17.3167
R303 VDD.n45 VDD.t11 17.3167
R304 VDD.n44 VDD.t121 17.3167
R305 VDD.n54 VDD.t120 17.3167
R306 VDD.n42 VDD.t122 17.3167
R307 VDD.n41 VDD.t123 17.3167
R308 VDD.n35 VDD.t1142 17.3167
R309 VDD.n31 VDD.t1139 17.3167
R310 VDD.n29 VDD.t1140 17.3167
R311 VDD.n2059 VDD.t344 17.3167
R312 VDD.n2055 VDD.t368 17.3167
R313 VDD.n2052 VDD.t360 17.3167
R314 VDD.n2053 VDD.t391 17.3167
R315 VDD.n2050 VDD.t361 17.3167
R316 VDD.n2047 VDD.t393 17.3167
R317 VDD.n2044 VDD.t375 17.3167
R318 VDD.n2045 VDD.t406 17.3167
R319 VDD.n164 VDD.t409 17.3167
R320 VDD.n161 VDD.t378 17.3167
R321 VDD.n158 VDD.t399 17.3167
R322 VDD.n159 VDD.t358 17.3167
R323 VDD.n1804 VDD.t379 17.3167
R324 VDD.n155 VDD.t350 17.3167
R325 VDD.n153 VDD.t416 17.3167
R326 VDD.n2034 VDD.t374 17.3167
R327 VDD.n2031 VDD.t397 17.3167
R328 VDD.n2028 VDD.t387 17.3167
R329 VDD.n2029 VDD.t418 17.3167
R330 VDD.n188 VDD.t367 17.3167
R331 VDD.n185 VDD.t357 17.3167
R332 VDD.n172 VDD.t402 17.3167
R333 VDD.n171 VDD.t434 17.3167
R334 VDD.n2039 VDD.t359 17.3167
R335 VDD.n183 VDD.t362 17.3167
R336 VDD.n180 VDD.t427 17.3167
R337 VDD.n181 VDD.t385 17.3167
R338 VDD.n1807 VDD.t354 17.3167
R339 VDD.n177 VDD.t376 17.3167
R340 VDD.n175 VDD.t348 17.3167
R341 VDD.n342 VDD.t93 17.3167
R342 VDD.n338 VDD.t95 17.3167
R343 VDD.n336 VDD.t96 17.3167
R344 VDD.n333 VDD.t1129 17.3167
R345 VDD.n329 VDD.t1132 17.3167
R346 VDD.n327 VDD.t1134 17.3167
R347 VDD.n302 VDD.t238 17.3167
R348 VDD.n299 VDD.t264 17.3167
R349 VDD.n192 VDD.t265 17.3167
R350 VDD.n191 VDD.t227 17.3167
R351 VDD.n2023 VDD.t225 17.3167
R352 VDD.n297 VDD.t212 17.3167
R353 VDD.n294 VDD.t213 17.3167
R354 VDD.n295 VDD.t199 17.3167
R355 VDD.n292 VDD.t200 17.3167
R356 VDD.n289 VDD.t259 17.3167
R357 VDD.n286 VDD.t258 17.3167
R358 VDD.n287 VDD.t223 17.3167
R359 VDD.n1810 VDD.t222 17.3167
R360 VDD.n283 VDD.t294 17.3167
R361 VDD.n280 VDD.t295 17.3167
R362 VDD.n281 VDD.t1002 17.3167
R363 VDD.n453 VDD.t1001 17.3167
R364 VDD.n277 VDD.t989 17.3167
R365 VDD.n274 VDD.t991 17.3167
R366 VDD.n275 VDD.t1010 17.3167
R367 VDD.n443 VDD.t1011 17.3167
R368 VDD.n271 VDD.t995 17.3167
R369 VDD.n268 VDD.t997 17.3167
R370 VDD.n269 VDD.t992 17.3167
R371 VDD.n433 VDD.t993 17.3167
R372 VDD.n265 VDD.t981 17.3167
R373 VDD.n262 VDD.t980 17.3167
R374 VDD.n263 VDD.t978 17.3167
R375 VDD.n423 VDD.t977 17.3167
R376 VDD.n259 VDD.t1007 17.3167
R377 VDD.n256 VDD.t1008 17.3167
R378 VDD.n257 VDD.t799 17.3167
R379 VDD.n413 VDD.t797 17.3167
R380 VDD.n253 VDD.t803 17.3167
R381 VDD.n250 VDD.t805 17.3167
R382 VDD.n251 VDD.t806 17.3167
R383 VDD.n403 VDD.t807 17.3167
R384 VDD.n247 VDD.t819 17.3167
R385 VDD.n244 VDD.t818 17.3167
R386 VDD.n245 VDD.t802 17.3167
R387 VDD.n393 VDD.t800 17.3167
R388 VDD.n241 VDD.t782 17.3167
R389 VDD.n238 VDD.t783 17.3167
R390 VDD.n239 VDD.t778 17.3167
R391 VDD.n383 VDD.t776 17.3167
R392 VDD.n235 VDD.t794 17.3167
R393 VDD.n205 VDD.t795 17.3167
R394 VDD.n233 VDD.t1059 17.3167
R395 VDD.n373 VDD.t1058 17.3167
R396 VDD.n230 VDD.t1056 17.3167
R397 VDD.n227 VDD.t1055 17.3167
R398 VDD.n228 VDD.t1050 17.3167
R399 VDD.n363 VDD.t1049 17.3167
R400 VDD.n224 VDD.t1061 17.3167
R401 VDD.n221 VDD.t1063 17.3167
R402 VDD.n222 VDD.t1048 17.3167
R403 VDD.n353 VDD.t1046 17.3167
R404 VDD.n218 VDD.t1043 17.3167
R405 VDD.n215 VDD.t1045 17.3167
R406 VDD.n216 VDD.t1042 17.3167
R407 VDD.n214 VDD.t1040 17.3167
R408 VDD.n211 VDD.t1052 17.3167
R409 VDD.n209 VDD.t1053 17.3167
R410 VDD.n2015 VDD.t285 17.3167
R411 VDD.n2011 VDD.t231 17.3167
R412 VDD.n2008 VDD.t232 17.3167
R413 VDD.n2009 VDD.t249 17.3167
R414 VDD.n2006 VDD.t250 17.3167
R415 VDD.n2003 VDD.t268 17.3167
R416 VDD.n2000 VDD.t267 17.3167
R417 VDD.n2001 VDD.t209 17.3167
R418 VDD.n468 VDD.t210 17.3167
R419 VDD.n465 VDD.t291 17.3167
R420 VDD.n462 VDD.t292 17.3167
R421 VDD.n463 VDD.t254 17.3167
R422 VDD.n1813 VDD.t252 17.3167
R423 VDD.n459 VDD.t261 17.3167
R424 VDD.n456 VDD.t262 17.3167
R425 VDD.n457 VDD.t1000 17.3167
R426 VDD.n452 VDD.t998 17.3167
R427 VDD.n449 VDD.t971 17.3167
R428 VDD.n446 VDD.t973 17.3167
R429 VDD.n447 VDD.t968 17.3167
R430 VDD.n442 VDD.t969 17.3167
R431 VDD.n439 VDD.t1014 17.3167
R432 VDD.n436 VDD.t1013 17.3167
R433 VDD.n437 VDD.t986 17.3167
R434 VDD.n432 VDD.t987 17.3167
R435 VDD.n429 VDD.t1004 17.3167
R436 VDD.n426 VDD.t1005 17.3167
R437 VDD.n427 VDD.t976 17.3167
R438 VDD.n422 VDD.t974 17.3167
R439 VDD.n419 VDD.t983 17.3167
R440 VDD.n416 VDD.t984 17.3167
R441 VDD.n417 VDD.t822 17.3167
R442 VDD.n412 VDD.t821 17.3167
R443 VDD.n409 VDD.t786 17.3167
R444 VDD.n406 VDD.t785 17.3167
R445 VDD.n407 VDD.t779 17.3167
R446 VDD.n402 VDD.t780 17.3167
R447 VDD.n399 VDD.t789 17.3167
R448 VDD.n396 VDD.t788 17.3167
R449 VDD.n397 VDD.t817 17.3167
R450 VDD.n392 VDD.t815 17.3167
R451 VDD.n389 VDD.t791 17.3167
R452 VDD.n386 VDD.t793 17.3167
R453 VDD.n387 VDD.t809 17.3167
R454 VDD.n382 VDD.t810 17.3167
R455 VDD.n379 VDD.t813 17.3167
R456 VDD.n376 VDD.t812 17.3167
R457 VDD.n377 VDD.t131 17.3167
R458 VDD.n372 VDD.t129 17.3167
R459 VDD.n369 VDD.t127 17.3167
R460 VDD.n366 VDD.t130 17.3167
R461 VDD.n367 VDD.t134 17.3167
R462 VDD.n362 VDD.t132 17.3167
R463 VDD.n359 VDD.t128 17.3167
R464 VDD.n356 VDD.t136 17.3167
R465 VDD.n357 VDD.t663 17.3167
R466 VDD.n352 VDD.t665 17.3167
R467 VDD.n349 VDD.t664 17.3167
R468 VDD.n346 VDD.t670 17.3167
R469 VDD.n347 VDD.t1064 17.3167
R470 VDD.n325 VDD.t1065 17.3167
R471 VDD.n322 VDD.t1069 17.3167
R472 VDD.n320 VDD.t1070 17.3167
R473 VDD.n1990 VDD.t203 17.3167
R474 VDD.n1987 VDD.t280 17.3167
R475 VDD.n1984 VDD.t279 17.3167
R476 VDD.n1985 VDD.t247 17.3167
R477 VDD.n489 VDD.t246 17.3167
R478 VDD.n486 VDD.t277 17.3167
R479 VDD.n473 VDD.t276 17.3167
R480 VDD.n472 VDD.t273 17.3167
R481 VDD.n1995 VDD.t274 17.3167
R482 VDD.n484 VDD.t243 17.3167
R483 VDD.n481 VDD.t244 17.3167
R484 VDD.n482 VDD.t240 17.3167
R485 VDD.n1816 VDD.t241 17.3167
R486 VDD.n478 VDD.t206 17.3167
R487 VDD.n476 VDD.t207 17.3167
R488 VDD.n518 VDD.t283 17.3167
R489 VDD.n515 VDD.t271 17.3167
R490 VDD.n493 VDD.t270 17.3167
R491 VDD.n492 VDD.t236 17.3167
R492 VDD.n1979 VDD.t234 17.3167
R493 VDD.n513 VDD.t220 17.3167
R494 VDD.n510 VDD.t219 17.3167
R495 VDD.n511 VDD.t216 17.3167
R496 VDD.n508 VDD.t217 17.3167
R497 VDD.n505 VDD.t288 17.3167
R498 VDD.n502 VDD.t290 17.3167
R499 VDD.n503 VDD.t228 17.3167
R500 VDD.n1819 VDD.t229 17.3167
R501 VDD.n499 VDD.t255 17.3167
R502 VDD.n497 VDD.t257 17.3167
R503 VDD.n668 VDD.t334 17.3167
R504 VDD.n667 VDD.t335 17.3167
R505 VDD.n672 VDD.t38 17.3167
R506 VDD.n663 VDD.t43 17.3167
R507 VDD.n665 VDD.t40 17.3167
R508 VDD.n664 VDD.t44 17.3167
R509 VDD.n1971 VDD.t588 17.3167
R510 VDD.n1967 VDD.t551 17.3167
R511 VDD.n1964 VDD.t602 17.3167
R512 VDD.n1965 VDD.t627 17.3167
R513 VDD.n1962 VDD.t582 17.3167
R514 VDD.n1959 VDD.t571 17.3167
R515 VDD.n1956 VDD.t614 17.3167
R516 VDD.n1957 VDD.t644 17.3167
R517 VDD.n620 VDD.t549 17.3167
R518 VDD.n617 VDD.t575 17.3167
R519 VDD.n614 VDD.t636 17.3167
R520 VDD.n615 VDD.t601 17.3167
R521 VDD.n1822 VDD.t568 17.3167
R522 VDD.n611 VDD.t591 17.3167
R523 VDD.n608 VDD.t561 17.3167
R524 VDD.n609 VDD.t1275 17.3167
R525 VDD.n773 VDD.t1287 17.3167
R526 VDD.n605 VDD.t1260 17.3167
R527 VDD.n602 VDD.t1283 17.3167
R528 VDD.n603 VDD.t1298 17.3167
R529 VDD.n763 VDD.t1273 17.3167
R530 VDD.n599 VDD.t1256 17.3167
R531 VDD.n596 VDD.t1289 17.3167
R532 VDD.n597 VDD.t1257 17.3167
R533 VDD.n753 VDD.t1258 17.3167
R534 VDD.n593 VDD.t1270 17.3167
R535 VDD.n590 VDD.t1265 17.3167
R536 VDD.n591 VDD.t1282 17.3167
R537 VDD.n743 VDD.t1266 17.3167
R538 VDD.n587 VDD.t1276 17.3167
R539 VDD.n584 VDD.t1263 17.3167
R540 VDD.n585 VDD.t1185 17.3167
R541 VDD.n733 VDD.t1165 17.3167
R542 VDD.n581 VDD.t1170 17.3167
R543 VDD.n578 VDD.t1181 17.3167
R544 VDD.n579 VDD.t1197 17.3167
R545 VDD.n723 VDD.t1150 17.3167
R546 VDD.n575 VDD.t1166 17.3167
R547 VDD.n572 VDD.t1151 17.3167
R548 VDD.n573 VDD.t1167 17.3167
R549 VDD.n713 VDD.t1152 17.3167
R550 VDD.n569 VDD.t1153 17.3167
R551 VDD.n566 VDD.t1175 17.3167
R552 VDD.n567 VDD.t1190 17.3167
R553 VDD.n703 VDD.t1157 17.3167
R554 VDD.n563 VDD.t1159 17.3167
R555 VDD.n533 VDD.t1184 17.3167
R556 VDD.n561 VDD.t177 17.3167
R557 VDD.n693 VDD.t178 17.3167
R558 VDD.n558 VDD.t174 17.3167
R559 VDD.n555 VDD.t176 17.3167
R560 VDD.n556 VDD.t196 17.3167
R561 VDD.n683 VDD.t195 17.3167
R562 VDD.n552 VDD.t189 17.3167
R563 VDD.n549 VDD.t190 17.3167
R564 VDD.n550 VDD.t194 17.3167
R565 VDD.n661 VDD.t192 17.3167
R566 VDD.n546 VDD.t180 17.3167
R567 VDD.n543 VDD.t181 17.3167
R568 VDD.n544 VDD.t188 17.3167
R569 VDD.n542 VDD.t186 17.3167
R570 VDD.n539 VDD.t183 17.3167
R571 VDD.n537 VDD.t184 17.3167
R572 VDD.n1946 VDD.t550 17.3167
R573 VDD.n1943 VDD.t579 17.3167
R574 VDD.n1940 VDD.t620 17.3167
R575 VDD.n1941 VDD.t556 17.3167
R576 VDD.n790 VDD.t606 17.3167
R577 VDD.n787 VDD.t558 17.3167
R578 VDD.n625 VDD.t635 17.3167
R579 VDD.n624 VDD.t574 17.3167
R580 VDD.n1951 VDD.t576 17.3167
R581 VDD.n785 VDD.t597 17.3167
R582 VDD.n782 VDD.t564 17.3167
R583 VDD.n783 VDD.t619 17.3167
R584 VDD.n1825 VDD.t592 17.3167
R585 VDD.n779 VDD.t562 17.3167
R586 VDD.n776 VDD.t584 17.3167
R587 VDD.n777 VDD.t1286 17.3167
R588 VDD.n772 VDD.t1259 17.3167
R589 VDD.n769 VDD.t1261 17.3167
R590 VDD.n766 VDD.t1294 17.3167
R591 VDD.n767 VDD.t1262 17.3167
R592 VDD.n762 VDD.t1285 17.3167
R593 VDD.n759 VDD.t1268 17.3167
R594 VDD.n756 VDD.t1301 17.3167
R595 VDD.n757 VDD.t1269 17.3167
R596 VDD.n752 VDD.t1271 17.3167
R597 VDD.n749 VDD.t1254 17.3167
R598 VDD.n746 VDD.t1277 17.3167
R599 VDD.n747 VDD.t1293 17.3167
R600 VDD.n742 VDD.t1255 17.3167
R601 VDD.n739 VDD.t1264 17.3167
R602 VDD.n736 VDD.t1274 17.3167
R603 VDD.n737 VDD.t1194 17.3167
R604 VDD.n732 VDD.t1174 17.3167
R605 VDD.n729 VDD.t1156 17.3167
R606 VDD.n726 VDD.t1192 17.3167
R607 VDD.n727 VDD.t1158 17.3167
R608 VDD.n722 VDD.t1160 17.3167
R609 VDD.n719 VDD.t1177 17.3167
R610 VDD.n716 VDD.t1161 17.3167
R611 VDD.n717 VDD.t1178 17.3167
R612 VDD.n712 VDD.t1163 17.3167
R613 VDD.n709 VDD.t1154 17.3167
R614 VDD.n706 VDD.t1187 17.3167
R615 VDD.n707 VDD.t1155 17.3167
R616 VDD.n702 VDD.t1169 17.3167
R617 VDD.n699 VDD.t1171 17.3167
R618 VDD.n696 VDD.t1193 17.3167
R619 VDD.n697 VDD.t21 17.3167
R620 VDD.n692 VDD.t19 17.3167
R621 VDD.n689 VDD.t23 17.3167
R622 VDD.n686 VDD.t20 17.3167
R623 VDD.n687 VDD.t24 17.3167
R624 VDD.n682 VDD.t22 17.3167
R625 VDD.n679 VDD.t18 17.3167
R626 VDD.n676 VDD.t26 17.3167
R627 VDD.n677 VDD.t47 17.3167
R628 VDD.n660 VDD.t41 17.3167
R629 VDD.n657 VDD.t39 17.3167
R630 VDD.n654 VDD.t46 17.3167
R631 VDD.n655 VDD.t489 17.3167
R632 VDD.n653 VDD.t492 17.3167
R633 VDD.n650 VDD.t490 17.3167
R634 VDD.n647 VDD.t491 17.3167
R635 VDD.n648 VDD.t828 17.3167
R636 VDD.n646 VDD.t826 17.3167
R637 VDD.n643 VDD.t830 17.3167
R638 VDD.n641 VDD.t831 17.3167
R639 VDD.n819 VDD.t583 17.3167
R640 VDD.n816 VDD.t560 17.3167
R641 VDD.n794 VDD.t581 17.3167
R642 VDD.n793 VDD.t559 17.3167
R643 VDD.n1935 VDD.t572 17.3167
R644 VDD.n814 VDD.t623 17.3167
R645 VDD.n811 VDD.t570 17.3167
R646 VDD.n812 VDD.t642 17.3167
R647 VDD.n809 VDD.t615 17.3167
R648 VDD.n806 VDD.t593 17.3167
R649 VDD.n803 VDD.t563 17.3167
R650 VDD.n804 VDD.t613 17.3167
R651 VDD.n1828 VDD.t586 17.3167
R652 VDD.n800 VDD.t585 17.3167
R653 VDD.n798 VDD.t548 17.3167
R654 VDD.n1927 VDD.t555 17.3167
R655 VDD.n1923 VDD.t554 17.3167
R656 VDD.n1920 VDD.t598 17.3167
R657 VDD.n1921 VDD.t577 17.3167
R658 VDD.n1918 VDD.t590 17.3167
R659 VDD.n1915 VDD.t567 17.3167
R660 VDD.n1912 VDD.t589 17.3167
R661 VDD.n1913 VDD.t566 17.3167
R662 VDD.n836 VDD.t553 17.3167
R663 VDD.n833 VDD.t565 17.3167
R664 VDD.n830 VDD.t580 17.3167
R665 VDD.n831 VDD.t625 17.3167
R666 VDD.n1831 VDD.t603 17.3167
R667 VDD.n827 VDD.t557 17.3167
R668 VDD.n825 VDD.t569 17.3167
R669 VDD.n1479 VDD.t1148 17.3167
R670 VDD.n1478 VDD.t671 17.3167
R671 VDD.n1476 VDD.t672 17.3167
R672 VDD.n1008 VDD.t88 17.3167
R673 VDD.n1009 VDD.t86 17.3167
R674 VDD.n1062 VDD.t91 17.3167
R675 VDD.n1061 VDD.t90 17.3167
R676 VDD.n1010 VDD.t447 17.3167
R677 VDD.n1011 VDD.t448 17.3167
R678 VDD.n1058 VDD.t441 17.3167
R679 VDD.n1057 VDD.t444 17.3167
R680 VDD.n1012 VDD.t443 17.3167
R681 VDD.n1013 VDD.t446 17.3167
R682 VDD.n1055 VDD.t442 17.3167
R683 VDD.n1054 VDD.t445 17.3167
R684 VDD.n1053 VDD.t1302 17.3167
R685 VDD.n1015 VDD.t118 17.3167
R686 VDD.n1017 VDD.t119 17.3167
R687 VDD.n1052 VDD.t81 17.3167
R688 VDD.n1051 VDD.t83 17.3167
R689 VDD.n1050 VDD.t84 17.3167
R690 VDD.n1019 VDD.t79 17.3167
R691 VDD.n1049 VDD.t449 17.3167
R692 VDD.n1048 VDD.t454 17.3167
R693 VDD.n1047 VDD.t452 17.3167
R694 VDD.n1021 VDD.t455 17.3167
R695 VDD.n1046 VDD.t457 17.3167
R696 VDD.n1045 VDD.t450 17.3167
R697 VDD.n1044 VDD.t453 17.3167
R698 VDD.n1023 VDD.t456 17.3167
R699 VDD.n1042 VDD.t772 17.3167
R700 VDD.n1041 VDD.t331 17.3167
R701 VDD.n1039 VDD.t332 17.3167
R702 VDD.n1024 VDD.t463 17.3167
R703 VDD.n1025 VDD.t466 17.3167
R704 VDD.n1037 VDD.t465 17.3167
R705 VDD.n1036 VDD.t467 17.3167
R706 VDD.n1026 VDD.t58 17.3167
R707 VDD.n1027 VDD.t54 17.3167
R708 VDD.n1034 VDD.t52 17.3167
R709 VDD.n1033 VDD.t55 17.3167
R710 VDD.n1028 VDD.t53 17.3167
R711 VDD.n1029 VDD.t50 17.3167
R712 VDD.n1031 VDD.t49 17.3167
R713 VDD.n1030 VDD.t56 17.3167
R714 VDD.n1409 VDD.t320 17.3167
R715 VDD.n1408 VDD.t322 17.3167
R716 VDD.n1407 VDD.t317 17.3167
R717 VDD.n1191 VDD.t318 17.3167
R718 VDD.n1406 VDD.t323 17.3167
R719 VDD.n1412 VDD.t316 17.3167
R720 VDD.n1192 VDD.t319 17.3167
R721 VDD.n1194 VDD.t321 17.3167
R722 VDD.n1404 VDD.t314 17.3167
R723 VDD.n1402 VDD.t315 17.3167
R724 VDD.n1401 VDD.t312 17.3167
R725 VDD.n1196 VDD.t313 17.3167
R726 VDD.n1400 VDD.t469 17.3167
R727 VDD.n1399 VDD.t468 17.3167
R728 VDD.n1198 VDD.t462 17.3167
R729 VDD.n1199 VDD.t151 17.3167
R730 VDD.n1201 VDD.t153 17.3167
R731 VDD.n1397 VDD.t148 17.3167
R732 VDD.n1396 VDD.t155 17.3167
R733 VDD.n1202 VDD.t152 17.3167
R734 VDD.n1203 VDD.t154 17.3167
R735 VDD.n1236 VDD.t149 17.3167
R736 VDD.n1235 VDD.t150 17.3167
R737 VDD.n1234 VDD.t169 17.3167
R738 VDD.n1205 VDD.t166 17.3167
R739 VDD.n1232 VDD.t167 17.3167
R740 VDD.n1231 VDD.t168 17.3167
R741 VDD.n1206 VDD.t76 17.3167
R742 VDD.n1207 VDD.t77 17.3167
R743 VDD.n1229 VDD.t546 17.3167
R744 VDD.n1228 VDD.t481 17.3167
R745 VDD.n1226 VDD.t484 17.3167
R746 VDD.n1225 VDD.t487 17.3167
R747 VDD.n1209 VDD.t486 17.3167
R748 VDD.n1224 VDD.t483 17.3167
R749 VDD.n1223 VDD.t485 17.3167
R750 VDD.n1222 VDD.t488 17.3167
R751 VDD.n1211 VDD.t482 17.3167
R752 VDD.n1220 VDD.t460 17.3167
R753 VDD.n1219 VDD.t461 17.3167
R754 VDD.n1218 VDD.t458 17.3167
R755 VDD.n1213 VDD.t459 17.3167
R756 VDD.n1217 VDD.t526 17.3167
R757 VDD.n1216 VDD.t527 17.3167
R758 VDD.n1214 VDD.t147 17.3167
R759 VDD.n1419 VDD.t858 17.3167
R760 VDD.n1418 VDD.t36 17.3167
R761 VDD.n1416 VDD.t35 17.3167
R762 VDD.n1135 VDD.t861 17.3167
R763 VDD.n1136 VDD.t859 17.3167
R764 VDD.n1188 VDD.t862 17.3167
R765 VDD.n1187 VDD.t860 17.3167
R766 VDD.n1137 VDD.t1074 17.3167
R767 VDD.n1138 VDD.t1079 17.3167
R768 VDD.n1184 VDD.t1077 17.3167
R769 VDD.n1183 VDD.t1075 17.3167
R770 VDD.n1139 VDD.t1072 17.3167
R771 VDD.n1422 VDD.t1076 17.3167
R772 VDD.n1181 VDD.t1078 17.3167
R773 VDD.n1180 VDD.t1073 17.3167
R774 VDD.n1179 VDD.t833 17.3167
R775 VDD.n1141 VDD.t117 17.3167
R776 VDD.n1143 VDD.t116 17.3167
R777 VDD.n1178 VDD.t72 17.3167
R778 VDD.n1177 VDD.t73 17.3167
R779 VDD.n1176 VDD.t74 17.3167
R780 VDD.n1145 VDD.t71 17.3167
R781 VDD.n1175 VDD.t656 17.3167
R782 VDD.n1174 VDD.t659 17.3167
R783 VDD.n1173 VDD.t657 17.3167
R784 VDD.n1147 VDD.t661 17.3167
R785 VDD.n1172 VDD.t660 17.3167
R786 VDD.n1171 VDD.t655 17.3167
R787 VDD.n1170 VDD.t658 17.3167
R788 VDD.n1149 VDD.t662 17.3167
R789 VDD.n1168 VDD.t172 17.3167
R790 VDD.n1167 VDD.t164 17.3167
R791 VDD.n1165 VDD.t165 17.3167
R792 VDD.n1150 VDD.t112 17.3167
R793 VDD.n1151 VDD.t114 17.3167
R794 VDD.n1163 VDD.t113 17.3167
R795 VDD.n1162 VDD.t115 17.3167
R796 VDD.n1152 VDD.t146 17.3167
R797 VDD.n1153 VDD.t142 17.3167
R798 VDD.n1160 VDD.t139 17.3167
R799 VDD.n1159 VDD.t144 17.3167
R800 VDD.n1154 VDD.t143 17.3167
R801 VDD.n1155 VDD.t141 17.3167
R802 VDD.n1157 VDD.t140 17.3167
R803 VDD.n1156 VDD.t145 17.3167
R804 VDD.n1468 VDD.t498 17.3167
R805 VDD.n1467 VDD.t495 17.3167
R806 VDD.n1466 VDD.t500 17.3167
R807 VDD.n1066 VDD.t501 17.3167
R808 VDD.n1465 VDD.t499 17.3167
R809 VDD.n1471 VDD.t496 17.3167
R810 VDD.n1067 VDD.t502 17.3167
R811 VDD.n1069 VDD.t497 17.3167
R812 VDD.n1463 VDD.t298 17.3167
R813 VDD.n1119 VDD.t299 17.3167
R814 VDD.n1070 VDD.t300 17.3167
R815 VDD.n1071 VDD.t297 17.3167
R816 VDD.n1117 VDD.t170 17.3167
R817 VDD.n1116 VDD.t171 17.3167
R818 VDD.n1073 VDD.t775 17.3167
R819 VDD.n1074 VDD.t158 17.3167
R820 VDD.n1076 VDD.t162 17.3167
R821 VDD.n1114 VDD.t161 17.3167
R822 VDD.n1113 VDD.t157 17.3167
R823 VDD.n1077 VDD.t156 17.3167
R824 VDD.n1078 VDD.t159 17.3167
R825 VDD.n1111 VDD.t160 17.3167
R826 VDD.n1110 VDD.t163 17.3167
R827 VDD.n1109 VDD.t1 17.3167
R828 VDD.n1080 VDD.t3 17.3167
R829 VDD.n1108 VDD.t2 17.3167
R830 VDD.n1107 VDD.t4 17.3167
R831 VDD.n1106 VDD.t515 17.3167
R832 VDD.n1082 VDD.t514 17.3167
R833 VDD.n1104 VDD.t1149 17.3167
R834 VDD.n1103 VDD.t534 17.3167
R835 VDD.n1101 VDD.t531 17.3167
R836 VDD.n1100 VDD.t528 17.3167
R837 VDD.n1084 VDD.t529 17.3167
R838 VDD.n1099 VDD.t535 17.3167
R839 VDD.n1098 VDD.t532 17.3167
R840 VDD.n1097 VDD.t530 17.3167
R841 VDD.n1086 VDD.t533 17.3167
R842 VDD.n1095 VDD.t32 17.3167
R843 VDD.n1094 VDD.t30 17.3167
R844 VDD.n1087 VDD.t33 17.3167
R845 VDD.n1088 VDD.t31 17.3167
R846 VDD.n1092 VDD.t773 17.3167
R847 VDD.n1091 VDD.t774 17.3167
R848 VDD.n1089 VDD.t1147 17.3167
R849 VDD.n1499 VDD.t1252 17.3167
R850 VDD.n998 VDD.t1253 17.3167
R851 VDD.n997 VDD.t825 17.3167
R852 VDD.n1502 VDD.t829 17.3167
R853 VDD.n1495 VDD.t918 17.3167
R854 VDD.n1001 VDD.t919 17.3167
R855 VDD.n1000 VDD.t1067 17.3167
R856 VDD.n1498 VDD.t1068 17.3167
R857 VDD.n1491 VDD.t1136 17.3167
R858 VDD.n1490 VDD.t1137 17.3167
R859 VDD.n1489 VDD.t1145 17.3167
R860 VDD.n1494 VDD.t1146 17.3167
R861 VDD.n1902 VDD.t706 17.3167
R862 VDD.n1899 VDD.t705 17.3167
R863 VDD.n1896 VDD.t746 17.3167
R864 VDD.n1897 VDD.t728 17.3167
R865 VDD.n942 VDD.t738 17.3167
R866 VDD.n939 VDD.t692 17.3167
R867 VDD.n841 VDD.t736 17.3167
R868 VDD.n840 VDD.t717 17.3167
R869 VDD.n1907 VDD.t682 17.3167
R870 VDD.n937 VDD.t716 17.3167
R871 VDD.n934 VDD.t730 17.3167
R872 VDD.n935 VDD.t680 17.3167
R873 VDD.n1834 VDD.t691 17.3167
R874 VDD.n931 VDD.t707 17.3167
R875 VDD.n928 VDD.t720 17.3167
R876 VDD.n929 VDD.t887 17.3167
R877 VDD.n1594 VDD.t888 17.3167
R878 VDD.n925 VDD.t879 17.3167
R879 VDD.n922 VDD.t878 17.3167
R880 VDD.n923 VDD.t867 17.3167
R881 VDD.n1584 VDD.t866 17.3167
R882 VDD.n919 VDD.t872 17.3167
R883 VDD.n916 VDD.t874 17.3167
R884 VDD.n917 VDD.t904 17.3167
R885 VDD.n1574 VDD.t902 17.3167
R886 VDD.n913 VDD.t905 17.3167
R887 VDD.n910 VDD.t906 17.3167
R888 VDD.n911 VDD.t909 17.3167
R889 VDD.n1564 VDD.t908 17.3167
R890 VDD.n907 VDD.t863 17.3167
R891 VDD.n904 VDD.t865 17.3167
R892 VDD.n905 VDD.t1237 17.3167
R893 VDD.n1554 VDD.t1238 17.3167
R894 VDD.n901 VDD.t1240 17.3167
R895 VDD.n898 VDD.t1241 17.3167
R896 VDD.n899 VDD.t1243 17.3167
R897 VDD.n1544 VDD.t1244 17.3167
R898 VDD.n895 VDD.t1213 17.3167
R899 VDD.n892 VDD.t1214 17.3167
R900 VDD.n893 VDD.t1212 17.3167
R901 VDD.n1534 VDD.t1210 17.3167
R902 VDD.n889 VDD.t1231 17.3167
R903 VDD.n886 VDD.t1233 17.3167
R904 VDD.n887 VDD.t1209 17.3167
R905 VDD.n1524 VDD.t1207 17.3167
R906 VDD.n883 VDD.t1228 17.3167
R907 VDD.n853 VDD.t1229 17.3167
R908 VDD.n881 VDD.t1023 17.3167
R909 VDD.n1514 VDD.t1022 17.3167
R910 VDD.n878 VDD.t1034 17.3167
R911 VDD.n875 VDD.t1035 17.3167
R912 VDD.n876 VDD.t1026 17.3167
R913 VDD.n993 VDD.t1025 17.3167
R914 VDD.n872 VDD.t1038 17.3167
R915 VDD.n869 VDD.t1037 17.3167
R916 VDD.n870 VDD.t1017 17.3167
R917 VDD.n983 VDD.t1016 17.3167
R918 VDD.n866 VDD.t1031 17.3167
R919 VDD.n863 VDD.t1032 17.3167
R920 VDD.n864 VDD.t1019 17.3167
R921 VDD.n862 VDD.t1020 17.3167
R922 VDD.n859 VDD.t1028 17.3167
R923 VDD.n857 VDD.t1029 17.3167
R924 VDD.n1619 VDD.t701 17.3167
R925 VDD.n1616 VDD.t676 17.3167
R926 VDD.n946 VDD.t700 17.3167
R927 VDD.n945 VDD.t675 17.3167
R928 VDD.n1891 VDD.t690 17.3167
R929 VDD.n1614 VDD.t745 17.3167
R930 VDD.n1611 VDD.t689 17.3167
R931 VDD.n1612 VDD.t764 17.3167
R932 VDD.n1609 VDD.t737 17.3167
R933 VDD.n1606 VDD.t713 17.3167
R934 VDD.n1603 VDD.t681 17.3167
R935 VDD.n1604 VDD.t735 17.3167
R936 VDD.n1837 VDD.t703 17.3167
R937 VDD.n1600 VDD.t702 17.3167
R938 VDD.n1597 VDD.t767 17.3167
R939 VDD.n1598 VDD.t877 17.3167
R940 VDD.n1593 VDD.t875 17.3167
R941 VDD.n1590 VDD.t896 17.3167
R942 VDD.n1587 VDD.t898 17.3167
R943 VDD.n1588 VDD.t890 17.3167
R944 VDD.n1583 VDD.t891 17.3167
R945 VDD.n1580 VDD.t869 17.3167
R946 VDD.n1577 VDD.t871 17.3167
R947 VDD.n1578 VDD.t900 17.3167
R948 VDD.n1573 VDD.t899 17.3167
R949 VDD.n1570 VDD.t885 17.3167
R950 VDD.n1567 VDD.t884 17.3167
R951 VDD.n1568 VDD.t883 17.3167
R952 VDD.n1563 VDD.t881 17.3167
R953 VDD.n1560 VDD.t893 17.3167
R954 VDD.n1557 VDD.t894 17.3167
R955 VDD.n1558 VDD.t1224 17.3167
R956 VDD.n1553 VDD.t1222 17.3167
R957 VDD.n1550 VDD.t1201 17.3167
R958 VDD.n1547 VDD.t1203 17.3167
R959 VDD.n1548 VDD.t1235 17.3167
R960 VDD.n1543 VDD.t1234 17.3167
R961 VDD.n1540 VDD.t1225 17.3167
R962 VDD.n1537 VDD.t1227 17.3167
R963 VDD.n1538 VDD.t1198 17.3167
R964 VDD.n1533 VDD.t1199 17.3167
R965 VDD.n1530 VDD.t1216 17.3167
R966 VDD.n1527 VDD.t1217 17.3167
R967 VDD.n1528 VDD.t1219 17.3167
R968 VDD.n1523 VDD.t1220 17.3167
R969 VDD.n1520 VDD.t1205 17.3167
R970 VDD.n1517 VDD.t1204 17.3167
R971 VDD.n1518 VDD.t101 17.3167
R972 VDD.n1513 VDD.t104 17.3167
R973 VDD.n1510 VDD.t100 17.3167
R974 VDD.n1507 VDD.t103 17.3167
R975 VDD.n1508 VDD.t111 17.3167
R976 VDD.n992 VDD.t102 17.3167
R977 VDD.n989 VDD.t105 17.3167
R978 VDD.n986 VDD.t108 17.3167
R979 VDD.n987 VDD.t340 17.3167
R980 VDD.n982 VDD.t336 17.3167
R981 VDD.n979 VDD.t333 17.3167
R982 VDD.n976 VDD.t338 17.3167
R983 VDD.n977 VDD.t328 17.3167
R984 VDD.n975 VDD.t325 17.3167
R985 VDD.n972 VDD.t324 17.3167
R986 VDD.n969 VDD.t326 17.3167
R987 VDD.n970 VDD.t1249 17.3167
R988 VDD.n968 VDD.t1250 17.3167
R989 VDD.n965 VDD.t1247 17.3167
R990 VDD.n963 VDD.t1246 17.3167
R991 VDD.n1883 VDD.t721 17.3167
R992 VDD.n1879 VDD.t694 17.3167
R993 VDD.n1876 VDD.t719 17.3167
R994 VDD.n1877 VDD.t693 17.3167
R995 VDD.n1874 VDD.t709 17.3167
R996 VDD.n1871 VDD.t686 17.3167
R997 VDD.n1868 VDD.t708 17.3167
R998 VDD.n1869 VDD.t684 17.3167
R999 VDD.n1636 VDD.t753 17.3167
R1000 VDD.n1633 VDD.t683 17.3167
R1001 VDD.n1630 VDD.t698 17.3167
R1002 VDD.n1631 VDD.t750 17.3167
R1003 VDD.n1840 VDD.t725 17.3167
R1004 VDD.n1627 VDD.t674 17.3167
R1005 VDD.n1625 VDD.t688 17.3167
R1006 VDD.n1859 VDD.t697 17.3167
R1007 VDD.n1857 VDD.t696 17.3167
R1008 VDD.n1854 VDD.t740 17.3167
R1009 VDD.n1855 VDD.t722 17.3167
R1010 VDD.n1852 VDD.t734 17.3167
R1011 VDD.n1849 VDD.t687 17.3167
R1012 VDD.n1640 VDD.t732 17.3167
R1013 VDD.n1639 VDD.t711 17.3167
R1014 VDD.n1864 VDD.t678 17.3167
R1015 VDD.n1847 VDD.t710 17.3167
R1016 VDD.n1844 VDD.t727 17.3167
R1017 VDD.n1845 VDD.t770 17.3167
R1018 VDD.n1648 VDD.t685 17.3167
R1019 VDD.n1645 VDD.t699 17.3167
R1020 VDD.n1643 VDD.t714 17.3167
R1021 VDD.n144 VDD.t365 17.3167
R1022 VDD.n141 VDD.t345 17.3167
R1023 VDD.n6 VDD.t433 17.3167
R1024 VDD.n5 VDD.t369 17.3167
R1025 VDD.n2067 VDD.t414 17.3167
R1026 VDD.n139 VDD.t370 17.3167
R1027 VDD.n136 VDD.t352 17.3167
R1028 VDD.n137 VDD.t383 17.3167
R1029 VDD.n165 VDD.t386 17.3167
R1030 VDD.n133 VDD.t355 17.3167
R1031 VDD.n130 VDD.t377 17.3167
R1032 VDD.n131 VDD.t432 17.3167
R1033 VDD.n1801 VDD.t356 17.3167
R1034 VDD.n127 VDD.t373 17.3167
R1035 VDD.n124 VDD.t394 17.3167
R1036 VDD.n125 VDD.t946 17.3167
R1037 VDD.n1789 VDD.t944 17.3167
R1038 VDD.n121 VDD.t933 17.3167
R1039 VDD.n118 VDD.t932 17.3167
R1040 VDD.n119 VDD.t948 17.3167
R1041 VDD.n1778 VDD.t947 17.3167
R1042 VDD.n115 VDD.t942 17.3167
R1043 VDD.n112 VDD.t941 17.3167
R1044 VDD.n113 VDD.t923 17.3167
R1045 VDD.n1767 VDD.t924 17.3167
R1046 VDD.n109 VDD.t959 17.3167
R1047 VDD.n106 VDD.t960 17.3167
R1048 VDD.n107 VDD.t962 17.3167
R1049 VDD.n1756 VDD.t963 17.3167
R1050 VDD.n103 VDD.t929 17.3167
R1051 VDD.n100 VDD.t930 17.3167
R1052 VDD.n101 VDD.t1120 17.3167
R1053 VDD.n1745 VDD.t1119 17.3167
R1054 VDD.n97 VDD.t1099 17.3167
R1055 VDD.n94 VDD.t1098 17.3167
R1056 VDD.n95 VDD.t1092 17.3167
R1057 VDD.n1734 VDD.t1093 17.3167
R1058 VDD.n91 VDD.t1113 17.3167
R1059 VDD.n88 VDD.t1114 17.3167
R1060 VDD.n89 VDD.t1109 17.3167
R1061 VDD.n1723 VDD.t1107 17.3167
R1062 VDD.n85 VDD.t1080 17.3167
R1063 VDD.n82 VDD.t1082 17.3167
R1064 VDD.n83 VDD.t1104 17.3167
R1065 VDD.n1712 VDD.t1105 17.3167
R1066 VDD.n79 VDD.t1126 17.3167
R1067 VDD.n76 VDD.t1125 17.3167
R1068 VDD.n77 VDD.t64 17.3167
R1069 VDD.n1701 VDD.t62 17.3167
R1070 VDD.n73 VDD.t60 17.3167
R1071 VDD.n70 VDD.t63 17.3167
R1072 VDD.n71 VDD.t67 17.3167
R1073 VDD.n1690 VDD.t59 17.3167
R1074 VDD.n67 VDD.t61 17.3167
R1075 VDD.n64 VDD.t69 17.3167
R1076 VDD.n65 VDD.t8 17.3167
R1077 VDD.n1679 VDD.t6 17.3167
R1078 VDD.n61 VDD.t12 17.3167
R1079 VDD.n58 VDD.t7 17.3167
R1080 VDD.n59 VDD.t911 17.3167
R1081 VDD.n27 VDD.t912 17.3167
R1082 VDD.n24 VDD.t914 17.3167
R1083 VDD.n22 VDD.t915 17.3167
R1084 VDD.n52 VDD.n40 17.0005
R1085 VDD.n52 VDD.n45 17.0005
R1086 VDD.n52 VDD.n39 17.0005
R1087 VDD.n52 VDD.n49 17.0005
R1088 VDD.n33 VDD.n32 17.0005
R1089 VDD.n2057 VDD.n156 17.0005
R1090 VDD.n2057 VDD.n162 17.0005
R1091 VDD.n2057 VDD.n2048 17.0005
R1092 VDD.n2057 VDD.n2056 17.0005
R1093 VDD.n2037 VDD.n178 17.0005
R1094 VDD.n2037 VDD.n184 17.0005
R1095 VDD.n2037 VDD.n186 17.0005
R1096 VDD.n2037 VDD.n2032 17.0005
R1097 VDD.n340 VDD.n339 17.0005
R1098 VDD.n331 VDD.n330 17.0005
R1099 VDD.n2021 VDD.n212 17.0005
R1100 VDD.n2021 VDD.n219 17.0005
R1101 VDD.n2021 VDD.n225 17.0005
R1102 VDD.n2021 VDD.n231 17.0005
R1103 VDD.n2021 VDD.n205 17.0005
R1104 VDD.n2021 VDD.n236 17.0005
R1105 VDD.n2021 VDD.n242 17.0005
R1106 VDD.n2021 VDD.n248 17.0005
R1107 VDD.n2021 VDD.n254 17.0005
R1108 VDD.n2021 VDD.n260 17.0005
R1109 VDD.n2021 VDD.n266 17.0005
R1110 VDD.n2021 VDD.n272 17.0005
R1111 VDD.n2021 VDD.n278 17.0005
R1112 VDD.n2021 VDD.n284 17.0005
R1113 VDD.n2021 VDD.n290 17.0005
R1114 VDD.n2021 VDD.n298 17.0005
R1115 VDD.n2021 VDD.n300 17.0005
R1116 VDD.n2013 VDD.n323 17.0005
R1117 VDD.n2013 VDD.n350 17.0005
R1118 VDD.n2013 VDD.n360 17.0005
R1119 VDD.n2013 VDD.n370 17.0005
R1120 VDD.n2013 VDD.n380 17.0005
R1121 VDD.n2013 VDD.n390 17.0005
R1122 VDD.n2013 VDD.n400 17.0005
R1123 VDD.n2013 VDD.n410 17.0005
R1124 VDD.n2013 VDD.n420 17.0005
R1125 VDD.n2013 VDD.n430 17.0005
R1126 VDD.n2013 VDD.n440 17.0005
R1127 VDD.n2013 VDD.n450 17.0005
R1128 VDD.n2013 VDD.n460 17.0005
R1129 VDD.n2013 VDD.n466 17.0005
R1130 VDD.n2013 VDD.n2004 17.0005
R1131 VDD.n2013 VDD.n2012 17.0005
R1132 VDD.n1993 VDD.n479 17.0005
R1133 VDD.n1993 VDD.n485 17.0005
R1134 VDD.n1993 VDD.n487 17.0005
R1135 VDD.n1993 VDD.n1988 17.0005
R1136 VDD.n1977 VDD.n500 17.0005
R1137 VDD.n1977 VDD.n506 17.0005
R1138 VDD.n1977 VDD.n514 17.0005
R1139 VDD.n1977 VDD.n516 17.0005
R1140 VDD.n670 VDD.n664 17.0005
R1141 VDD.n670 VDD.n663 17.0005
R1142 VDD.n670 VDD.n667 17.0005
R1143 VDD.n1969 VDD.n540 17.0005
R1144 VDD.n1969 VDD.n547 17.0005
R1145 VDD.n1969 VDD.n553 17.0005
R1146 VDD.n1969 VDD.n559 17.0005
R1147 VDD.n1969 VDD.n533 17.0005
R1148 VDD.n1969 VDD.n564 17.0005
R1149 VDD.n1969 VDD.n570 17.0005
R1150 VDD.n1969 VDD.n576 17.0005
R1151 VDD.n1969 VDD.n582 17.0005
R1152 VDD.n1969 VDD.n588 17.0005
R1153 VDD.n1969 VDD.n594 17.0005
R1154 VDD.n1969 VDD.n600 17.0005
R1155 VDD.n1969 VDD.n606 17.0005
R1156 VDD.n1969 VDD.n612 17.0005
R1157 VDD.n1969 VDD.n618 17.0005
R1158 VDD.n1969 VDD.n1960 17.0005
R1159 VDD.n1969 VDD.n1968 17.0005
R1160 VDD.n1949 VDD.n644 17.0005
R1161 VDD.n1949 VDD.n651 17.0005
R1162 VDD.n1949 VDD.n658 17.0005
R1163 VDD.n1949 VDD.n680 17.0005
R1164 VDD.n1949 VDD.n690 17.0005
R1165 VDD.n1949 VDD.n700 17.0005
R1166 VDD.n1949 VDD.n710 17.0005
R1167 VDD.n1949 VDD.n720 17.0005
R1168 VDD.n1949 VDD.n730 17.0005
R1169 VDD.n1949 VDD.n740 17.0005
R1170 VDD.n1949 VDD.n750 17.0005
R1171 VDD.n1949 VDD.n760 17.0005
R1172 VDD.n1949 VDD.n770 17.0005
R1173 VDD.n1949 VDD.n780 17.0005
R1174 VDD.n1949 VDD.n786 17.0005
R1175 VDD.n1949 VDD.n788 17.0005
R1176 VDD.n1949 VDD.n1944 17.0005
R1177 VDD.n1933 VDD.n801 17.0005
R1178 VDD.n1933 VDD.n807 17.0005
R1179 VDD.n1933 VDD.n815 17.0005
R1180 VDD.n1933 VDD.n817 17.0005
R1181 VDD.n1925 VDD.n828 17.0005
R1182 VDD.n1925 VDD.n834 17.0005
R1183 VDD.n1925 VDD.n1916 17.0005
R1184 VDD.n1925 VDD.n1924 17.0005
R1185 VDD.n1327 VDD.t1379 17.0005
R1186 VDD.n1328 VDD.t1366 17.0005
R1187 VDD.n1324 VDD.t1356 17.0005
R1188 VDD.n1325 VDD.t1343 17.0005
R1189 VDD.n1320 VDD.t1365 17.0005
R1190 VDD.n1321 VDD.t1348 17.0005
R1191 VDD.n1276 VDD.t1358 17.0005
R1192 VDD.n1277 VDD.t1346 17.0005
R1193 VDD.n1278 VDD.t1351 17.0005
R1194 VDD.n1279 VDD.t1362 17.0005
R1195 VDD.n1316 VDD.t1357 17.0005
R1196 VDD.n1317 VDD.t1345 17.0005
R1197 VDD.n1303 VDD.t1359 17.0005
R1198 VDD.n1304 VDD.t1344 17.0005
R1199 VDD.n1299 VDD.t1352 17.0005
R1200 VDD.n1300 VDD.t1355 17.0005
R1201 VDD.n1296 VDD.t1349 17.0005
R1202 VDD.n1297 VDD.t1364 17.0005
R1203 VDD.n1285 VDD.t1353 17.0005
R1204 VDD.n1286 VDD.t1354 17.0005
R1205 VDD.n1282 VDD.t1360 17.0005
R1206 VDD.n1283 VDD.t1347 17.0005
R1207 VDD.n1330 VDD.n1281 17.0005
R1208 VDD.n1385 VDD.t1403 17.0005
R1209 VDD.n1386 VDD.t1389 17.0005
R1210 VDD.n1382 VDD.t1417 17.0005
R1211 VDD.n1383 VDD.t1399 17.0005
R1212 VDD.n1378 VDD.t1393 17.0005
R1213 VDD.n1379 VDD.t1396 17.0005
R1214 VDD.n1454 VDD.t1330 17.0005
R1215 VDD.n1455 VDD.t1316 17.0005
R1216 VDD.n1451 VDD.t1308 17.0005
R1217 VDD.n1452 VDD.t1333 17.0005
R1218 VDD.n1447 VDD.t1303 17.0005
R1219 VDD.n1448 VDD.t1311 17.0005
R1220 VDD.n1442 VDD.t1309 17.0005
R1221 VDD.n1443 VDD.t1305 17.0005
R1222 VDD.n1438 VDD.t1315 17.0005
R1223 VDD.n1439 VDD.t1310 17.0005
R1224 VDD.n1434 VDD.t1312 17.0005
R1225 VDD.n1435 VDD.t1317 17.0005
R1226 VDD.n1121 VDD.t1318 17.0005
R1227 VDD.n1122 VDD.t1325 17.0005
R1228 VDD.n1124 VDD.t1304 17.0005
R1229 VDD.n1125 VDD.t1306 17.0005
R1230 VDD.n1429 VDD.t1328 17.0005
R1231 VDD.n1430 VDD.t1313 17.0005
R1232 VDD.n1130 VDD.t1323 17.0005
R1233 VDD.n1131 VDD.t1307 17.0005
R1234 VDD.n1127 VDD.t1314 17.0005
R1235 VDD.n1128 VDD.t1337 17.0005
R1236 VDD.n1458 VDD.n1457 17.0005
R1237 VDD.n1494 VDD.n1493 17.0005
R1238 VDD.n1493 VDD.n1490 17.0005
R1239 VDD.n1498 VDD.n1497 17.0005
R1240 VDD.n1497 VDD.n1001 17.0005
R1241 VDD.n1502 VDD.n1501 17.0005
R1242 VDD.n1501 VDD.n998 17.0005
R1243 VDD.n1483 VDD.n1003 17.0005
R1244 VDD.n1348 VDD.n1345 17.0005
R1245 VDD.n1241 VDD.t1387 17.0005
R1246 VDD.n1242 VDD.t1390 17.0005
R1247 VDD.n1243 VDD.t1394 17.0005
R1248 VDD.n1244 VDD.t1397 17.0005
R1249 VDD.n1374 VDD.t1386 17.0005
R1250 VDD.n1375 VDD.t1400 17.0005
R1251 VDD.n1268 VDD.t1384 17.0005
R1252 VDD.n1269 VDD.t1391 17.0005
R1253 VDD.n1264 VDD.t1401 17.0005
R1254 VDD.n1265 VDD.t1385 17.0005
R1255 VDD.n1261 VDD.t1383 17.0005
R1256 VDD.n1262 VDD.t1392 17.0005
R1257 VDD.n1250 VDD.t1388 17.0005
R1258 VDD.n1251 VDD.t1398 17.0005
R1259 VDD.n1247 VDD.t1410 17.0005
R1260 VDD.n1248 VDD.t1395 17.0005
R1261 VDD.n1388 VDD.n1246 17.0005
R1262 VDD.n1470 VDD.n1091 17.0005
R1263 VDD.n1470 VDD.n1088 17.0005
R1264 VDD.n1470 VDD 17.0005
R1265 VDD.n1470 VDD.n1087 17.0005
R1266 VDD.n1470 VDD.n1094 17.0005
R1267 VDD.n1470 VDD.n1086 17.0005
R1268 VDD.n1470 VDD.n1098 17.0005
R1269 VDD.n1470 VDD 17.0005
R1270 VDD.n1470 VDD.n1099 17.0005
R1271 VDD.n1470 VDD.n1084 17.0005
R1272 VDD.n1470 VDD.n1101 17.0005
R1273 VDD.n1470 VDD.n1082 17.0005
R1274 VDD.n1470 VDD.n1107 17.0005
R1275 VDD.n1470 VDD 17.0005
R1276 VDD.n1470 VDD.n1108 17.0005
R1277 VDD.n1470 VDD.n1080 17.0005
R1278 VDD.n1470 VDD.n1110 17.0005
R1279 VDD.n1470 VDD.n1078 17.0005
R1280 VDD.n1470 VDD 17.0005
R1281 VDD.n1470 VDD.n1077 17.0005
R1282 VDD.n1470 VDD.n1113 17.0005
R1283 VDD.n1470 VDD.n1076 17.0005
R1284 VDD.n1470 VDD.n1116 17.0005
R1285 VDD.n1470 VDD.n1071 17.0005
R1286 VDD.n1470 VDD 17.0005
R1287 VDD.n1470 VDD.n1070 17.0005
R1288 VDD.n1470 VDD.n1119 17.0005
R1289 VDD.n1470 VDD.n1069 17.0005
R1290 VDD.n1471 VDD.n1470 17.0005
R1291 VDD.n1470 VDD 17.0005
R1292 VDD.n1470 VDD.n1465 17.0005
R1293 VDD.n1470 VDD.n1066 17.0005
R1294 VDD.n1470 VDD.n1467 17.0005
R1295 VDD.n1421 VDD.n1156 17.0005
R1296 VDD.n1421 VDD.n1155 17.0005
R1297 VDD.n1421 VDD 17.0005
R1298 VDD.n1421 VDD.n1154 17.0005
R1299 VDD.n1421 VDD.n1159 17.0005
R1300 VDD.n1421 VDD.n1153 17.0005
R1301 VDD.n1421 VDD 17.0005
R1302 VDD.n1421 VDD.n1152 17.0005
R1303 VDD.n1421 VDD.n1162 17.0005
R1304 VDD.n1421 VDD.n1151 17.0005
R1305 VDD.n1421 VDD 17.0005
R1306 VDD.n1421 VDD.n1150 17.0005
R1307 VDD.n1421 VDD.n1165 17.0005
R1308 VDD.n1421 VDD.n1149 17.0005
R1309 VDD.n1421 VDD.n1171 17.0005
R1310 VDD.n1421 VDD 17.0005
R1311 VDD.n1421 VDD.n1172 17.0005
R1312 VDD.n1421 VDD.n1147 17.0005
R1313 VDD.n1421 VDD.n1174 17.0005
R1314 VDD.n1421 VDD 17.0005
R1315 VDD.n1421 VDD.n1175 17.0005
R1316 VDD.n1421 VDD.n1145 17.0005
R1317 VDD.n1421 VDD.n1177 17.0005
R1318 VDD.n1421 VDD 17.0005
R1319 VDD.n1421 VDD.n1178 17.0005
R1320 VDD.n1421 VDD.n1143 17.0005
R1321 VDD.n1421 VDD.n1180 17.0005
R1322 VDD.n1422 VDD.n1421 17.0005
R1323 VDD.n1421 VDD 17.0005
R1324 VDD.n1421 VDD.n1139 17.0005
R1325 VDD.n1421 VDD.n1183 17.0005
R1326 VDD.n1421 VDD.n1138 17.0005
R1327 VDD.n1421 VDD 17.0005
R1328 VDD.n1421 VDD.n1137 17.0005
R1329 VDD.n1421 VDD.n1187 17.0005
R1330 VDD.n1421 VDD.n1136 17.0005
R1331 VDD.n1421 VDD 17.0005
R1332 VDD.n1421 VDD.n1135 17.0005
R1333 VDD.n1421 VDD.n1416 17.0005
R1334 VDD.n1411 VDD.n1216 17.0005
R1335 VDD.n1411 VDD 17.0005
R1336 VDD.n1411 VDD.n1217 17.0005
R1337 VDD.n1411 VDD.n1213 17.0005
R1338 VDD.n1411 VDD.n1219 17.0005
R1339 VDD.n1411 VDD.n1211 17.0005
R1340 VDD.n1411 VDD.n1223 17.0005
R1341 VDD.n1411 VDD 17.0005
R1342 VDD.n1411 VDD.n1224 17.0005
R1343 VDD.n1411 VDD.n1209 17.0005
R1344 VDD.n1411 VDD.n1226 17.0005
R1345 VDD.n1411 VDD.n1207 17.0005
R1346 VDD.n1411 VDD 17.0005
R1347 VDD.n1411 VDD.n1206 17.0005
R1348 VDD.n1411 VDD.n1231 17.0005
R1349 VDD.n1411 VDD.n1205 17.0005
R1350 VDD.n1411 VDD.n1235 17.0005
R1351 VDD.n1411 VDD.n1203 17.0005
R1352 VDD.n1411 VDD 17.0005
R1353 VDD.n1411 VDD.n1202 17.0005
R1354 VDD.n1411 VDD.n1396 17.0005
R1355 VDD.n1411 VDD.n1201 17.0005
R1356 VDD.n1411 VDD.n1399 17.0005
R1357 VDD.n1411 VDD 17.0005
R1358 VDD.n1411 VDD.n1400 17.0005
R1359 VDD.n1411 VDD.n1196 17.0005
R1360 VDD.n1411 VDD.n1402 17.0005
R1361 VDD.n1411 VDD.n1194 17.0005
R1362 VDD.n1412 VDD.n1411 17.0005
R1363 VDD.n1411 VDD 17.0005
R1364 VDD.n1411 VDD.n1406 17.0005
R1365 VDD.n1411 VDD.n1191 17.0005
R1366 VDD.n1411 VDD.n1408 17.0005
R1367 VDD.n1481 VDD.n1030 17.0005
R1368 VDD.n1481 VDD.n1029 17.0005
R1369 VDD.n1481 VDD 17.0005
R1370 VDD.n1481 VDD.n1028 17.0005
R1371 VDD.n1481 VDD.n1033 17.0005
R1372 VDD.n1481 VDD.n1027 17.0005
R1373 VDD.n1481 VDD 17.0005
R1374 VDD.n1481 VDD.n1026 17.0005
R1375 VDD.n1481 VDD.n1036 17.0005
R1376 VDD.n1481 VDD.n1025 17.0005
R1377 VDD.n1481 VDD 17.0005
R1378 VDD.n1481 VDD.n1024 17.0005
R1379 VDD.n1481 VDD.n1039 17.0005
R1380 VDD.n1481 VDD.n1023 17.0005
R1381 VDD.n1481 VDD.n1045 17.0005
R1382 VDD.n1481 VDD 17.0005
R1383 VDD.n1481 VDD.n1046 17.0005
R1384 VDD.n1481 VDD.n1021 17.0005
R1385 VDD.n1481 VDD.n1048 17.0005
R1386 VDD.n1481 VDD 17.0005
R1387 VDD.n1481 VDD.n1049 17.0005
R1388 VDD.n1481 VDD.n1019 17.0005
R1389 VDD.n1481 VDD.n1051 17.0005
R1390 VDD.n1481 VDD 17.0005
R1391 VDD.n1481 VDD.n1052 17.0005
R1392 VDD.n1481 VDD.n1017 17.0005
R1393 VDD.n1481 VDD.n1054 17.0005
R1394 VDD.n1481 VDD.n1013 17.0005
R1395 VDD.n1481 VDD 17.0005
R1396 VDD.n1481 VDD.n1012 17.0005
R1397 VDD.n1481 VDD.n1057 17.0005
R1398 VDD.n1481 VDD.n1011 17.0005
R1399 VDD.n1481 VDD 17.0005
R1400 VDD.n1481 VDD.n1010 17.0005
R1401 VDD.n1481 VDD.n1061 17.0005
R1402 VDD.n1481 VDD.n1009 17.0005
R1403 VDD.n1481 VDD 17.0005
R1404 VDD.n1481 VDD.n1008 17.0005
R1405 VDD.n1481 VDD.n1476 17.0005
R1406 VDD.n1905 VDD.n860 17.0005
R1407 VDD.n1905 VDD.n867 17.0005
R1408 VDD.n1905 VDD.n873 17.0005
R1409 VDD.n1905 VDD.n879 17.0005
R1410 VDD.n1905 VDD.n853 17.0005
R1411 VDD.n1905 VDD.n884 17.0005
R1412 VDD.n1905 VDD.n890 17.0005
R1413 VDD.n1905 VDD.n896 17.0005
R1414 VDD.n1905 VDD.n902 17.0005
R1415 VDD.n1905 VDD.n908 17.0005
R1416 VDD.n1905 VDD.n914 17.0005
R1417 VDD.n1905 VDD.n920 17.0005
R1418 VDD.n1905 VDD.n926 17.0005
R1419 VDD.n1905 VDD.n932 17.0005
R1420 VDD.n1905 VDD.n938 17.0005
R1421 VDD.n1905 VDD.n940 17.0005
R1422 VDD.n1905 VDD.n1900 17.0005
R1423 VDD.n1889 VDD.n966 17.0005
R1424 VDD.n1889 VDD.n973 17.0005
R1425 VDD.n1889 VDD.n980 17.0005
R1426 VDD.n1889 VDD.n990 17.0005
R1427 VDD.n1889 VDD.n1511 17.0005
R1428 VDD.n1889 VDD.n1521 17.0005
R1429 VDD.n1889 VDD.n1531 17.0005
R1430 VDD.n1889 VDD.n1541 17.0005
R1431 VDD.n1889 VDD.n1551 17.0005
R1432 VDD.n1889 VDD.n1561 17.0005
R1433 VDD.n1889 VDD.n1571 17.0005
R1434 VDD.n1889 VDD.n1581 17.0005
R1435 VDD.n1889 VDD.n1591 17.0005
R1436 VDD.n1889 VDD.n1601 17.0005
R1437 VDD.n1889 VDD.n1607 17.0005
R1438 VDD.n1889 VDD.n1615 17.0005
R1439 VDD.n1889 VDD.n1617 17.0005
R1440 VDD.n1881 VDD.n1628 17.0005
R1441 VDD.n1881 VDD.n1634 17.0005
R1442 VDD.n1881 VDD.n1872 17.0005
R1443 VDD.n1881 VDD.n1880 17.0005
R1444 VDD.n1862 VDD.n1646 17.0005
R1445 VDD.n1862 VDD.n1848 17.0005
R1446 VDD.n1862 VDD.n1850 17.0005
R1447 VDD.n1862 VDD.n1858 17.0005
R1448 VDD.n2065 VDD.n25 17.0005
R1449 VDD.n2065 VDD.n62 17.0005
R1450 VDD.n2065 VDD.n68 17.0005
R1451 VDD.n2065 VDD.n74 17.0005
R1452 VDD.n2065 VDD.n80 17.0005
R1453 VDD.n2065 VDD.n86 17.0005
R1454 VDD.n2065 VDD.n92 17.0005
R1455 VDD.n2065 VDD.n98 17.0005
R1456 VDD.n2065 VDD.n104 17.0005
R1457 VDD.n2065 VDD.n110 17.0005
R1458 VDD.n2065 VDD.n116 17.0005
R1459 VDD.n2065 VDD.n122 17.0005
R1460 VDD.n2065 VDD.n128 17.0005
R1461 VDD.n2065 VDD.n134 17.0005
R1462 VDD.n2065 VDD.n140 17.0005
R1463 VDD.n2065 VDD.n142 17.0005
R1464 VDD.n1687 VDD.n1 17.0005
R1465 VDD.n1706 VDD.n1 17.0005
R1466 VDD.n1709 VDD.n1 17.0005
R1467 VDD.n1731 VDD.n1 17.0005
R1468 VDD.n1753 VDD.n1 17.0005
R1469 VDD.n1775 VDD.n1 17.0005
R1470 VDD.n1797 VDD.n1 17.0005
R1471 VDD.n1650 VDD.n1 17.0005
R1472 VDD.n1669 VDD.n1 17.0005
R1473 VDD.n56 VDD.n36 13.9411
R1474 VDD.n57 VDD.n56 13.9411
R1475 VDD.n344 VDD.n334 13.9411
R1476 VDD.n345 VDD.n344 13.9411
R1477 VDD.n56 VDD.n55 13.5005
R1478 VDD.n344 VDD.n343 13.5005
R1479 VDD.n1474 VDD.n1007 9.98362
R1480 VDD.n1357 VDD.n1356 9.77364
R1481 VDD.n1339 VDD.n1338 9.77364
R1482 VDD.n1487 VDD.n1486 9.44616
R1483 VDD.n1362 VDD.n1270 9.44616
R1484 VDD.n1133 VDD.n1132 9.44553
R1485 VDD.n1253 VDD.n1252 9.44553
R1486 VDD.n1288 VDD.n1287 9.44553
R1487 VDD.n674 VDD.n673 9.44113
R1488 VDD.n674 VDD.n662 9.44113
R1489 VDD.n1505 VDD.n994 9.44113
R1490 VDD.n1866 VDD.n1865 9.44113
R1491 VDD.n1843 VDD.n1842 9.44113
R1492 VDD.n1885 VDD.n1620 9.44113
R1493 VDD.n1853 VDD.n943 9.44113
R1494 VDD.n1803 VDD.n1800 9.44113
R1495 VDD.n2070 VDD.n2069 9.44113
R1496 VDD.n2062 VDD.n147 9.44113
R1497 VDD.n1656 VDD.n167 9.44113
R1498 VDD.n1414 VDD.n1413 9.4405
R1499 VDD.n1403 VDD.n1120 9.4405
R1500 VDD.n1395 VDD.n1394 9.4405
R1501 VDD.n1424 VDD.n1134 9.4405
R1502 VDD.n1256 VDD.n1254 9.4405
R1503 VDD.n1274 VDD.n1272 9.4405
R1504 VDD.n1291 VDD.n1289 9.4405
R1505 VDD.n1311 VDD.n1309 9.4405
R1506 VDD.n1369 VDD.n1367 9.43987
R1507 VDD.n1475 VDD.n1474 9.00364
R1508 VDD.n1060 VDD.n1002 9.00301
R1509 VDD.n1356 VDD.n1355 9.00301
R1510 VDD.n1338 VDD.n1337 9.00301
R1511 VDD.n1364 VDD.n1363 9.00301
R1512 VDD.n1306 VDD.n1305 9.00301
R1513 VDD.n2061 VDD.n2060 9.0005
R1514 VDD.n2035 VDD.n148 9.0005
R1515 VDD.n2017 VDD.n2016 9.0005
R1516 VDD.n1991 VDD.n303 9.0005
R1517 VDD.n1975 VDD.n1974 9.0005
R1518 VDD.n675 VDD.n674 9.0005
R1519 VDD.n1947 VDD.n519 9.0005
R1520 VDD.n1931 VDD.n1930 9.0005
R1521 VDD.n1929 VDD.n1928 9.0005
R1522 VDD.n1973 VDD.n1972 9.0005
R1523 VDD.n2019 VDD.n2018 9.0005
R1524 VDD.n1903 VDD.n820 9.0005
R1525 VDD.n1334 VDD.n1333 9.0005
R1526 VDD.n1445 VDD.n1064 9.0005
R1527 VDD.n1426 VDD.n1425 9.0005
R1528 VDD.n1460 VDD.n1459 9.0005
R1529 VDD.n1486 VDD.n1485 9.0005
R1530 VDD.n1392 VDD.n1391 9.0005
R1531 VDD.n1258 VDD.n1257 9.0005
R1532 VDD.n1253 VDD 9.0005
R1533 VDD.n1239 VDD.n1238 9.0005
R1534 VDD.n1133 VDD 9.0005
R1535 VDD.n1462 VDD.n1461 9.0005
R1536 VDD.n1473 VDD.n1472 9.0005
R1537 VDD.n1336 VDD.n1335 9.0005
R1538 VDD.n1274 VDD.n1273 9.0005
R1539 VDD.n1256 VDD.n1255 9.0005
R1540 VDD.n1394 VDD.n1393 9.0005
R1541 VDD.n1424 VDD.n1423 9.0005
R1542 VDD.n1186 VDD.n1120 9.0005
R1543 VDD.n1415 VDD.n1414 9.0005
R1544 VDD.n1369 VDD.n1368 9.0005
R1545 VDD.n1366 VDD.n1365 9.0005
R1546 VDD.n1362 VDD.n1361 9.0005
R1547 VDD.n1371 VDD.n1370 9.0005
R1548 VDD.n1291 VDD.n1290 9.0005
R1549 VDD.n1288 VDD 9.0005
R1550 VDD.n1293 VDD.n1292 9.0005
R1551 VDD.n1311 VDD.n1310 9.0005
R1552 VDD.n1308 VDD.n1307 9.0005
R1553 VDD.n1344 VDD.n995 9.0005
R1554 VDD.n1504 VDD.n1503 9.0005
R1555 VDD.n1313 VDD.n1312 9.0005
R1556 VDD.n1506 VDD.n1505 9.0005
R1557 VDD.n1887 VDD.n1886 9.0005
R1558 VDD.n1839 VDD.n1838 9.0005
R1559 VDD.n1836 VDD.n1835 9.0005
R1560 VDD.n1833 VDD.n1832 9.0005
R1561 VDD.n1830 VDD.n1829 9.0005
R1562 VDD.n1827 VDD.n1826 9.0005
R1563 VDD.n1824 VDD.n1823 9.0005
R1564 VDD.n1821 VDD.n1820 9.0005
R1565 VDD.n1818 VDD.n1817 9.0005
R1566 VDD.n1815 VDD.n1814 9.0005
R1567 VDD.n1812 VDD.n1811 9.0005
R1568 VDD.n1809 VDD.n1808 9.0005
R1569 VDD.n1806 VDD.n1805 9.0005
R1570 VDD.n1842 VDD.n1841 9.0005
R1571 VDD.n1885 VDD.n1884 9.0005
R1572 VDD.n1867 VDD.n1866 9.0005
R1573 VDD.n1610 VDD.n837 9.0005
R1574 VDD.n1909 VDD.n1908 9.0005
R1575 VDD.n1911 VDD.n1910 9.0005
R1576 VDD.n810 VDD.n621 9.0005
R1577 VDD.n1953 VDD.n1952 9.0005
R1578 VDD.n1955 VDD.n1954 9.0005
R1579 VDD.n509 VDD.n469 9.0005
R1580 VDD.n1997 VDD.n1996 9.0005
R1581 VDD.n1999 VDD.n1998 9.0005
R1582 VDD.n293 VDD.n168 9.0005
R1583 VDD.n2041 VDD.n2040 9.0005
R1584 VDD.n2043 VDD.n2042 9.0005
R1585 VDD.n1875 VDD.n943 9.0005
R1586 VDD.n1893 VDD.n1892 9.0005
R1587 VDD.n1895 VDD.n1894 9.0005
R1588 VDD.n1919 VDD.n791 9.0005
R1589 VDD.n1937 VDD.n1936 9.0005
R1590 VDD.n1939 VDD.n1938 9.0005
R1591 VDD.n1963 VDD.n490 9.0005
R1592 VDD.n1981 VDD.n1980 9.0005
R1593 VDD.n1983 VDD.n1982 9.0005
R1594 VDD.n2007 VDD.n189 9.0005
R1595 VDD.n2025 VDD.n2024 9.0005
R1596 VDD.n2027 VDD.n2026 9.0005
R1597 VDD.n2051 VDD.n3 9.0005
R1598 VDD.n2069 VDD.n2068 9.0005
R1599 VDD.n167 VDD.n166 9.0005
R1600 VDD.n1803 VDD.n1802 9.0005
R1601 VDD.n2063 VDD.n2062 9.0005
R1602 VDD.n53 VDD.n52 8.47207
R1603 VDD.n52 VDD.n37 8.47207
R1604 VDD.n52 VDD.n47 8.47207
R1605 VDD.n52 VDD.n38 8.47207
R1606 VDD.n52 VDD.n51 8.47207
R1607 VDD.n34 VDD.n33 8.47207
R1608 VDD.n33 VDD.n28 8.47207
R1609 VDD.n2057 VDD.n157 8.47207
R1610 VDD.n2057 VDD.n160 8.47207
R1611 VDD.n2057 VDD.n163 8.47207
R1612 VDD.n2057 VDD.n2046 8.47207
R1613 VDD.n2057 VDD.n2049 8.47207
R1614 VDD.n2057 VDD.n2054 8.47207
R1615 VDD.n2058 VDD.n2057 8.47207
R1616 VDD.n2057 VDD.n149 8.47207
R1617 VDD.n2037 VDD.n179 8.47207
R1618 VDD.n2037 VDD.n182 8.47207
R1619 VDD.n2038 VDD.n2037 8.47207
R1620 VDD.n2037 VDD.n169 8.47207
R1621 VDD.n2037 VDD.n187 8.47207
R1622 VDD.n2037 VDD.n2030 8.47207
R1623 VDD.n2037 VDD.n2033 8.47207
R1624 VDD.n2037 VDD.n2036 8.47207
R1625 VDD.n341 VDD.n340 8.47207
R1626 VDD.n340 VDD.n335 8.47207
R1627 VDD.n332 VDD.n331 8.47207
R1628 VDD.n331 VDD.n326 8.47207
R1629 VDD.n2021 VDD.n213 8.47207
R1630 VDD.n2021 VDD.n217 8.47207
R1631 VDD.n2021 VDD.n220 8.47207
R1632 VDD.n2021 VDD.n223 8.47207
R1633 VDD.n2021 VDD.n226 8.47207
R1634 VDD.n2021 VDD.n229 8.47207
R1635 VDD.n2021 VDD.n232 8.47207
R1636 VDD.n2021 VDD.n234 8.47207
R1637 VDD.n2021 VDD.n204 8.47207
R1638 VDD.n2021 VDD.n237 8.47207
R1639 VDD.n2021 VDD.n240 8.47207
R1640 VDD.n2021 VDD.n243 8.47207
R1641 VDD.n2021 VDD.n246 8.47207
R1642 VDD.n2021 VDD.n249 8.47207
R1643 VDD.n2021 VDD.n252 8.47207
R1644 VDD.n2021 VDD.n255 8.47207
R1645 VDD.n2021 VDD.n258 8.47207
R1646 VDD.n2021 VDD.n261 8.47207
R1647 VDD.n2021 VDD.n264 8.47207
R1648 VDD.n2021 VDD.n267 8.47207
R1649 VDD.n2021 VDD.n270 8.47207
R1650 VDD.n2021 VDD.n273 8.47207
R1651 VDD.n2021 VDD.n276 8.47207
R1652 VDD.n2021 VDD.n279 8.47207
R1653 VDD.n2021 VDD.n282 8.47207
R1654 VDD.n2021 VDD.n285 8.47207
R1655 VDD.n2021 VDD.n288 8.47207
R1656 VDD.n2021 VDD.n291 8.47207
R1657 VDD.n2021 VDD.n296 8.47207
R1658 VDD.n2022 VDD.n2021 8.47207
R1659 VDD.n2021 VDD.n190 8.47207
R1660 VDD.n2021 VDD.n301 8.47207
R1661 VDD.n2021 VDD.n2020 8.47207
R1662 VDD.n2013 VDD.n324 8.47207
R1663 VDD.n2013 VDD.n348 8.47207
R1664 VDD.n2013 VDD.n351 8.47207
R1665 VDD.n2013 VDD.n358 8.47207
R1666 VDD.n2013 VDD.n361 8.47207
R1667 VDD.n2013 VDD.n368 8.47207
R1668 VDD.n2013 VDD.n371 8.47207
R1669 VDD.n2013 VDD.n378 8.47207
R1670 VDD.n2013 VDD.n381 8.47207
R1671 VDD.n2013 VDD.n388 8.47207
R1672 VDD.n2013 VDD.n391 8.47207
R1673 VDD.n2013 VDD.n398 8.47207
R1674 VDD.n2013 VDD.n401 8.47207
R1675 VDD.n2013 VDD.n408 8.47207
R1676 VDD.n2013 VDD.n411 8.47207
R1677 VDD.n2013 VDD.n418 8.47207
R1678 VDD.n2013 VDD.n421 8.47207
R1679 VDD.n2013 VDD.n428 8.47207
R1680 VDD.n2013 VDD.n431 8.47207
R1681 VDD.n2013 VDD.n438 8.47207
R1682 VDD.n2013 VDD.n441 8.47207
R1683 VDD.n2013 VDD.n448 8.47207
R1684 VDD.n2013 VDD.n451 8.47207
R1685 VDD.n2013 VDD.n458 8.47207
R1686 VDD.n2013 VDD.n461 8.47207
R1687 VDD.n2013 VDD.n464 8.47207
R1688 VDD.n2013 VDD.n467 8.47207
R1689 VDD.n2013 VDD.n2002 8.47207
R1690 VDD.n2013 VDD.n2005 8.47207
R1691 VDD.n2013 VDD.n2010 8.47207
R1692 VDD.n2014 VDD.n2013 8.47207
R1693 VDD.n2013 VDD.n304 8.47207
R1694 VDD.n1993 VDD.n480 8.47207
R1695 VDD.n1993 VDD.n483 8.47207
R1696 VDD.n1994 VDD.n1993 8.47207
R1697 VDD.n1993 VDD.n470 8.47207
R1698 VDD.n1993 VDD.n488 8.47207
R1699 VDD.n1993 VDD.n1986 8.47207
R1700 VDD.n1993 VDD.n1989 8.47207
R1701 VDD.n1993 VDD.n1992 8.47207
R1702 VDD.n1977 VDD.n501 8.47207
R1703 VDD.n1977 VDD.n504 8.47207
R1704 VDD.n1977 VDD.n507 8.47207
R1705 VDD.n1977 VDD.n512 8.47207
R1706 VDD.n1978 VDD.n1977 8.47207
R1707 VDD.n1977 VDD.n491 8.47207
R1708 VDD.n1977 VDD.n517 8.47207
R1709 VDD.n1977 VDD.n1976 8.47207
R1710 VDD.n670 VDD.n666 8.47207
R1711 VDD.n671 VDD.n670 8.47207
R1712 VDD.n670 VDD.n669 8.47207
R1713 VDD.n1969 VDD.n541 8.47207
R1714 VDD.n1969 VDD.n545 8.47207
R1715 VDD.n1969 VDD.n548 8.47207
R1716 VDD.n1969 VDD.n551 8.47207
R1717 VDD.n1969 VDD.n554 8.47207
R1718 VDD.n1969 VDD.n557 8.47207
R1719 VDD.n1969 VDD.n560 8.47207
R1720 VDD.n1969 VDD.n562 8.47207
R1721 VDD.n1969 VDD.n532 8.47207
R1722 VDD.n1969 VDD.n565 8.47207
R1723 VDD.n1969 VDD.n568 8.47207
R1724 VDD.n1969 VDD.n571 8.47207
R1725 VDD.n1969 VDD.n574 8.47207
R1726 VDD.n1969 VDD.n577 8.47207
R1727 VDD.n1969 VDD.n580 8.47207
R1728 VDD.n1969 VDD.n583 8.47207
R1729 VDD.n1969 VDD.n586 8.47207
R1730 VDD.n1969 VDD.n589 8.47207
R1731 VDD.n1969 VDD.n592 8.47207
R1732 VDD.n1969 VDD.n595 8.47207
R1733 VDD.n1969 VDD.n598 8.47207
R1734 VDD.n1969 VDD.n601 8.47207
R1735 VDD.n1969 VDD.n604 8.47207
R1736 VDD.n1969 VDD.n607 8.47207
R1737 VDD.n1969 VDD.n610 8.47207
R1738 VDD.n1969 VDD.n613 8.47207
R1739 VDD.n1969 VDD.n616 8.47207
R1740 VDD.n1969 VDD.n619 8.47207
R1741 VDD.n1969 VDD.n1958 8.47207
R1742 VDD.n1969 VDD.n1961 8.47207
R1743 VDD.n1969 VDD.n1966 8.47207
R1744 VDD.n1970 VDD.n1969 8.47207
R1745 VDD.n1969 VDD.n520 8.47207
R1746 VDD.n1949 VDD.n645 8.47207
R1747 VDD.n1949 VDD.n649 8.47207
R1748 VDD.n1949 VDD.n652 8.47207
R1749 VDD.n1949 VDD.n656 8.47207
R1750 VDD.n1949 VDD.n659 8.47207
R1751 VDD.n1949 VDD.n678 8.47207
R1752 VDD.n1949 VDD.n681 8.47207
R1753 VDD.n1949 VDD.n688 8.47207
R1754 VDD.n1949 VDD.n691 8.47207
R1755 VDD.n1949 VDD.n698 8.47207
R1756 VDD.n1949 VDD.n701 8.47207
R1757 VDD.n1949 VDD.n708 8.47207
R1758 VDD.n1949 VDD.n711 8.47207
R1759 VDD.n1949 VDD.n718 8.47207
R1760 VDD.n1949 VDD.n721 8.47207
R1761 VDD.n1949 VDD.n728 8.47207
R1762 VDD.n1949 VDD.n731 8.47207
R1763 VDD.n1949 VDD.n738 8.47207
R1764 VDD.n1949 VDD.n741 8.47207
R1765 VDD.n1949 VDD.n748 8.47207
R1766 VDD.n1949 VDD.n751 8.47207
R1767 VDD.n1949 VDD.n758 8.47207
R1768 VDD.n1949 VDD.n761 8.47207
R1769 VDD.n1949 VDD.n768 8.47207
R1770 VDD.n1949 VDD.n771 8.47207
R1771 VDD.n1949 VDD.n778 8.47207
R1772 VDD.n1949 VDD.n781 8.47207
R1773 VDD.n1949 VDD.n784 8.47207
R1774 VDD.n1950 VDD.n1949 8.47207
R1775 VDD.n1949 VDD.n622 8.47207
R1776 VDD.n1949 VDD.n789 8.47207
R1777 VDD.n1949 VDD.n1942 8.47207
R1778 VDD.n1949 VDD.n1945 8.47207
R1779 VDD.n1949 VDD.n1948 8.47207
R1780 VDD.n1933 VDD.n802 8.47207
R1781 VDD.n1933 VDD.n805 8.47207
R1782 VDD.n1933 VDD.n808 8.47207
R1783 VDD.n1933 VDD.n813 8.47207
R1784 VDD.n1934 VDD.n1933 8.47207
R1785 VDD.n1933 VDD.n792 8.47207
R1786 VDD.n1933 VDD.n818 8.47207
R1787 VDD.n1933 VDD.n1932 8.47207
R1788 VDD.n1925 VDD.n829 8.47207
R1789 VDD.n1925 VDD.n832 8.47207
R1790 VDD.n1925 VDD.n835 8.47207
R1791 VDD.n1925 VDD.n1914 8.47207
R1792 VDD.n1925 VDD.n1917 8.47207
R1793 VDD.n1925 VDD.n1922 8.47207
R1794 VDD.n1926 VDD.n1925 8.47207
R1795 VDD.n1925 VDD.n821 8.47207
R1796 VDD.n1330 VDD.n1284 8.47207
R1797 VDD.n1330 VDD.n1302 8.47207
R1798 VDD.n1330 VDD.n1319 8.47207
R1799 VDD.n1331 VDD.n1330 8.47207
R1800 VDD.n1330 VDD.n1275 8.47207
R1801 VDD.n1330 VDD.n1323 8.47207
R1802 VDD.n1330 VDD.n1329 8.47207
R1803 VDD.n1457 VDD.n1129 8.47207
R1804 VDD.n1457 VDD.n1432 8.47207
R1805 VDD.n1457 VDD.n1437 8.47207
R1806 VDD.n1457 VDD.n1441 8.47207
R1807 VDD.n1457 VDD.n1446 8.47207
R1808 VDD.n1457 VDD.n1450 8.47207
R1809 VDD.n1457 VDD.n1456 8.47207
R1810 VDD.n1493 VDD.n1488 8.47207
R1811 VDD.n1493 VDD.n1492 8.47207
R1812 VDD.n1497 VDD.n999 8.47207
R1813 VDD.n1497 VDD.n1496 8.47207
R1814 VDD.n1501 VDD.n996 8.47207
R1815 VDD.n1501 VDD.n1500 8.47207
R1816 VDD.n1388 VDD.n1249 8.47207
R1817 VDD.n1388 VDD.n1267 8.47207
R1818 VDD.n1388 VDD.n1377 8.47207
R1819 VDD.n1389 VDD.n1388 8.47207
R1820 VDD.n1388 VDD.n1240 8.47207
R1821 VDD.n1388 VDD.n1381 8.47207
R1822 VDD.n1388 VDD.n1387 8.47207
R1823 VDD.n1470 VDD.n1090 8.47207
R1824 VDD.n1470 VDD.n1093 8.47207
R1825 VDD.n1470 VDD.n1096 8.47207
R1826 VDD.n1470 VDD.n1085 8.47207
R1827 VDD.n1470 VDD.n1083 8.47207
R1828 VDD.n1470 VDD.n1102 8.47207
R1829 VDD.n1470 VDD.n1105 8.47207
R1830 VDD.n1470 VDD.n1081 8.47207
R1831 VDD.n1470 VDD.n1079 8.47207
R1832 VDD.n1470 VDD.n1112 8.47207
R1833 VDD.n1470 VDD.n1115 8.47207
R1834 VDD.n1470 VDD.n1075 8.47207
R1835 VDD.n1470 VDD.n1072 8.47207
R1836 VDD.n1470 VDD.n1118 8.47207
R1837 VDD.n1470 VDD.n1464 8.47207
R1838 VDD.n1470 VDD.n1068 8.47207
R1839 VDD.n1470 VDD.n1065 8.47207
R1840 VDD.n1470 VDD.n1469 8.47207
R1841 VDD.n1421 VDD.n1158 8.47207
R1842 VDD.n1421 VDD.n1161 8.47207
R1843 VDD.n1421 VDD.n1164 8.47207
R1844 VDD.n1421 VDD.n1166 8.47207
R1845 VDD.n1421 VDD.n1169 8.47207
R1846 VDD.n1421 VDD.n1148 8.47207
R1847 VDD.n1421 VDD.n1146 8.47207
R1848 VDD.n1421 VDD.n1144 8.47207
R1849 VDD.n1421 VDD.n1142 8.47207
R1850 VDD.n1421 VDD.n1140 8.47207
R1851 VDD.n1421 VDD.n1182 8.47207
R1852 VDD.n1421 VDD.n1185 8.47207
R1853 VDD.n1421 VDD.n1189 8.47207
R1854 VDD.n1421 VDD.n1417 8.47207
R1855 VDD.n1421 VDD.n1420 8.47207
R1856 VDD.n1411 VDD.n1215 8.47207
R1857 VDD.n1411 VDD.n1212 8.47207
R1858 VDD.n1411 VDD.n1221 8.47207
R1859 VDD.n1411 VDD.n1210 8.47207
R1860 VDD.n1411 VDD.n1208 8.47207
R1861 VDD.n1411 VDD.n1227 8.47207
R1862 VDD.n1411 VDD.n1230 8.47207
R1863 VDD.n1411 VDD.n1233 8.47207
R1864 VDD.n1411 VDD.n1204 8.47207
R1865 VDD.n1411 VDD.n1237 8.47207
R1866 VDD.n1411 VDD.n1398 8.47207
R1867 VDD.n1411 VDD.n1200 8.47207
R1868 VDD.n1411 VDD.n1197 8.47207
R1869 VDD.n1411 VDD.n1195 8.47207
R1870 VDD.n1411 VDD.n1405 8.47207
R1871 VDD.n1411 VDD.n1193 8.47207
R1872 VDD.n1411 VDD.n1190 8.47207
R1873 VDD.n1411 VDD.n1410 8.47207
R1874 VDD.n1481 VDD.n1032 8.47207
R1875 VDD.n1481 VDD.n1035 8.47207
R1876 VDD.n1481 VDD.n1038 8.47207
R1877 VDD.n1481 VDD.n1040 8.47207
R1878 VDD.n1481 VDD.n1043 8.47207
R1879 VDD.n1481 VDD.n1022 8.47207
R1880 VDD.n1481 VDD.n1020 8.47207
R1881 VDD.n1481 VDD.n1018 8.47207
R1882 VDD.n1481 VDD.n1016 8.47207
R1883 VDD.n1481 VDD.n1014 8.47207
R1884 VDD.n1481 VDD.n1056 8.47207
R1885 VDD.n1481 VDD.n1059 8.47207
R1886 VDD.n1481 VDD.n1063 8.47207
R1887 VDD.n1481 VDD.n1477 8.47207
R1888 VDD.n1481 VDD.n1480 8.47207
R1889 VDD.n1905 VDD.n861 8.47207
R1890 VDD.n1905 VDD.n865 8.47207
R1891 VDD.n1905 VDD.n868 8.47207
R1892 VDD.n1905 VDD.n871 8.47207
R1893 VDD.n1905 VDD.n874 8.47207
R1894 VDD.n1905 VDD.n877 8.47207
R1895 VDD.n1905 VDD.n880 8.47207
R1896 VDD.n1905 VDD.n882 8.47207
R1897 VDD.n1905 VDD.n852 8.47207
R1898 VDD.n1905 VDD.n885 8.47207
R1899 VDD.n1905 VDD.n888 8.47207
R1900 VDD.n1905 VDD.n891 8.47207
R1901 VDD.n1905 VDD.n894 8.47207
R1902 VDD.n1905 VDD.n897 8.47207
R1903 VDD.n1905 VDD.n900 8.47207
R1904 VDD.n1905 VDD.n903 8.47207
R1905 VDD.n1905 VDD.n906 8.47207
R1906 VDD.n1905 VDD.n909 8.47207
R1907 VDD.n1905 VDD.n912 8.47207
R1908 VDD.n1905 VDD.n915 8.47207
R1909 VDD.n1905 VDD.n918 8.47207
R1910 VDD.n1905 VDD.n921 8.47207
R1911 VDD.n1905 VDD.n924 8.47207
R1912 VDD.n1905 VDD.n927 8.47207
R1913 VDD.n1905 VDD.n930 8.47207
R1914 VDD.n1905 VDD.n933 8.47207
R1915 VDD.n1905 VDD.n936 8.47207
R1916 VDD.n1906 VDD.n1905 8.47207
R1917 VDD.n1905 VDD.n838 8.47207
R1918 VDD.n1905 VDD.n941 8.47207
R1919 VDD.n1905 VDD.n1898 8.47207
R1920 VDD.n1905 VDD.n1901 8.47207
R1921 VDD.n1905 VDD.n1904 8.47207
R1922 VDD.n1889 VDD.n967 8.47207
R1923 VDD.n1889 VDD.n971 8.47207
R1924 VDD.n1889 VDD.n974 8.47207
R1925 VDD.n1889 VDD.n978 8.47207
R1926 VDD.n1889 VDD.n981 8.47207
R1927 VDD.n1889 VDD.n988 8.47207
R1928 VDD.n1889 VDD.n991 8.47207
R1929 VDD.n1889 VDD.n1509 8.47207
R1930 VDD.n1889 VDD.n1512 8.47207
R1931 VDD.n1889 VDD.n1519 8.47207
R1932 VDD.n1889 VDD.n1522 8.47207
R1933 VDD.n1889 VDD.n1529 8.47207
R1934 VDD.n1889 VDD.n1532 8.47207
R1935 VDD.n1889 VDD.n1539 8.47207
R1936 VDD.n1889 VDD.n1542 8.47207
R1937 VDD.n1889 VDD.n1549 8.47207
R1938 VDD.n1889 VDD.n1552 8.47207
R1939 VDD.n1889 VDD.n1559 8.47207
R1940 VDD.n1889 VDD.n1562 8.47207
R1941 VDD.n1889 VDD.n1569 8.47207
R1942 VDD.n1889 VDD.n1572 8.47207
R1943 VDD.n1889 VDD.n1579 8.47207
R1944 VDD.n1889 VDD.n1582 8.47207
R1945 VDD.n1889 VDD.n1589 8.47207
R1946 VDD.n1889 VDD.n1592 8.47207
R1947 VDD.n1889 VDD.n1599 8.47207
R1948 VDD.n1889 VDD.n1602 8.47207
R1949 VDD.n1889 VDD.n1605 8.47207
R1950 VDD.n1889 VDD.n1608 8.47207
R1951 VDD.n1889 VDD.n1613 8.47207
R1952 VDD.n1890 VDD.n1889 8.47207
R1953 VDD.n1889 VDD.n944 8.47207
R1954 VDD.n1889 VDD.n1618 8.47207
R1955 VDD.n1889 VDD.n1888 8.47207
R1956 VDD.n1881 VDD.n1629 8.47207
R1957 VDD.n1881 VDD.n1632 8.47207
R1958 VDD.n1881 VDD.n1635 8.47207
R1959 VDD.n1881 VDD.n1870 8.47207
R1960 VDD.n1881 VDD.n1873 8.47207
R1961 VDD.n1881 VDD.n1878 8.47207
R1962 VDD.n1882 VDD.n1881 8.47207
R1963 VDD.n1881 VDD.n1621 8.47207
R1964 VDD.n1862 VDD.n1647 8.47207
R1965 VDD.n1862 VDD.n1846 8.47207
R1966 VDD.n1863 VDD.n1862 8.47207
R1967 VDD.n1862 VDD.n1637 8.47207
R1968 VDD.n1862 VDD.n1851 8.47207
R1969 VDD.n1862 VDD.n1856 8.47207
R1970 VDD.n1862 VDD.n1860 8.47207
R1971 VDD.n1862 VDD.n1861 8.47207
R1972 VDD.n2065 VDD.n26 8.47207
R1973 VDD.n2065 VDD.n60 8.47207
R1974 VDD.n2065 VDD.n63 8.47207
R1975 VDD.n2065 VDD.n66 8.47207
R1976 VDD.n2065 VDD.n69 8.47207
R1977 VDD.n2065 VDD.n72 8.47207
R1978 VDD.n2065 VDD.n75 8.47207
R1979 VDD.n2065 VDD.n78 8.47207
R1980 VDD.n2065 VDD.n81 8.47207
R1981 VDD.n2065 VDD.n84 8.47207
R1982 VDD.n2065 VDD.n87 8.47207
R1983 VDD.n2065 VDD.n90 8.47207
R1984 VDD.n2065 VDD.n93 8.47207
R1985 VDD.n2065 VDD.n96 8.47207
R1986 VDD.n2065 VDD.n99 8.47207
R1987 VDD.n2065 VDD.n102 8.47207
R1988 VDD.n2065 VDD.n105 8.47207
R1989 VDD.n2065 VDD.n108 8.47207
R1990 VDD.n2065 VDD.n111 8.47207
R1991 VDD.n2065 VDD.n114 8.47207
R1992 VDD.n2065 VDD.n117 8.47207
R1993 VDD.n2065 VDD.n120 8.47207
R1994 VDD.n2065 VDD.n123 8.47207
R1995 VDD.n2065 VDD.n126 8.47207
R1996 VDD.n2065 VDD.n129 8.47207
R1997 VDD.n2065 VDD.n132 8.47207
R1998 VDD.n2065 VDD.n135 8.47207
R1999 VDD.n2065 VDD.n138 8.47207
R2000 VDD.n2066 VDD.n2065 8.47207
R2001 VDD.n2065 VDD.n4 8.47207
R2002 VDD.n2065 VDD.n143 8.47207
R2003 VDD.n2065 VDD.n2064 8.47207
R2004 VDD.n1707 VDD.n1 8.47207
R2005 VDD.n145 VDD.n1 8.47207
R2006 VDD.n1 VDD.n0 8.47207
R2007 VDD.n2076 VDD.n1 8.47207
R2008 VDD.n2074 VDD.n1 8.47207
R2009 VDD.n2071 VDD.n1 8.47207
R2010 VDD.n1649 VDD.n1 8.47207
R2011 VDD.n1655 VDD.n1 8.47207
R2012 VDD.n1658 VDD.n1 8.47207
R2013 VDD.n1659 VDD.n1 8.47207
R2014 VDD.n1661 VDD.n1 8.47207
R2015 VDD.n1664 VDD.n1 8.47207
R2016 VDD.n1798 VDD.n1 8.47207
R2017 VDD.n1792 VDD.n1 8.47207
R2018 VDD.n1787 VDD.n1 8.47207
R2019 VDD.n1786 VDD.n1 8.47207
R2020 VDD.n1784 VDD.n1 8.47207
R2021 VDD.n1781 VDD.n1 8.47207
R2022 VDD.n1776 VDD.n1 8.47207
R2023 VDD.n1770 VDD.n1 8.47207
R2024 VDD.n1765 VDD.n1 8.47207
R2025 VDD.n1764 VDD.n1 8.47207
R2026 VDD.n1762 VDD.n1 8.47207
R2027 VDD.n1759 VDD.n1 8.47207
R2028 VDD.n1754 VDD.n1 8.47207
R2029 VDD.n1748 VDD.n1 8.47207
R2030 VDD.n1743 VDD.n1 8.47207
R2031 VDD.n1742 VDD.n1 8.47207
R2032 VDD.n1740 VDD.n1 8.47207
R2033 VDD.n1737 VDD.n1 8.47207
R2034 VDD.n1732 VDD.n1 8.47207
R2035 VDD.n1726 VDD.n1 8.47207
R2036 VDD.n1721 VDD.n1 8.47207
R2037 VDD.n1720 VDD.n1 8.47207
R2038 VDD.n1718 VDD.n1 8.47207
R2039 VDD.n1715 VDD.n1 8.47207
R2040 VDD.n1710 VDD.n1 8.47207
R2041 VDD.n1704 VDD.n1 8.47207
R2042 VDD.n1699 VDD.n1 8.47207
R2043 VDD.n1698 VDD.n1 8.47207
R2044 VDD.n1696 VDD.n1 8.47207
R2045 VDD.n1693 VDD.n1 8.47207
R2046 VDD.n1688 VDD.n1 8.47207
R2047 VDD.n1682 VDD.n1 8.47207
R2048 VDD.n1677 VDD.n1 8.47207
R2049 VDD.n1676 VDD.n1 8.47207
R2050 VDD.n1674 VDD.n1 8.47207
R2051 VDD.n1668 VDD.n1 8.47207
R2052 VDD.n1666 VDD.n1 8.47207
R2053 VDD.n1481 VDD.t57 5.66717
R2054 VDD.n1481 VDD.t78 5.66717
R2055 VDD.n1481 VDD.t89 5.66717
R2056 VDD.n1359 VDD.n1271 5.62191
R2057 VDD.n52 VDD.n43 5.61655
R2058 VDD.n33 VDD.n30 5.61655
R2059 VDD.n2057 VDD.n154 5.61655
R2060 VDD.n2057 VDD.n152 5.61655
R2061 VDD.n2057 VDD.n151 5.61655
R2062 VDD.n2057 VDD.n150 5.61655
R2063 VDD.n2037 VDD.n176 5.61655
R2064 VDD.n2037 VDD.n174 5.61655
R2065 VDD.n2037 VDD.n173 5.61655
R2066 VDD.n2037 VDD.n170 5.61655
R2067 VDD.n340 VDD.n337 5.61655
R2068 VDD.n331 VDD.n328 5.61655
R2069 VDD.n2021 VDD.n210 5.61655
R2070 VDD.n2021 VDD.n208 5.61655
R2071 VDD.n2021 VDD.n207 5.61655
R2072 VDD.n2021 VDD.n206 5.61655
R2073 VDD.n2021 VDD.n203 5.61655
R2074 VDD.n2021 VDD.n202 5.61655
R2075 VDD.n2021 VDD.n201 5.61655
R2076 VDD.n2021 VDD.n200 5.61655
R2077 VDD.n2021 VDD.n199 5.61655
R2078 VDD.n2021 VDD.n198 5.61655
R2079 VDD.n2021 VDD.n197 5.61655
R2080 VDD.n2021 VDD.n196 5.61655
R2081 VDD.n2021 VDD.n195 5.61655
R2082 VDD.n2021 VDD.n194 5.61655
R2083 VDD.n2021 VDD.n193 5.61655
R2084 VDD.n2013 VDD.n321 5.61655
R2085 VDD.n2013 VDD.n319 5.61655
R2086 VDD.n2013 VDD.n318 5.61655
R2087 VDD.n2013 VDD.n317 5.61655
R2088 VDD.n2013 VDD.n316 5.61655
R2089 VDD.n2013 VDD.n315 5.61655
R2090 VDD.n2013 VDD.n314 5.61655
R2091 VDD.n2013 VDD.n313 5.61655
R2092 VDD.n2013 VDD.n312 5.61655
R2093 VDD.n2013 VDD.n311 5.61655
R2094 VDD.n2013 VDD.n310 5.61655
R2095 VDD.n2013 VDD.n309 5.61655
R2096 VDD.n2013 VDD.n308 5.61655
R2097 VDD.n2013 VDD.n307 5.61655
R2098 VDD.n2013 VDD.n306 5.61655
R2099 VDD.n2013 VDD.n305 5.61655
R2100 VDD.n1993 VDD.n477 5.61655
R2101 VDD.n1993 VDD.n475 5.61655
R2102 VDD.n1993 VDD.n474 5.61655
R2103 VDD.n1993 VDD.n471 5.61655
R2104 VDD.n1977 VDD.n498 5.61655
R2105 VDD.n1977 VDD.n496 5.61655
R2106 VDD.n1977 VDD.n495 5.61655
R2107 VDD.n1977 VDD.n494 5.61655
R2108 VDD.n1969 VDD.n538 5.61655
R2109 VDD.n1969 VDD.n536 5.61655
R2110 VDD.n1969 VDD.n535 5.61655
R2111 VDD.n1969 VDD.n534 5.61655
R2112 VDD.n1969 VDD.n531 5.61655
R2113 VDD.n1969 VDD.n530 5.61655
R2114 VDD.n1969 VDD.n529 5.61655
R2115 VDD.n1969 VDD.n528 5.61655
R2116 VDD.n1969 VDD.n527 5.61655
R2117 VDD.n1969 VDD.n526 5.61655
R2118 VDD.n1969 VDD.n525 5.61655
R2119 VDD.n1969 VDD.n524 5.61655
R2120 VDD.n1969 VDD.n523 5.61655
R2121 VDD.n1969 VDD.n522 5.61655
R2122 VDD.n1969 VDD.n521 5.61655
R2123 VDD.n1949 VDD.n642 5.61655
R2124 VDD.n1949 VDD.n640 5.61655
R2125 VDD.n1949 VDD.n639 5.61655
R2126 VDD.n1949 VDD.n638 5.61655
R2127 VDD.n1949 VDD.n637 5.61655
R2128 VDD.n1949 VDD.n636 5.61655
R2129 VDD.n1949 VDD.n635 5.61655
R2130 VDD.n1949 VDD.n634 5.61655
R2131 VDD.n1949 VDD.n633 5.61655
R2132 VDD.n1949 VDD.n632 5.61655
R2133 VDD.n1949 VDD.n631 5.61655
R2134 VDD.n1949 VDD.n630 5.61655
R2135 VDD.n1949 VDD.n629 5.61655
R2136 VDD.n1949 VDD.n628 5.61655
R2137 VDD.n1949 VDD.n627 5.61655
R2138 VDD.n1949 VDD.n626 5.61655
R2139 VDD.n1949 VDD.n623 5.61655
R2140 VDD.n1933 VDD.n799 5.61655
R2141 VDD.n1933 VDD.n797 5.61655
R2142 VDD.n1933 VDD.n796 5.61655
R2143 VDD.n1933 VDD.n795 5.61655
R2144 VDD.n1925 VDD.n826 5.61655
R2145 VDD.n1925 VDD.n824 5.61655
R2146 VDD.n1925 VDD.n823 5.61655
R2147 VDD.n1925 VDD.n822 5.61655
R2148 VDD.n1330 VDD.n1295 5.61655
R2149 VDD.n1330 VDD.n1315 5.61655
R2150 VDD.n1457 VDD.n1428 5.61655
R2151 VDD.n1457 VDD.n1433 5.61655
R2152 VDD.n1388 VDD.n1260 5.61655
R2153 VDD.n1388 VDD.n1373 5.61655
R2154 VDD.n1905 VDD.n858 5.61655
R2155 VDD.n1905 VDD.n856 5.61655
R2156 VDD.n1905 VDD.n855 5.61655
R2157 VDD.n1905 VDD.n854 5.61655
R2158 VDD.n1905 VDD.n851 5.61655
R2159 VDD.n1905 VDD.n850 5.61655
R2160 VDD.n1905 VDD.n849 5.61655
R2161 VDD.n1905 VDD.n848 5.61655
R2162 VDD.n1905 VDD.n847 5.61655
R2163 VDD.n1905 VDD.n846 5.61655
R2164 VDD.n1905 VDD.n845 5.61655
R2165 VDD.n1905 VDD.n844 5.61655
R2166 VDD.n1905 VDD.n843 5.61655
R2167 VDD.n1905 VDD.n842 5.61655
R2168 VDD.n1905 VDD.n839 5.61655
R2169 VDD.n1889 VDD.n964 5.61655
R2170 VDD.n1889 VDD.n962 5.61655
R2171 VDD.n1889 VDD.n961 5.61655
R2172 VDD.n1889 VDD.n960 5.61655
R2173 VDD.n1889 VDD.n959 5.61655
R2174 VDD.n1889 VDD.n958 5.61655
R2175 VDD.n1889 VDD.n957 5.61655
R2176 VDD.n1889 VDD.n956 5.61655
R2177 VDD.n1889 VDD.n955 5.61655
R2178 VDD.n1889 VDD.n954 5.61655
R2179 VDD.n1889 VDD.n953 5.61655
R2180 VDD.n1889 VDD.n952 5.61655
R2181 VDD.n1889 VDD.n951 5.61655
R2182 VDD.n1889 VDD.n950 5.61655
R2183 VDD.n1889 VDD.n949 5.61655
R2184 VDD.n1889 VDD.n948 5.61655
R2185 VDD.n1889 VDD.n947 5.61655
R2186 VDD.n1881 VDD.n1626 5.61655
R2187 VDD.n1881 VDD.n1624 5.61655
R2188 VDD.n1881 VDD.n1623 5.61655
R2189 VDD.n1881 VDD.n1622 5.61655
R2190 VDD.n1862 VDD.n1644 5.61655
R2191 VDD.n1862 VDD.n1642 5.61655
R2192 VDD.n1862 VDD.n1641 5.61655
R2193 VDD.n1862 VDD.n1638 5.61655
R2194 VDD.n2065 VDD.n23 5.61655
R2195 VDD.n2065 VDD.n21 5.61655
R2196 VDD.n2065 VDD.n20 5.61655
R2197 VDD.n2065 VDD.n19 5.61655
R2198 VDD.n2065 VDD.n18 5.61655
R2199 VDD.n2065 VDD.n17 5.61655
R2200 VDD.n2065 VDD.n16 5.61655
R2201 VDD.n2065 VDD.n15 5.61655
R2202 VDD.n2065 VDD.n14 5.61655
R2203 VDD.n2065 VDD.n13 5.61655
R2204 VDD.n2065 VDD.n12 5.61655
R2205 VDD.n2065 VDD.n11 5.61655
R2206 VDD.n2065 VDD.n10 5.61655
R2207 VDD.n2065 VDD.n9 5.61655
R2208 VDD.n2065 VDD.n8 5.61655
R2209 VDD.n2065 VDD.n7 5.61655
R2210 VDD.n1685 VDD.n1 5.61655
R2211 VDD.n1729 VDD.n1 5.61655
R2212 VDD.n1751 VDD.n1 5.61655
R2213 VDD.n1773 VDD.n1 5.61655
R2214 VDD.n1795 VDD.n1 5.61655
R2215 VDD.n1652 VDD.n1 5.61655
R2216 VDD.n1671 VDD.n1 5.61655
R2217 VDD.n1483 VDD.n1006 4.25119
R2218 VDD.n1483 VDD.n1005 4.251
R2219 VDD.n1483 VDD.n1004 4.251
R2220 VDD.n1359 VDD.n1352 4.251
R2221 VDD.n1359 VDD.n1351 4.251
R2222 VDD.n1359 VDD.n1350 4.251
R2223 VDD.n1348 VDD.n1343 4.251
R2224 VDD.n1348 VDD.n1341 4.251
R2225 VDD.n1348 VDD.n1340 4.251
R2226 VDD.n1481 VDD.t464 4.2505
R2227 VDD.n1481 VDD.t82 4.2505
R2228 VDD.n1481 VDD.t440 4.2505
R2229 VDD.t85 VDD.n1481 4.2505
R2230 VDD.n1359 VDD.n1353 4.18701
R2231 VDD.n1359 VDD.n1358 4.18701
R2232 VDD.n1349 VDD.n1348 4.18701
R2233 VDD.n1483 VDD.n1482 3.40124
R2234 VDD.n1359 VDD.n1354 3.40124
R2235 VDD.n1348 VDD.n1347 3.40124
R2236 VDD.n1481 VDD.t48 3.4005
R2237 VDD.n1481 VDD.t51 3.4005
R2238 VDD.n1481 VDD.t451 3.4005
R2239 VDD.n1493 VDD.t1135 2.83383
R2240 VDD.n1497 VDD.t917 2.83383
R2241 VDD.n1501 VDD.t824 2.83383
R2242 VDD.n1481 VDD.t87 2.83383
R2243 VDD.n1484 VDD.n1483 2.73623
R2244 VDD.n1360 VDD.n1359 2.73623
R2245 VDD.n1348 VDD.n1342 2.73623
R2246 VDD.n1348 VDD.n1346 2.73623
R2247 VDD.n33 VDD.t1138 2.1255
R2248 VDD.n340 VDD.t92 2.1255
R2249 VDD.n331 VDD.t1128 2.1255
R2250 VDD.n670 VDD.t37 1.88939
R2251 VDD.n1483 VDD.n1007 1.59844
R2252 VDD.n1481 VDD.t330 1.54595
R2253 VDD.n1358 VDD 1.42902
R2254 VDD VDD.n1349 1.42902
R2255 VDD.n1481 VDD.t80 1.41717
R2256 VDD.n1505 VDD.n1504 1.15016
R2257 VDD.n52 VDD.t9 1.0005
R2258 VDD.n1330 VDD.t470 0.810024
R2259 VDD.n1457 VDD.t503 0.810024
R2260 VDD.n1388 VDD.t301 0.810024
R2261 VDD.n1486 VDD.n1002 0.773643
R2262 VDD.n1364 VDD.n1362 0.773643
R2263 VDD.n1306 VDD.n995 0.773643
R2264 VDD.n1414 VDD.n1064 0.744729
R2265 VDD.n1425 VDD.n1424 0.744729
R2266 VDD.n1460 VDD.n1120 0.744729
R2267 VDD.n1394 VDD.n1392 0.744729
R2268 VDD.n1257 VDD.n1256 0.744729
R2269 VDD.n1334 VDD.n1274 0.744729
R2270 VDD.n1370 VDD.n1369 0.744729
R2271 VDD.n1292 VDD.n1291 0.744729
R2272 VDD.n1312 VDD.n1311 0.744729
R2273 VDD.n2057 VDD.t343 0.53175
R2274 VDD.n2037 VDD.t347 0.53175
R2275 VDD.n1993 VDD.t202 0.53175
R2276 VDD.n1977 VDD.t215 0.53175
R2277 VDD.n1933 VDD.t547 0.53175
R2278 VDD.n1925 VDD.t552 0.53175
R2279 VDD.n1881 VDD.t673 0.53175
R2280 VDD.n1862 VDD.t677 0.53175
R2281 VDD.n1473 VDD.n1064 0.466271
R2282 VDD.n1425 VDD.n1133 0.466271
R2283 VDD.n1461 VDD.n1460 0.466271
R2284 VDD.n1392 VDD.n1239 0.466271
R2285 VDD.n1257 VDD.n1253 0.466271
R2286 VDD.n1336 VDD.n1334 0.466271
R2287 VDD.n1370 VDD.n1366 0.466271
R2288 VDD.n1292 VDD.n1288 0.466271
R2289 VDD.n1312 VDD.n1308 0.466271
R2290 VDD.n1504 VDD.n995 0.446157
R2291 VDD.n1474 VDD.n1473 0.443014
R2292 VDD.n1461 VDD.n1002 0.443014
R2293 VDD.n1356 VDD.n1239 0.443014
R2294 VDD.n1338 VDD.n1336 0.443014
R2295 VDD.n1366 VDD.n1364 0.443014
R2296 VDD.n1308 VDD.n1306 0.443014
R2297 VDD.n2062 VDD.n2061 0.441129
R2298 VDD.n2061 VDD.n148 0.441129
R2299 VDD.n2018 VDD.n148 0.441129
R2300 VDD.n2018 VDD.n2017 0.441129
R2301 VDD.n2017 VDD.n303 0.441129
R2302 VDD.n1974 VDD.n303 0.441129
R2303 VDD.n1974 VDD.n1973 0.441129
R2304 VDD.n1973 VDD.n519 0.441129
R2305 VDD.n1930 VDD.n519 0.441129
R2306 VDD.n1930 VDD.n1929 0.441129
R2307 VDD.n1929 VDD.n820 0.441129
R2308 VDD.n1886 VDD.n820 0.441129
R2309 VDD.n1886 VDD.n1885 0.441129
R2310 VDD.n1806 VDD.n1803 0.441129
R2311 VDD.n1809 VDD.n1806 0.441129
R2312 VDD.n1812 VDD.n1809 0.441129
R2313 VDD.n1815 VDD.n1812 0.441129
R2314 VDD.n1818 VDD.n1815 0.441129
R2315 VDD.n1821 VDD.n1818 0.441129
R2316 VDD.n1824 VDD.n1821 0.441129
R2317 VDD.n1827 VDD.n1824 0.441129
R2318 VDD.n1830 VDD.n1827 0.441129
R2319 VDD.n1833 VDD.n1830 0.441129
R2320 VDD.n1836 VDD.n1833 0.441129
R2321 VDD.n1839 VDD.n1836 0.441129
R2322 VDD.n1842 VDD.n1839 0.441129
R2323 VDD.n2042 VDD.n167 0.441129
R2324 VDD.n2042 VDD.n2041 0.441129
R2325 VDD.n2041 VDD.n168 0.441129
R2326 VDD.n1998 VDD.n168 0.441129
R2327 VDD.n1998 VDD.n1997 0.441129
R2328 VDD.n1997 VDD.n469 0.441129
R2329 VDD.n1954 VDD.n469 0.441129
R2330 VDD.n1954 VDD.n1953 0.441129
R2331 VDD.n1953 VDD.n621 0.441129
R2332 VDD.n1910 VDD.n621 0.441129
R2333 VDD.n1910 VDD.n1909 0.441129
R2334 VDD.n1909 VDD.n837 0.441129
R2335 VDD.n1866 VDD.n837 0.441129
R2336 VDD.n2069 VDD.n3 0.441129
R2337 VDD.n2026 VDD.n3 0.441129
R2338 VDD.n2026 VDD.n2025 0.441129
R2339 VDD.n2025 VDD.n189 0.441129
R2340 VDD.n1982 VDD.n189 0.441129
R2341 VDD.n1982 VDD.n1981 0.441129
R2342 VDD.n1981 VDD.n490 0.441129
R2343 VDD.n1938 VDD.n490 0.441129
R2344 VDD.n1938 VDD.n1937 0.441129
R2345 VDD.n1937 VDD.n791 0.441129
R2346 VDD.n1894 VDD.n791 0.441129
R2347 VDD.n1894 VDD.n1893 0.441129
R2348 VDD.n1893 VDD.n943 0.441129
R2349 VDD.n1007 VDD 0.390575
R2350 VDD.n1329 VDD.n1328 0.375108
R2351 VDD.n1284 VDD.n1283 0.375108
R2352 VDD.n1387 VDD.n1386 0.375108
R2353 VDD.n1456 VDD.n1455 0.375108
R2354 VDD.n1129 VDD.n1128 0.375108
R2355 VDD.n1249 VDD.n1248 0.375108
R2356 VDD.n1346 VDD.n1339 0.359255
R2357 VDD.n1484 VDD 0.351811
R2358 VDD.n1360 VDD 0.351811
R2359 VDD.n1342 VDD 0.351811
R2360 VDD.n1328 VDD.n1327 0.351125
R2361 VDD.n1325 VDD.n1324 0.351125
R2362 VDD.n1321 VDD.n1320 0.351125
R2363 VDD.n1277 VDD.n1276 0.351125
R2364 VDD.n1279 VDD.n1278 0.351125
R2365 VDD.n1317 VDD.n1316 0.351125
R2366 VDD.n1304 VDD.n1303 0.351125
R2367 VDD.n1300 VDD.n1299 0.351125
R2368 VDD.n1297 VDD.n1296 0.351125
R2369 VDD.n1286 VDD.n1285 0.351125
R2370 VDD.n1283 VDD.n1282 0.351125
R2371 VDD.n1386 VDD.n1385 0.351125
R2372 VDD.n1383 VDD.n1382 0.351125
R2373 VDD.n1379 VDD.n1378 0.351125
R2374 VDD.n1455 VDD.n1454 0.351125
R2375 VDD.n1452 VDD.n1451 0.351125
R2376 VDD.n1448 VDD.n1447 0.351125
R2377 VDD.n1443 VDD.n1442 0.351125
R2378 VDD.n1439 VDD.n1438 0.351125
R2379 VDD.n1435 VDD.n1434 0.351125
R2380 VDD.n1122 VDD.n1121 0.351125
R2381 VDD.n1125 VDD.n1124 0.351125
R2382 VDD.n1430 VDD.n1429 0.351125
R2383 VDD.n1131 VDD.n1130 0.351125
R2384 VDD.n1128 VDD.n1127 0.351125
R2385 VDD.n1242 VDD.n1241 0.351125
R2386 VDD.n1244 VDD.n1243 0.351125
R2387 VDD.n1375 VDD.n1374 0.351125
R2388 VDD.n1269 VDD.n1268 0.351125
R2389 VDD.n1265 VDD.n1264 0.351125
R2390 VDD.n1262 VDD.n1261 0.351125
R2391 VDD.n1251 VDD.n1250 0.351125
R2392 VDD.n1248 VDD.n1247 0.351125
R2393 VDD.n1326 VDD.n1325 0.31675
R2394 VDD.n1322 VDD.n1321 0.31675
R2395 VDD.n1332 VDD.n1277 0.31675
R2396 VDD.n1280 VDD.n1279 0.31675
R2397 VDD.n1318 VDD.n1317 0.31675
R2398 VDD.n1314 VDD.n1304 0.31675
R2399 VDD.n1301 VDD.n1300 0.31675
R2400 VDD.n1298 VDD.n1297 0.31675
R2401 VDD.n1294 VDD.n1286 0.31675
R2402 VDD.n1384 VDD.n1383 0.31675
R2403 VDD.n1380 VDD.n1379 0.31675
R2404 VDD.n1453 VDD.n1452 0.31675
R2405 VDD.n1449 VDD.n1448 0.31675
R2406 VDD.n1444 VDD.n1443 0.31675
R2407 VDD.n1440 VDD.n1439 0.31675
R2408 VDD.n1436 VDD.n1435 0.31675
R2409 VDD.n1123 VDD.n1122 0.31675
R2410 VDD.n1126 VDD.n1125 0.31675
R2411 VDD.n1431 VDD.n1430 0.31675
R2412 VDD.n1427 VDD.n1131 0.31675
R2413 VDD.n1390 VDD.n1242 0.31675
R2414 VDD.n1245 VDD.n1244 0.31675
R2415 VDD.n1376 VDD.n1375 0.31675
R2416 VDD.n1372 VDD.n1269 0.31675
R2417 VDD.n1266 VDD.n1265 0.31675
R2418 VDD.n1263 VDD.n1262 0.31675
R2419 VDD.n1259 VDD.n1251 0.31675
R2420 VDD.n1485 VDD.n1484 0.300181
R2421 VDD.n1361 VDD.n1360 0.300181
R2422 VDD.n1344 VDD.n1342 0.300181
R2423 VDD.n1357 VDD.n1353 0.258739
R2424 VDD.n1346 VDD 0.258108
R2425 VDD.n1470 VDD.t0 0.246877
R2426 VDD.n1421 VDD.t34 0.246877
R2427 VDD.n1411 VDD.t75 0.246877
R2428 VDD VDD.n1271 0.208474
R2429 VDD.n217 VDD.n214 0.174969
R2430 VDD.n545 VDD.n542 0.174969
R2431 VDD.n656 VDD.n653 0.174969
R2432 VDD.n649 VDD.n646 0.174969
R2433 VDD.n1329 VDD.n1326 0.174969
R2434 VDD.n1323 VDD.n1322 0.174969
R2435 VDD.n1331 VDD.n1280 0.174969
R2436 VDD.n1319 VDD.n1318 0.174969
R2437 VDD.n1302 VDD.n1298 0.174969
R2438 VDD.n1456 VDD.n1453 0.174969
R2439 VDD.n1450 VDD.n1449 0.174969
R2440 VDD.n1441 VDD.n1440 0.174969
R2441 VDD.n1437 VDD.n1436 0.174969
R2442 VDD.n1432 VDD.n1431 0.174969
R2443 VDD.n1387 VDD.n1384 0.174969
R2444 VDD.n1381 VDD.n1380 0.174969
R2445 VDD.n1389 VDD.n1245 0.174969
R2446 VDD.n1377 VDD.n1376 0.174969
R2447 VDD.n1267 VDD.n1263 0.174969
R2448 VDD.n865 VDD.n862 0.174969
R2449 VDD.n978 VDD.n975 0.174969
R2450 VDD.n971 VDD.n968 0.174969
R2451 VDD.n2075 VDD.n2074 0.174969
R2452 VDD.n1661 VDD.n1660 0.174969
R2453 VDD.n1785 VDD.n1784 0.174969
R2454 VDD.n1763 VDD.n1762 0.174969
R2455 VDD.n1741 VDD.n1740 0.174969
R2456 VDD.n1719 VDD.n1718 0.174969
R2457 VDD.n1697 VDD.n1696 0.174969
R2458 VDD.n1675 VDD.n1674 0.174969
R2459 VDD.n1667 VDD.n1666 0.174969
R2460 VDD.n1361 VDD.n1271 0.165017
R2461 VDD VDD.n204 0.158673
R2462 VDD VDD.n532 0.158673
R2463 VDD VDD.n852 0.158673
R2464 VDD.n1707 VDD 0.158673
R2465 VDD.n1358 VDD.n1357 0.157653
R2466 VDD.n1349 VDD.n1339 0.157653
R2467 VDD.n1353 VDD 0.156635
R2468 VDD.n53 VDD 0.152562
R2469 VDD.n34 VDD 0.152562
R2470 VDD.n2058 VDD 0.152562
R2471 VDD.n2049 VDD 0.152562
R2472 VDD.n163 VDD 0.152562
R2473 VDD.n157 VDD 0.152562
R2474 VDD.n2033 VDD 0.152562
R2475 VDD.n187 VDD 0.152562
R2476 VDD.n2038 VDD 0.152562
R2477 VDD.n179 VDD 0.152562
R2478 VDD.n341 VDD 0.152562
R2479 VDD.n332 VDD 0.152562
R2480 VDD.n301 VDD 0.152562
R2481 VDD.n2022 VDD 0.152562
R2482 VDD.n291 VDD 0.152562
R2483 VDD.n285 VDD 0.152562
R2484 VDD.n279 VDD 0.152562
R2485 VDD.n273 VDD 0.152562
R2486 VDD.n267 VDD 0.152562
R2487 VDD.n261 VDD 0.152562
R2488 VDD.n255 VDD 0.152562
R2489 VDD.n249 VDD 0.152562
R2490 VDD.n243 VDD 0.152562
R2491 VDD.n237 VDD 0.152562
R2492 VDD.n232 VDD 0.152562
R2493 VDD.n226 VDD 0.152562
R2494 VDD.n220 VDD 0.152562
R2495 VDD.n213 VDD 0.152562
R2496 VDD.n2014 VDD 0.152562
R2497 VDD.n2005 VDD 0.152562
R2498 VDD.n467 VDD 0.152562
R2499 VDD.n461 VDD 0.152562
R2500 VDD.n451 VDD 0.152562
R2501 VDD.n441 VDD 0.152562
R2502 VDD.n431 VDD 0.152562
R2503 VDD.n421 VDD 0.152562
R2504 VDD.n411 VDD 0.152562
R2505 VDD.n401 VDD 0.152562
R2506 VDD.n391 VDD 0.152562
R2507 VDD.n381 VDD 0.152562
R2508 VDD.n371 VDD 0.152562
R2509 VDD.n361 VDD 0.152562
R2510 VDD.n351 VDD 0.152562
R2511 VDD.n324 VDD 0.152562
R2512 VDD.n1989 VDD 0.152562
R2513 VDD.n488 VDD 0.152562
R2514 VDD.n1994 VDD 0.152562
R2515 VDD.n480 VDD 0.152562
R2516 VDD.n517 VDD 0.152562
R2517 VDD.n1978 VDD 0.152562
R2518 VDD.n507 VDD 0.152562
R2519 VDD.n501 VDD 0.152562
R2520 VDD.n1970 VDD 0.152562
R2521 VDD.n1961 VDD 0.152562
R2522 VDD.n619 VDD 0.152562
R2523 VDD.n613 VDD 0.152562
R2524 VDD.n607 VDD 0.152562
R2525 VDD.n601 VDD 0.152562
R2526 VDD.n595 VDD 0.152562
R2527 VDD.n589 VDD 0.152562
R2528 VDD.n583 VDD 0.152562
R2529 VDD.n577 VDD 0.152562
R2530 VDD.n571 VDD 0.152562
R2531 VDD.n565 VDD 0.152562
R2532 VDD.n560 VDD 0.152562
R2533 VDD.n554 VDD 0.152562
R2534 VDD.n548 VDD 0.152562
R2535 VDD.n541 VDD 0.152562
R2536 VDD.n1945 VDD 0.152562
R2537 VDD.n789 VDD 0.152562
R2538 VDD.n1950 VDD 0.152562
R2539 VDD.n781 VDD 0.152562
R2540 VDD.n771 VDD 0.152562
R2541 VDD.n761 VDD 0.152562
R2542 VDD.n751 VDD 0.152562
R2543 VDD.n741 VDD 0.152562
R2544 VDD.n731 VDD 0.152562
R2545 VDD.n721 VDD 0.152562
R2546 VDD.n711 VDD 0.152562
R2547 VDD.n701 VDD 0.152562
R2548 VDD.n691 VDD 0.152562
R2549 VDD.n681 VDD 0.152562
R2550 VDD.n659 VDD 0.152562
R2551 VDD.n652 VDD 0.152562
R2552 VDD.n645 VDD 0.152562
R2553 VDD.n818 VDD 0.152562
R2554 VDD.n1934 VDD 0.152562
R2555 VDD.n808 VDD 0.152562
R2556 VDD.n802 VDD 0.152562
R2557 VDD.n1926 VDD 0.152562
R2558 VDD.n1917 VDD 0.152562
R2559 VDD.n835 VDD 0.152562
R2560 VDD.n829 VDD 0.152562
R2561 VDD VDD.n1072 0.152562
R2562 VDD.n1105 VDD 0.152562
R2563 VDD VDD.n1090 0.152562
R2564 VDD.n1420 VDD 0.152562
R2565 VDD VDD.n1140 0.152562
R2566 VDD.n1169 VDD 0.152562
R2567 VDD VDD.n1197 0.152562
R2568 VDD.n1230 VDD 0.152562
R2569 VDD VDD.n1215 0.152562
R2570 VDD.n1480 VDD 0.152562
R2571 VDD VDD.n1014 0.152562
R2572 VDD.n1043 VDD 0.152562
R2573 VDD.n1901 VDD 0.152562
R2574 VDD.n941 VDD 0.152562
R2575 VDD.n1906 VDD 0.152562
R2576 VDD.n933 VDD 0.152562
R2577 VDD.n927 VDD 0.152562
R2578 VDD.n921 VDD 0.152562
R2579 VDD.n915 VDD 0.152562
R2580 VDD.n909 VDD 0.152562
R2581 VDD.n903 VDD 0.152562
R2582 VDD.n897 VDD 0.152562
R2583 VDD.n891 VDD 0.152562
R2584 VDD.n885 VDD 0.152562
R2585 VDD.n880 VDD 0.152562
R2586 VDD.n874 VDD 0.152562
R2587 VDD.n868 VDD 0.152562
R2588 VDD.n861 VDD 0.152562
R2589 VDD.n1618 VDD 0.152562
R2590 VDD.n1890 VDD 0.152562
R2591 VDD.n1608 VDD 0.152562
R2592 VDD.n1602 VDD 0.152562
R2593 VDD.n1592 VDD 0.152562
R2594 VDD.n1582 VDD 0.152562
R2595 VDD.n1572 VDD 0.152562
R2596 VDD.n1562 VDD 0.152562
R2597 VDD.n1552 VDD 0.152562
R2598 VDD.n1542 VDD 0.152562
R2599 VDD.n1532 VDD 0.152562
R2600 VDD.n1522 VDD 0.152562
R2601 VDD.n1512 VDD 0.152562
R2602 VDD.n991 VDD 0.152562
R2603 VDD.n981 VDD 0.152562
R2604 VDD.n974 VDD 0.152562
R2605 VDD.n967 VDD 0.152562
R2606 VDD.n1882 VDD 0.152562
R2607 VDD.n1873 VDD 0.152562
R2608 VDD.n1635 VDD 0.152562
R2609 VDD.n1629 VDD 0.152562
R2610 VDD.n1860 VDD 0.152562
R2611 VDD.n1851 VDD 0.152562
R2612 VDD.n1863 VDD 0.152562
R2613 VDD.n1647 VDD 0.152562
R2614 VDD.n143 VDD 0.152562
R2615 VDD.n2066 VDD 0.152562
R2616 VDD.n135 VDD 0.152562
R2617 VDD.n129 VDD 0.152562
R2618 VDD.n123 VDD 0.152562
R2619 VDD.n117 VDD 0.152562
R2620 VDD.n111 VDD 0.152562
R2621 VDD.n105 VDD 0.152562
R2622 VDD.n99 VDD 0.152562
R2623 VDD.n93 VDD 0.152562
R2624 VDD.n87 VDD 0.152562
R2625 VDD.n81 VDD 0.152562
R2626 VDD.n75 VDD 0.152562
R2627 VDD.n69 VDD 0.152562
R2628 VDD.n63 VDD 0.152562
R2629 VDD.n26 VDD 0.152562
R2630 VDD VDD.n0 0.152562
R2631 VDD VDD.n2076 0.152562
R2632 VDD VDD.n1649 0.152562
R2633 VDD VDD.n1658 0.152562
R2634 VDD.n1659 VDD 0.152562
R2635 VDD.n1798 VDD 0.152562
R2636 VDD.n1787 VDD 0.152562
R2637 VDD VDD.n1786 0.152562
R2638 VDD.n1776 VDD 0.152562
R2639 VDD.n1765 VDD 0.152562
R2640 VDD VDD.n1764 0.152562
R2641 VDD.n1754 VDD 0.152562
R2642 VDD.n1743 VDD 0.152562
R2643 VDD VDD.n1742 0.152562
R2644 VDD.n1732 VDD 0.152562
R2645 VDD.n1721 VDD 0.152562
R2646 VDD VDD.n1720 0.152562
R2647 VDD.n1710 VDD 0.152562
R2648 VDD.n1699 VDD 0.152562
R2649 VDD VDD.n1698 0.152562
R2650 VDD.n1688 VDD 0.152562
R2651 VDD.n1677 VDD 0.152562
R2652 VDD VDD.n1676 0.152562
R2653 VDD VDD.n1668 0.152562
R2654 VDD.n2021 VDD.t198 0.133313
R2655 VDD.n2013 VDD.t126 0.133313
R2656 VDD.n1969 VDD.t173 0.133313
R2657 VDD.n1905 VDD.t679 0.133313
R2658 VDD.n2065 VDD.t5 0.133313
R2659 VDD.n1 VDD.t341 0.133313
R2660 VDD.n1949 VDD.t17 0.1255
R2661 VDD.n1889 VDD.t99 0.1255
R2662 VDD.n1333 VDD.n1275 0.120988
R2663 VDD.n1446 VDD.n1445 0.120988
R2664 VDD.n1391 VDD.n1240 0.120988
R2665 VDD.n43 VDD.n41 0.11699
R2666 VDD.n30 VDD.n29 0.11699
R2667 VDD.n154 VDD.n153 0.11699
R2668 VDD.n158 VDD.n152 0.11699
R2669 VDD.n2044 VDD.n151 0.11699
R2670 VDD.n2052 VDD.n150 0.11699
R2671 VDD.n176 VDD.n175 0.11699
R2672 VDD.n180 VDD.n174 0.11699
R2673 VDD.n173 VDD.n172 0.11699
R2674 VDD.n2028 VDD.n170 0.11699
R2675 VDD.n337 VDD.n336 0.11699
R2676 VDD.n328 VDD.n327 0.11699
R2677 VDD.n210 VDD.n209 0.11699
R2678 VDD.n215 VDD.n208 0.11699
R2679 VDD.n221 VDD.n207 0.11699
R2680 VDD.n227 VDD.n206 0.11699
R2681 VDD.n238 VDD.n203 0.11699
R2682 VDD.n244 VDD.n202 0.11699
R2683 VDD.n250 VDD.n201 0.11699
R2684 VDD.n256 VDD.n200 0.11699
R2685 VDD.n262 VDD.n199 0.11699
R2686 VDD.n268 VDD.n198 0.11699
R2687 VDD.n274 VDD.n197 0.11699
R2688 VDD.n280 VDD.n196 0.11699
R2689 VDD.n286 VDD.n195 0.11699
R2690 VDD.n294 VDD.n194 0.11699
R2691 VDD.n193 VDD.n192 0.11699
R2692 VDD.n321 VDD.n320 0.11699
R2693 VDD.n346 VDD.n319 0.11699
R2694 VDD.n356 VDD.n318 0.11699
R2695 VDD.n366 VDD.n317 0.11699
R2696 VDD.n376 VDD.n316 0.11699
R2697 VDD.n386 VDD.n315 0.11699
R2698 VDD.n396 VDD.n314 0.11699
R2699 VDD.n406 VDD.n313 0.11699
R2700 VDD.n416 VDD.n312 0.11699
R2701 VDD.n426 VDD.n311 0.11699
R2702 VDD.n436 VDD.n310 0.11699
R2703 VDD.n446 VDD.n309 0.11699
R2704 VDD.n456 VDD.n308 0.11699
R2705 VDD.n462 VDD.n307 0.11699
R2706 VDD.n2000 VDD.n306 0.11699
R2707 VDD.n2008 VDD.n305 0.11699
R2708 VDD.n477 VDD.n476 0.11699
R2709 VDD.n481 VDD.n475 0.11699
R2710 VDD.n474 VDD.n473 0.11699
R2711 VDD.n1984 VDD.n471 0.11699
R2712 VDD.n498 VDD.n497 0.11699
R2713 VDD.n502 VDD.n496 0.11699
R2714 VDD.n510 VDD.n495 0.11699
R2715 VDD.n494 VDD.n493 0.11699
R2716 VDD.n538 VDD.n537 0.11699
R2717 VDD.n543 VDD.n536 0.11699
R2718 VDD.n549 VDD.n535 0.11699
R2719 VDD.n555 VDD.n534 0.11699
R2720 VDD.n566 VDD.n531 0.11699
R2721 VDD.n572 VDD.n530 0.11699
R2722 VDD.n578 VDD.n529 0.11699
R2723 VDD.n584 VDD.n528 0.11699
R2724 VDD.n590 VDD.n527 0.11699
R2725 VDD.n596 VDD.n526 0.11699
R2726 VDD.n602 VDD.n525 0.11699
R2727 VDD.n608 VDD.n524 0.11699
R2728 VDD.n614 VDD.n523 0.11699
R2729 VDD.n1956 VDD.n522 0.11699
R2730 VDD.n1964 VDD.n521 0.11699
R2731 VDD.n642 VDD.n641 0.11699
R2732 VDD.n647 VDD.n640 0.11699
R2733 VDD.n654 VDD.n639 0.11699
R2734 VDD.n676 VDD.n638 0.11699
R2735 VDD.n686 VDD.n637 0.11699
R2736 VDD.n696 VDD.n636 0.11699
R2737 VDD.n706 VDD.n635 0.11699
R2738 VDD.n716 VDD.n634 0.11699
R2739 VDD.n726 VDD.n633 0.11699
R2740 VDD.n736 VDD.n632 0.11699
R2741 VDD.n746 VDD.n631 0.11699
R2742 VDD.n756 VDD.n630 0.11699
R2743 VDD.n766 VDD.n629 0.11699
R2744 VDD.n776 VDD.n628 0.11699
R2745 VDD.n782 VDD.n627 0.11699
R2746 VDD.n626 VDD.n625 0.11699
R2747 VDD.n1940 VDD.n623 0.11699
R2748 VDD.n799 VDD.n798 0.11699
R2749 VDD.n803 VDD.n797 0.11699
R2750 VDD.n811 VDD.n796 0.11699
R2751 VDD.n795 VDD.n794 0.11699
R2752 VDD.n826 VDD.n825 0.11699
R2753 VDD.n830 VDD.n824 0.11699
R2754 VDD.n1912 VDD.n823 0.11699
R2755 VDD.n1920 VDD.n822 0.11699
R2756 VDD.n1295 VDD.n1294 0.11699
R2757 VDD.n1315 VDD.n1314 0.11699
R2758 VDD.n1428 VDD.n1427 0.11699
R2759 VDD.n1433 VDD.n1123 0.11699
R2760 VDD.n1260 VDD.n1259 0.11699
R2761 VDD.n1373 VDD.n1372 0.11699
R2762 VDD.n858 VDD.n857 0.11699
R2763 VDD.n863 VDD.n856 0.11699
R2764 VDD.n869 VDD.n855 0.11699
R2765 VDD.n875 VDD.n854 0.11699
R2766 VDD.n886 VDD.n851 0.11699
R2767 VDD.n892 VDD.n850 0.11699
R2768 VDD.n898 VDD.n849 0.11699
R2769 VDD.n904 VDD.n848 0.11699
R2770 VDD.n910 VDD.n847 0.11699
R2771 VDD.n916 VDD.n846 0.11699
R2772 VDD.n922 VDD.n845 0.11699
R2773 VDD.n928 VDD.n844 0.11699
R2774 VDD.n934 VDD.n843 0.11699
R2775 VDD.n842 VDD.n841 0.11699
R2776 VDD.n1896 VDD.n839 0.11699
R2777 VDD.n964 VDD.n963 0.11699
R2778 VDD.n969 VDD.n962 0.11699
R2779 VDD.n976 VDD.n961 0.11699
R2780 VDD.n986 VDD.n960 0.11699
R2781 VDD.n1507 VDD.n959 0.11699
R2782 VDD.n1517 VDD.n958 0.11699
R2783 VDD.n1527 VDD.n957 0.11699
R2784 VDD.n1537 VDD.n956 0.11699
R2785 VDD.n1547 VDD.n955 0.11699
R2786 VDD.n1557 VDD.n954 0.11699
R2787 VDD.n1567 VDD.n953 0.11699
R2788 VDD.n1577 VDD.n952 0.11699
R2789 VDD.n1587 VDD.n951 0.11699
R2790 VDD.n1597 VDD.n950 0.11699
R2791 VDD.n1603 VDD.n949 0.11699
R2792 VDD.n1611 VDD.n948 0.11699
R2793 VDD.n947 VDD.n946 0.11699
R2794 VDD.n1626 VDD.n1625 0.11699
R2795 VDD.n1630 VDD.n1624 0.11699
R2796 VDD.n1868 VDD.n1623 0.11699
R2797 VDD.n1876 VDD.n1622 0.11699
R2798 VDD.n1644 VDD.n1643 0.11699
R2799 VDD.n1844 VDD.n1642 0.11699
R2800 VDD.n1641 VDD.n1640 0.11699
R2801 VDD.n1854 VDD.n1638 0.11699
R2802 VDD.n23 VDD.n22 0.11699
R2803 VDD.n58 VDD.n21 0.11699
R2804 VDD.n64 VDD.n20 0.11699
R2805 VDD.n70 VDD.n19 0.11699
R2806 VDD.n76 VDD.n18 0.11699
R2807 VDD.n82 VDD.n17 0.11699
R2808 VDD.n88 VDD.n16 0.11699
R2809 VDD.n94 VDD.n15 0.11699
R2810 VDD.n100 VDD.n14 0.11699
R2811 VDD.n106 VDD.n13 0.11699
R2812 VDD.n112 VDD.n12 0.11699
R2813 VDD.n118 VDD.n11 0.11699
R2814 VDD.n124 VDD.n10 0.11699
R2815 VDD.n130 VDD.n9 0.11699
R2816 VDD.n136 VDD.n8 0.11699
R2817 VDD.n7 VDD.n6 0.11699
R2818 VDD.n1652 VDD.n1651 0.11699
R2819 VDD.n1796 VDD.n1795 0.11699
R2820 VDD.n1774 VDD.n1773 0.11699
R2821 VDD.n1752 VDD.n1751 0.11699
R2822 VDD.n1730 VDD.n1729 0.11699
R2823 VDD.n1686 VDD.n1685 0.11699
R2824 VDD.n1672 VDD.n1671 0.11699
R2825 VDD.n55 VDD.n37 0.116914
R2826 VDD.n36 VDD.n28 0.116914
R2827 VDD.n2060 VDD.n149 0.116914
R2828 VDD.n2054 VDD.n2051 0.116914
R2829 VDD.n2046 VDD.n2043 0.116914
R2830 VDD.n1805 VDD.n160 0.116914
R2831 VDD.n2036 VDD.n2035 0.116914
R2832 VDD.n2030 VDD.n2027 0.116914
R2833 VDD.n2040 VDD.n169 0.116914
R2834 VDD.n1808 VDD.n182 0.116914
R2835 VDD.n343 VDD.n335 0.116914
R2836 VDD.n334 VDD.n326 0.116914
R2837 VDD.n2020 VDD.n2019 0.116914
R2838 VDD.n2024 VDD.n190 0.116914
R2839 VDD.n296 VDD.n293 0.116914
R2840 VDD.n1811 VDD.n288 0.116914
R2841 VDD.n454 VDD.n282 0.116914
R2842 VDD.n444 VDD.n276 0.116914
R2843 VDD.n434 VDD.n270 0.116914
R2844 VDD.n424 VDD.n264 0.116914
R2845 VDD.n414 VDD.n258 0.116914
R2846 VDD.n404 VDD.n252 0.116914
R2847 VDD.n394 VDD.n246 0.116914
R2848 VDD.n384 VDD.n240 0.116914
R2849 VDD.n374 VDD.n234 0.116914
R2850 VDD.n364 VDD.n229 0.116914
R2851 VDD.n354 VDD.n223 0.116914
R2852 VDD.n2016 VDD.n304 0.116914
R2853 VDD.n2010 VDD.n2007 0.116914
R2854 VDD.n2002 VDD.n1999 0.116914
R2855 VDD.n1814 VDD.n464 0.116914
R2856 VDD.n458 VDD.n455 0.116914
R2857 VDD.n448 VDD.n445 0.116914
R2858 VDD.n438 VDD.n435 0.116914
R2859 VDD.n428 VDD.n425 0.116914
R2860 VDD.n418 VDD.n415 0.116914
R2861 VDD.n408 VDD.n405 0.116914
R2862 VDD.n398 VDD.n395 0.116914
R2863 VDD.n388 VDD.n385 0.116914
R2864 VDD.n378 VDD.n375 0.116914
R2865 VDD.n368 VDD.n365 0.116914
R2866 VDD.n358 VDD.n355 0.116914
R2867 VDD.n348 VDD.n345 0.116914
R2868 VDD.n1992 VDD.n1991 0.116914
R2869 VDD.n1986 VDD.n1983 0.116914
R2870 VDD.n1996 VDD.n470 0.116914
R2871 VDD.n1817 VDD.n483 0.116914
R2872 VDD.n1976 VDD.n1975 0.116914
R2873 VDD.n1980 VDD.n491 0.116914
R2874 VDD.n512 VDD.n509 0.116914
R2875 VDD.n1820 VDD.n504 0.116914
R2876 VDD.n1972 VDD.n520 0.116914
R2877 VDD.n1966 VDD.n1963 0.116914
R2878 VDD.n1958 VDD.n1955 0.116914
R2879 VDD.n1823 VDD.n616 0.116914
R2880 VDD.n774 VDD.n610 0.116914
R2881 VDD.n764 VDD.n604 0.116914
R2882 VDD.n754 VDD.n598 0.116914
R2883 VDD.n744 VDD.n592 0.116914
R2884 VDD.n734 VDD.n586 0.116914
R2885 VDD.n724 VDD.n580 0.116914
R2886 VDD.n714 VDD.n574 0.116914
R2887 VDD.n704 VDD.n568 0.116914
R2888 VDD.n694 VDD.n562 0.116914
R2889 VDD.n684 VDD.n557 0.116914
R2890 VDD.n662 VDD.n551 0.116914
R2891 VDD.n1948 VDD.n1947 0.116914
R2892 VDD.n1942 VDD.n1939 0.116914
R2893 VDD.n1952 VDD.n622 0.116914
R2894 VDD.n1826 VDD.n784 0.116914
R2895 VDD.n778 VDD.n775 0.116914
R2896 VDD.n768 VDD.n765 0.116914
R2897 VDD.n758 VDD.n755 0.116914
R2898 VDD.n748 VDD.n745 0.116914
R2899 VDD.n738 VDD.n735 0.116914
R2900 VDD.n728 VDD.n725 0.116914
R2901 VDD.n718 VDD.n715 0.116914
R2902 VDD.n708 VDD.n705 0.116914
R2903 VDD.n698 VDD.n695 0.116914
R2904 VDD.n688 VDD.n685 0.116914
R2905 VDD.n678 VDD.n675 0.116914
R2906 VDD.n1932 VDD.n1931 0.116914
R2907 VDD.n1936 VDD.n792 0.116914
R2908 VDD.n813 VDD.n810 0.116914
R2909 VDD.n1829 VDD.n805 0.116914
R2910 VDD.n1928 VDD.n821 0.116914
R2911 VDD.n1922 VDD.n1919 0.116914
R2912 VDD.n1914 VDD.n1911 0.116914
R2913 VDD.n1832 VDD.n832 0.116914
R2914 VDD.n1904 VDD.n1903 0.116914
R2915 VDD.n1898 VDD.n1895 0.116914
R2916 VDD.n1908 VDD.n838 0.116914
R2917 VDD.n1835 VDD.n936 0.116914
R2918 VDD.n1595 VDD.n930 0.116914
R2919 VDD.n1585 VDD.n924 0.116914
R2920 VDD.n1575 VDD.n918 0.116914
R2921 VDD.n1565 VDD.n912 0.116914
R2922 VDD.n1555 VDD.n906 0.116914
R2923 VDD.n1545 VDD.n900 0.116914
R2924 VDD.n1535 VDD.n894 0.116914
R2925 VDD.n1525 VDD.n888 0.116914
R2926 VDD.n1515 VDD.n882 0.116914
R2927 VDD.n994 VDD.n877 0.116914
R2928 VDD.n984 VDD.n871 0.116914
R2929 VDD.n1888 VDD.n1887 0.116914
R2930 VDD.n1892 VDD.n944 0.116914
R2931 VDD.n1613 VDD.n1610 0.116914
R2932 VDD.n1838 VDD.n1605 0.116914
R2933 VDD.n1599 VDD.n1596 0.116914
R2934 VDD.n1589 VDD.n1586 0.116914
R2935 VDD.n1579 VDD.n1576 0.116914
R2936 VDD.n1569 VDD.n1566 0.116914
R2937 VDD.n1559 VDD.n1556 0.116914
R2938 VDD.n1549 VDD.n1546 0.116914
R2939 VDD.n1539 VDD.n1536 0.116914
R2940 VDD.n1529 VDD.n1526 0.116914
R2941 VDD.n1519 VDD.n1516 0.116914
R2942 VDD.n1509 VDD.n1506 0.116914
R2943 VDD.n988 VDD.n985 0.116914
R2944 VDD.n1884 VDD.n1621 0.116914
R2945 VDD.n1878 VDD.n1875 0.116914
R2946 VDD.n1870 VDD.n1867 0.116914
R2947 VDD.n1841 VDD.n1632 0.116914
R2948 VDD.n1861 VDD.n1620 0.116914
R2949 VDD.n1856 VDD.n1853 0.116914
R2950 VDD.n1865 VDD.n1637 0.116914
R2951 VDD.n1846 VDD.n1843 0.116914
R2952 VDD.n2064 VDD.n2063 0.116914
R2953 VDD.n2068 VDD.n4 0.116914
R2954 VDD.n166 VDD.n138 0.116914
R2955 VDD.n1802 VDD.n132 0.116914
R2956 VDD.n1790 VDD.n126 0.116914
R2957 VDD.n1779 VDD.n120 0.116914
R2958 VDD.n1768 VDD.n114 0.116914
R2959 VDD.n1757 VDD.n108 0.116914
R2960 VDD.n1746 VDD.n102 0.116914
R2961 VDD.n1735 VDD.n96 0.116914
R2962 VDD.n1724 VDD.n90 0.116914
R2963 VDD.n1713 VDD.n84 0.116914
R2964 VDD.n1702 VDD.n78 0.116914
R2965 VDD.n1691 VDD.n72 0.116914
R2966 VDD.n1680 VDD.n66 0.116914
R2967 VDD.n60 VDD.n57 0.116914
R2968 VDD.n147 VDD.n145 0.116914
R2969 VDD.n2071 VDD.n2070 0.116914
R2970 VDD.n1656 VDD.n1655 0.116914
R2971 VDD.n1800 VDD.n1664 0.116914
R2972 VDD.n1792 VDD.n1791 0.116914
R2973 VDD.n1781 VDD.n1780 0.116914
R2974 VDD.n1770 VDD.n1769 0.116914
R2975 VDD.n1759 VDD.n1758 0.116914
R2976 VDD.n1748 VDD.n1747 0.116914
R2977 VDD.n1737 VDD.n1736 0.116914
R2978 VDD.n1726 VDD.n1725 0.116914
R2979 VDD.n1715 VDD.n1714 0.116914
R2980 VDD.n1704 VDD.n1703 0.116914
R2981 VDD.n1693 VDD.n1692 0.116914
R2982 VDD.n1682 VDD.n1681 0.116914
R2983 VDD.n43 VDD.n42 0.11665
R2984 VDD.n31 VDD.n30 0.11665
R2985 VDD.n2055 VDD.n150 0.11665
R2986 VDD.n2047 VDD.n151 0.11665
R2987 VDD.n161 VDD.n152 0.11665
R2988 VDD.n155 VDD.n154 0.11665
R2989 VDD.n2031 VDD.n170 0.11665
R2990 VDD.n185 VDD.n173 0.11665
R2991 VDD.n183 VDD.n174 0.11665
R2992 VDD.n177 VDD.n176 0.11665
R2993 VDD.n338 VDD.n337 0.11665
R2994 VDD.n329 VDD.n328 0.11665
R2995 VDD.n299 VDD.n193 0.11665
R2996 VDD.n297 VDD.n194 0.11665
R2997 VDD.n289 VDD.n195 0.11665
R2998 VDD.n283 VDD.n196 0.11665
R2999 VDD.n277 VDD.n197 0.11665
R3000 VDD.n271 VDD.n198 0.11665
R3001 VDD.n265 VDD.n199 0.11665
R3002 VDD.n259 VDD.n200 0.11665
R3003 VDD.n253 VDD.n201 0.11665
R3004 VDD.n247 VDD.n202 0.11665
R3005 VDD.n241 VDD.n203 0.11665
R3006 VDD.n230 VDD.n206 0.11665
R3007 VDD.n224 VDD.n207 0.11665
R3008 VDD.n218 VDD.n208 0.11665
R3009 VDD.n211 VDD.n210 0.11665
R3010 VDD.n2011 VDD.n305 0.11665
R3011 VDD.n2003 VDD.n306 0.11665
R3012 VDD.n465 VDD.n307 0.11665
R3013 VDD.n459 VDD.n308 0.11665
R3014 VDD.n449 VDD.n309 0.11665
R3015 VDD.n439 VDD.n310 0.11665
R3016 VDD.n429 VDD.n311 0.11665
R3017 VDD.n419 VDD.n312 0.11665
R3018 VDD.n409 VDD.n313 0.11665
R3019 VDD.n399 VDD.n314 0.11665
R3020 VDD.n389 VDD.n315 0.11665
R3021 VDD.n379 VDD.n316 0.11665
R3022 VDD.n369 VDD.n317 0.11665
R3023 VDD.n359 VDD.n318 0.11665
R3024 VDD.n349 VDD.n319 0.11665
R3025 VDD.n322 VDD.n321 0.11665
R3026 VDD.n1987 VDD.n471 0.11665
R3027 VDD.n486 VDD.n474 0.11665
R3028 VDD.n484 VDD.n475 0.11665
R3029 VDD.n478 VDD.n477 0.11665
R3030 VDD.n515 VDD.n494 0.11665
R3031 VDD.n513 VDD.n495 0.11665
R3032 VDD.n505 VDD.n496 0.11665
R3033 VDD.n499 VDD.n498 0.11665
R3034 VDD.n1967 VDD.n521 0.11665
R3035 VDD.n1959 VDD.n522 0.11665
R3036 VDD.n617 VDD.n523 0.11665
R3037 VDD.n611 VDD.n524 0.11665
R3038 VDD.n605 VDD.n525 0.11665
R3039 VDD.n599 VDD.n526 0.11665
R3040 VDD.n593 VDD.n527 0.11665
R3041 VDD.n587 VDD.n528 0.11665
R3042 VDD.n581 VDD.n529 0.11665
R3043 VDD.n575 VDD.n530 0.11665
R3044 VDD.n569 VDD.n531 0.11665
R3045 VDD.n558 VDD.n534 0.11665
R3046 VDD.n552 VDD.n535 0.11665
R3047 VDD.n546 VDD.n536 0.11665
R3048 VDD.n539 VDD.n538 0.11665
R3049 VDD.n1943 VDD.n623 0.11665
R3050 VDD.n787 VDD.n626 0.11665
R3051 VDD.n785 VDD.n627 0.11665
R3052 VDD.n779 VDD.n628 0.11665
R3053 VDD.n769 VDD.n629 0.11665
R3054 VDD.n759 VDD.n630 0.11665
R3055 VDD.n749 VDD.n631 0.11665
R3056 VDD.n739 VDD.n632 0.11665
R3057 VDD.n729 VDD.n633 0.11665
R3058 VDD.n719 VDD.n634 0.11665
R3059 VDD.n709 VDD.n635 0.11665
R3060 VDD.n699 VDD.n636 0.11665
R3061 VDD.n689 VDD.n637 0.11665
R3062 VDD.n679 VDD.n638 0.11665
R3063 VDD.n657 VDD.n639 0.11665
R3064 VDD.n650 VDD.n640 0.11665
R3065 VDD.n643 VDD.n642 0.11665
R3066 VDD.n816 VDD.n795 0.11665
R3067 VDD.n814 VDD.n796 0.11665
R3068 VDD.n806 VDD.n797 0.11665
R3069 VDD.n800 VDD.n799 0.11665
R3070 VDD.n1923 VDD.n822 0.11665
R3071 VDD.n1915 VDD.n823 0.11665
R3072 VDD.n833 VDD.n824 0.11665
R3073 VDD.n827 VDD.n826 0.11665
R3074 VDD.n1318 VDD.n1315 0.11665
R3075 VDD.n1298 VDD.n1295 0.11665
R3076 VDD.n1436 VDD.n1433 0.11665
R3077 VDD.n1431 VDD.n1428 0.11665
R3078 VDD.n1376 VDD.n1373 0.11665
R3079 VDD.n1263 VDD.n1260 0.11665
R3080 VDD.n1899 VDD.n839 0.11665
R3081 VDD.n939 VDD.n842 0.11665
R3082 VDD.n937 VDD.n843 0.11665
R3083 VDD.n931 VDD.n844 0.11665
R3084 VDD.n925 VDD.n845 0.11665
R3085 VDD.n919 VDD.n846 0.11665
R3086 VDD.n913 VDD.n847 0.11665
R3087 VDD.n907 VDD.n848 0.11665
R3088 VDD.n901 VDD.n849 0.11665
R3089 VDD.n895 VDD.n850 0.11665
R3090 VDD.n889 VDD.n851 0.11665
R3091 VDD.n878 VDD.n854 0.11665
R3092 VDD.n872 VDD.n855 0.11665
R3093 VDD.n866 VDD.n856 0.11665
R3094 VDD.n859 VDD.n858 0.11665
R3095 VDD.n1616 VDD.n947 0.11665
R3096 VDD.n1614 VDD.n948 0.11665
R3097 VDD.n1606 VDD.n949 0.11665
R3098 VDD.n1600 VDD.n950 0.11665
R3099 VDD.n1590 VDD.n951 0.11665
R3100 VDD.n1580 VDD.n952 0.11665
R3101 VDD.n1570 VDD.n953 0.11665
R3102 VDD.n1560 VDD.n954 0.11665
R3103 VDD.n1550 VDD.n955 0.11665
R3104 VDD.n1540 VDD.n956 0.11665
R3105 VDD.n1530 VDD.n957 0.11665
R3106 VDD.n1520 VDD.n958 0.11665
R3107 VDD.n1510 VDD.n959 0.11665
R3108 VDD.n989 VDD.n960 0.11665
R3109 VDD.n979 VDD.n961 0.11665
R3110 VDD.n972 VDD.n962 0.11665
R3111 VDD.n965 VDD.n964 0.11665
R3112 VDD.n1879 VDD.n1622 0.11665
R3113 VDD.n1871 VDD.n1623 0.11665
R3114 VDD.n1633 VDD.n1624 0.11665
R3115 VDD.n1627 VDD.n1626 0.11665
R3116 VDD.n1857 VDD.n1638 0.11665
R3117 VDD.n1849 VDD.n1641 0.11665
R3118 VDD.n1847 VDD.n1642 0.11665
R3119 VDD.n1645 VDD.n1644 0.11665
R3120 VDD.n141 VDD.n7 0.11665
R3121 VDD.n139 VDD.n8 0.11665
R3122 VDD.n133 VDD.n9 0.11665
R3123 VDD.n127 VDD.n10 0.11665
R3124 VDD.n121 VDD.n11 0.11665
R3125 VDD.n115 VDD.n12 0.11665
R3126 VDD.n109 VDD.n13 0.11665
R3127 VDD.n103 VDD.n14 0.11665
R3128 VDD.n97 VDD.n15 0.11665
R3129 VDD.n91 VDD.n16 0.11665
R3130 VDD.n85 VDD.n17 0.11665
R3131 VDD.n79 VDD.n18 0.11665
R3132 VDD.n73 VDD.n19 0.11665
R3133 VDD.n67 VDD.n20 0.11665
R3134 VDD.n61 VDD.n21 0.11665
R3135 VDD.n24 VDD.n23 0.11665
R3136 VDD.n1671 VDD.n1670 0.11665
R3137 VDD.n1685 VDD.n1684 0.11665
R3138 VDD.n1729 VDD.n1728 0.11665
R3139 VDD.n1751 VDD.n1750 0.11665
R3140 VDD.n1773 VDD.n1772 0.11665
R3141 VDD.n1795 VDD.n1794 0.11665
R3142 VDD.n1653 VDD.n1652 0.11665
R3143 VDD.n42 VDD.n40 0.116611
R3144 VDD.n32 VDD.n31 0.116611
R3145 VDD.n2056 VDD.n2055 0.116611
R3146 VDD.n2048 VDD.n2047 0.116611
R3147 VDD.n162 VDD.n161 0.116611
R3148 VDD.n156 VDD.n155 0.116611
R3149 VDD.n2032 VDD.n2031 0.116611
R3150 VDD.n186 VDD.n185 0.116611
R3151 VDD.n184 VDD.n183 0.116611
R3152 VDD.n178 VDD.n177 0.116611
R3153 VDD.n339 VDD.n338 0.116611
R3154 VDD.n330 VDD.n329 0.116611
R3155 VDD.n300 VDD.n299 0.116611
R3156 VDD.n298 VDD.n297 0.116611
R3157 VDD.n290 VDD.n289 0.116611
R3158 VDD.n284 VDD.n283 0.116611
R3159 VDD.n278 VDD.n277 0.116611
R3160 VDD.n272 VDD.n271 0.116611
R3161 VDD.n266 VDD.n265 0.116611
R3162 VDD.n260 VDD.n259 0.116611
R3163 VDD.n254 VDD.n253 0.116611
R3164 VDD.n248 VDD.n247 0.116611
R3165 VDD.n242 VDD.n241 0.116611
R3166 VDD.n236 VDD.n235 0.116611
R3167 VDD.n231 VDD.n230 0.116611
R3168 VDD.n225 VDD.n224 0.116611
R3169 VDD.n219 VDD.n218 0.116611
R3170 VDD.n212 VDD.n211 0.116611
R3171 VDD.n2012 VDD.n2011 0.116611
R3172 VDD.n2004 VDD.n2003 0.116611
R3173 VDD.n466 VDD.n465 0.116611
R3174 VDD.n460 VDD.n459 0.116611
R3175 VDD.n450 VDD.n449 0.116611
R3176 VDD.n440 VDD.n439 0.116611
R3177 VDD.n430 VDD.n429 0.116611
R3178 VDD.n420 VDD.n419 0.116611
R3179 VDD.n410 VDD.n409 0.116611
R3180 VDD.n400 VDD.n399 0.116611
R3181 VDD.n390 VDD.n389 0.116611
R3182 VDD.n380 VDD.n379 0.116611
R3183 VDD.n370 VDD.n369 0.116611
R3184 VDD.n360 VDD.n359 0.116611
R3185 VDD.n350 VDD.n349 0.116611
R3186 VDD.n323 VDD.n322 0.116611
R3187 VDD.n1988 VDD.n1987 0.116611
R3188 VDD.n487 VDD.n486 0.116611
R3189 VDD.n485 VDD.n484 0.116611
R3190 VDD.n479 VDD.n478 0.116611
R3191 VDD.n516 VDD.n515 0.116611
R3192 VDD.n514 VDD.n513 0.116611
R3193 VDD.n506 VDD.n505 0.116611
R3194 VDD.n500 VDD.n499 0.116611
R3195 VDD.n1968 VDD.n1967 0.116611
R3196 VDD.n1960 VDD.n1959 0.116611
R3197 VDD.n618 VDD.n617 0.116611
R3198 VDD.n612 VDD.n611 0.116611
R3199 VDD.n606 VDD.n605 0.116611
R3200 VDD.n600 VDD.n599 0.116611
R3201 VDD.n594 VDD.n593 0.116611
R3202 VDD.n588 VDD.n587 0.116611
R3203 VDD.n582 VDD.n581 0.116611
R3204 VDD.n576 VDD.n575 0.116611
R3205 VDD.n570 VDD.n569 0.116611
R3206 VDD.n564 VDD.n563 0.116611
R3207 VDD.n559 VDD.n558 0.116611
R3208 VDD.n553 VDD.n552 0.116611
R3209 VDD.n547 VDD.n546 0.116611
R3210 VDD.n540 VDD.n539 0.116611
R3211 VDD.n1944 VDD.n1943 0.116611
R3212 VDD.n788 VDD.n787 0.116611
R3213 VDD.n786 VDD.n785 0.116611
R3214 VDD.n780 VDD.n779 0.116611
R3215 VDD.n770 VDD.n769 0.116611
R3216 VDD.n760 VDD.n759 0.116611
R3217 VDD.n750 VDD.n749 0.116611
R3218 VDD.n740 VDD.n739 0.116611
R3219 VDD.n730 VDD.n729 0.116611
R3220 VDD.n720 VDD.n719 0.116611
R3221 VDD.n710 VDD.n709 0.116611
R3222 VDD.n700 VDD.n699 0.116611
R3223 VDD.n690 VDD.n689 0.116611
R3224 VDD.n680 VDD.n679 0.116611
R3225 VDD.n658 VDD.n657 0.116611
R3226 VDD.n651 VDD.n650 0.116611
R3227 VDD.n644 VDD.n643 0.116611
R3228 VDD.n817 VDD.n816 0.116611
R3229 VDD.n815 VDD.n814 0.116611
R3230 VDD.n807 VDD.n806 0.116611
R3231 VDD.n801 VDD.n800 0.116611
R3232 VDD.n1924 VDD.n1923 0.116611
R3233 VDD.n1916 VDD.n1915 0.116611
R3234 VDD.n834 VDD.n833 0.116611
R3235 VDD.n828 VDD.n827 0.116611
R3236 VDD.n1301 VDD.n1281 0.116611
R3237 VDD.n1458 VDD.n1126 0.116611
R3238 VDD.n1266 VDD.n1246 0.116611
R3239 VDD.n1900 VDD.n1899 0.116611
R3240 VDD.n940 VDD.n939 0.116611
R3241 VDD.n938 VDD.n937 0.116611
R3242 VDD.n932 VDD.n931 0.116611
R3243 VDD.n926 VDD.n925 0.116611
R3244 VDD.n920 VDD.n919 0.116611
R3245 VDD.n914 VDD.n913 0.116611
R3246 VDD.n908 VDD.n907 0.116611
R3247 VDD.n902 VDD.n901 0.116611
R3248 VDD.n896 VDD.n895 0.116611
R3249 VDD.n890 VDD.n889 0.116611
R3250 VDD.n884 VDD.n883 0.116611
R3251 VDD.n879 VDD.n878 0.116611
R3252 VDD.n873 VDD.n872 0.116611
R3253 VDD.n867 VDD.n866 0.116611
R3254 VDD.n860 VDD.n859 0.116611
R3255 VDD.n1617 VDD.n1616 0.116611
R3256 VDD.n1615 VDD.n1614 0.116611
R3257 VDD.n1607 VDD.n1606 0.116611
R3258 VDD.n1601 VDD.n1600 0.116611
R3259 VDD.n1591 VDD.n1590 0.116611
R3260 VDD.n1581 VDD.n1580 0.116611
R3261 VDD.n1571 VDD.n1570 0.116611
R3262 VDD.n1561 VDD.n1560 0.116611
R3263 VDD.n1551 VDD.n1550 0.116611
R3264 VDD.n1541 VDD.n1540 0.116611
R3265 VDD.n1531 VDD.n1530 0.116611
R3266 VDD.n1521 VDD.n1520 0.116611
R3267 VDD.n1511 VDD.n1510 0.116611
R3268 VDD.n990 VDD.n989 0.116611
R3269 VDD.n980 VDD.n979 0.116611
R3270 VDD.n973 VDD.n972 0.116611
R3271 VDD.n966 VDD.n965 0.116611
R3272 VDD.n1880 VDD.n1879 0.116611
R3273 VDD.n1872 VDD.n1871 0.116611
R3274 VDD.n1634 VDD.n1633 0.116611
R3275 VDD.n1628 VDD.n1627 0.116611
R3276 VDD.n1858 VDD.n1857 0.116611
R3277 VDD.n1850 VDD.n1849 0.116611
R3278 VDD.n1848 VDD.n1847 0.116611
R3279 VDD.n1646 VDD.n1645 0.116611
R3280 VDD.n142 VDD.n141 0.116611
R3281 VDD.n140 VDD.n139 0.116611
R3282 VDD.n134 VDD.n133 0.116611
R3283 VDD.n128 VDD.n127 0.116611
R3284 VDD.n122 VDD.n121 0.116611
R3285 VDD.n116 VDD.n115 0.116611
R3286 VDD.n110 VDD.n109 0.116611
R3287 VDD.n104 VDD.n103 0.116611
R3288 VDD.n98 VDD.n97 0.116611
R3289 VDD.n92 VDD.n91 0.116611
R3290 VDD.n86 VDD.n85 0.116611
R3291 VDD.n80 VDD.n79 0.116611
R3292 VDD.n74 VDD.n73 0.116611
R3293 VDD.n68 VDD.n67 0.116611
R3294 VDD.n62 VDD.n61 0.116611
R3295 VDD.n25 VDD.n24 0.116611
R3296 VDD.n1651 VDD.n1650 0.116611
R3297 VDD.n1797 VDD.n1796 0.116611
R3298 VDD.n1775 VDD.n1774 0.116611
R3299 VDD.n1753 VDD.n1752 0.116611
R3300 VDD.n1731 VDD.n1730 0.116611
R3301 VDD.n1709 VDD.n1708 0.116611
R3302 VDD.n1687 VDD.n1686 0.116611
R3303 VDD.n1670 VDD.n1669 0.116611
R3304 VDD VDD.n1135 0.109481
R3305 VDD VDD.n1137 0.109481
R3306 VDD.n1139 VDD 0.109481
R3307 VDD.n1178 VDD 0.109481
R3308 VDD.n1175 VDD 0.109481
R3309 VDD.n1172 VDD 0.109481
R3310 VDD VDD.n1150 0.109481
R3311 VDD VDD.n1152 0.109481
R3312 VDD VDD.n1154 0.109481
R3313 VDD VDD.n1008 0.109481
R3314 VDD VDD.n1010 0.109481
R3315 VDD VDD.n1012 0.109481
R3316 VDD.n1052 VDD 0.109481
R3317 VDD.n1049 VDD 0.109481
R3318 VDD.n1046 VDD 0.109481
R3319 VDD VDD.n1024 0.109481
R3320 VDD VDD.n1026 0.109481
R3321 VDD VDD.n1028 0.109481
R3322 VDD.n1293 VDD.n1284 0.107747
R3323 VDD.n1426 VDD.n1129 0.107747
R3324 VDD.n1258 VDD.n1249 0.107747
R3325 VDD VDD.n1003 0.104389
R3326 VDD VDD.n1345 0.104389
R3327 VDD.n1400 VDD.n1134 0.0992963
R3328 VDD.n1254 VDD.n1206 0.0992963
R3329 VDD.n1289 VDD.n1217 0.0992963
R3330 VDD VDD.n44 0.0942037
R3331 VDD.n40 VDD 0.0942037
R3332 VDD.n41 VDD 0.0942037
R3333 VDD.n32 VDD 0.0942037
R3334 VDD.n29 VDD 0.0942037
R3335 VDD.n2056 VDD 0.0942037
R3336 VDD VDD.n2052 0.0942037
R3337 VDD.n2053 VDD 0.0942037
R3338 VDD VDD.n2048 0.0942037
R3339 VDD VDD.n2044 0.0942037
R3340 VDD.n2045 VDD 0.0942037
R3341 VDD VDD.n162 0.0942037
R3342 VDD VDD.n158 0.0942037
R3343 VDD.n159 VDD 0.0942037
R3344 VDD VDD.n156 0.0942037
R3345 VDD.n153 VDD 0.0942037
R3346 VDD VDD.n2032 0.0942037
R3347 VDD VDD.n2028 0.0942037
R3348 VDD.n2029 VDD 0.0942037
R3349 VDD VDD.n186 0.0942037
R3350 VDD.n172 VDD 0.0942037
R3351 VDD VDD.n171 0.0942037
R3352 VDD.n184 VDD 0.0942037
R3353 VDD VDD.n180 0.0942037
R3354 VDD.n181 VDD 0.0942037
R3355 VDD VDD.n178 0.0942037
R3356 VDD.n175 VDD 0.0942037
R3357 VDD.n339 VDD 0.0942037
R3358 VDD.n336 VDD 0.0942037
R3359 VDD.n330 VDD 0.0942037
R3360 VDD.n327 VDD 0.0942037
R3361 VDD VDD.n300 0.0942037
R3362 VDD.n192 VDD 0.0942037
R3363 VDD VDD.n191 0.0942037
R3364 VDD.n298 VDD 0.0942037
R3365 VDD VDD.n294 0.0942037
R3366 VDD.n295 VDD 0.0942037
R3367 VDD VDD.n290 0.0942037
R3368 VDD VDD.n286 0.0942037
R3369 VDD.n287 VDD 0.0942037
R3370 VDD VDD.n284 0.0942037
R3371 VDD VDD.n280 0.0942037
R3372 VDD.n281 VDD 0.0942037
R3373 VDD VDD.n278 0.0942037
R3374 VDD VDD.n274 0.0942037
R3375 VDD.n275 VDD 0.0942037
R3376 VDD VDD.n272 0.0942037
R3377 VDD VDD.n268 0.0942037
R3378 VDD.n269 VDD 0.0942037
R3379 VDD VDD.n266 0.0942037
R3380 VDD VDD.n262 0.0942037
R3381 VDD.n263 VDD 0.0942037
R3382 VDD VDD.n260 0.0942037
R3383 VDD VDD.n256 0.0942037
R3384 VDD.n257 VDD 0.0942037
R3385 VDD VDD.n254 0.0942037
R3386 VDD VDD.n250 0.0942037
R3387 VDD.n251 VDD 0.0942037
R3388 VDD VDD.n248 0.0942037
R3389 VDD VDD.n244 0.0942037
R3390 VDD.n245 VDD 0.0942037
R3391 VDD VDD.n242 0.0942037
R3392 VDD VDD.n238 0.0942037
R3393 VDD.n239 VDD 0.0942037
R3394 VDD VDD.n236 0.0942037
R3395 VDD VDD.n205 0.0942037
R3396 VDD.n233 VDD 0.0942037
R3397 VDD VDD.n231 0.0942037
R3398 VDD VDD.n227 0.0942037
R3399 VDD.n228 VDD 0.0942037
R3400 VDD VDD.n225 0.0942037
R3401 VDD VDD.n221 0.0942037
R3402 VDD.n222 VDD 0.0942037
R3403 VDD VDD.n219 0.0942037
R3404 VDD VDD.n215 0.0942037
R3405 VDD.n216 VDD 0.0942037
R3406 VDD VDD.n212 0.0942037
R3407 VDD.n209 VDD 0.0942037
R3408 VDD.n2012 VDD 0.0942037
R3409 VDD VDD.n2008 0.0942037
R3410 VDD.n2009 VDD 0.0942037
R3411 VDD VDD.n2004 0.0942037
R3412 VDD VDD.n2000 0.0942037
R3413 VDD.n2001 VDD 0.0942037
R3414 VDD VDD.n466 0.0942037
R3415 VDD VDD.n462 0.0942037
R3416 VDD.n463 VDD 0.0942037
R3417 VDD VDD.n460 0.0942037
R3418 VDD VDD.n456 0.0942037
R3419 VDD.n457 VDD 0.0942037
R3420 VDD VDD.n450 0.0942037
R3421 VDD VDD.n446 0.0942037
R3422 VDD.n447 VDD 0.0942037
R3423 VDD VDD.n440 0.0942037
R3424 VDD VDD.n436 0.0942037
R3425 VDD.n437 VDD 0.0942037
R3426 VDD VDD.n430 0.0942037
R3427 VDD VDD.n426 0.0942037
R3428 VDD.n427 VDD 0.0942037
R3429 VDD VDD.n420 0.0942037
R3430 VDD VDD.n416 0.0942037
R3431 VDD.n417 VDD 0.0942037
R3432 VDD VDD.n410 0.0942037
R3433 VDD VDD.n406 0.0942037
R3434 VDD.n407 VDD 0.0942037
R3435 VDD VDD.n400 0.0942037
R3436 VDD VDD.n396 0.0942037
R3437 VDD.n397 VDD 0.0942037
R3438 VDD VDD.n390 0.0942037
R3439 VDD VDD.n386 0.0942037
R3440 VDD.n387 VDD 0.0942037
R3441 VDD VDD.n380 0.0942037
R3442 VDD VDD.n376 0.0942037
R3443 VDD.n377 VDD 0.0942037
R3444 VDD VDD.n370 0.0942037
R3445 VDD VDD.n366 0.0942037
R3446 VDD.n367 VDD 0.0942037
R3447 VDD VDD.n360 0.0942037
R3448 VDD VDD.n356 0.0942037
R3449 VDD.n357 VDD 0.0942037
R3450 VDD VDD.n350 0.0942037
R3451 VDD VDD.n346 0.0942037
R3452 VDD.n347 VDD 0.0942037
R3453 VDD VDD.n323 0.0942037
R3454 VDD.n320 VDD 0.0942037
R3455 VDD VDD.n1988 0.0942037
R3456 VDD VDD.n1984 0.0942037
R3457 VDD.n1985 VDD 0.0942037
R3458 VDD VDD.n487 0.0942037
R3459 VDD.n473 VDD 0.0942037
R3460 VDD VDD.n472 0.0942037
R3461 VDD.n485 VDD 0.0942037
R3462 VDD VDD.n481 0.0942037
R3463 VDD.n482 VDD 0.0942037
R3464 VDD VDD.n479 0.0942037
R3465 VDD.n476 VDD 0.0942037
R3466 VDD VDD.n516 0.0942037
R3467 VDD.n493 VDD 0.0942037
R3468 VDD VDD.n492 0.0942037
R3469 VDD.n514 VDD 0.0942037
R3470 VDD VDD.n510 0.0942037
R3471 VDD.n511 VDD 0.0942037
R3472 VDD VDD.n506 0.0942037
R3473 VDD VDD.n502 0.0942037
R3474 VDD.n503 VDD 0.0942037
R3475 VDD VDD.n500 0.0942037
R3476 VDD.n497 VDD 0.0942037
R3477 VDD.n1968 VDD 0.0942037
R3478 VDD VDD.n1964 0.0942037
R3479 VDD.n1965 VDD 0.0942037
R3480 VDD VDD.n1960 0.0942037
R3481 VDD VDD.n1956 0.0942037
R3482 VDD.n1957 VDD 0.0942037
R3483 VDD VDD.n618 0.0942037
R3484 VDD VDD.n614 0.0942037
R3485 VDD.n615 VDD 0.0942037
R3486 VDD VDD.n612 0.0942037
R3487 VDD VDD.n608 0.0942037
R3488 VDD.n609 VDD 0.0942037
R3489 VDD VDD.n606 0.0942037
R3490 VDD VDD.n602 0.0942037
R3491 VDD.n603 VDD 0.0942037
R3492 VDD VDD.n600 0.0942037
R3493 VDD VDD.n596 0.0942037
R3494 VDD.n597 VDD 0.0942037
R3495 VDD VDD.n594 0.0942037
R3496 VDD VDD.n590 0.0942037
R3497 VDD.n591 VDD 0.0942037
R3498 VDD VDD.n588 0.0942037
R3499 VDD VDD.n584 0.0942037
R3500 VDD.n585 VDD 0.0942037
R3501 VDD VDD.n582 0.0942037
R3502 VDD VDD.n578 0.0942037
R3503 VDD.n579 VDD 0.0942037
R3504 VDD VDD.n576 0.0942037
R3505 VDD VDD.n572 0.0942037
R3506 VDD.n573 VDD 0.0942037
R3507 VDD VDD.n570 0.0942037
R3508 VDD VDD.n566 0.0942037
R3509 VDD.n567 VDD 0.0942037
R3510 VDD VDD.n564 0.0942037
R3511 VDD VDD.n533 0.0942037
R3512 VDD.n561 VDD 0.0942037
R3513 VDD VDD.n559 0.0942037
R3514 VDD VDD.n555 0.0942037
R3515 VDD.n556 VDD 0.0942037
R3516 VDD VDD.n553 0.0942037
R3517 VDD VDD.n549 0.0942037
R3518 VDD.n550 VDD 0.0942037
R3519 VDD VDD.n547 0.0942037
R3520 VDD VDD.n543 0.0942037
R3521 VDD.n544 VDD 0.0942037
R3522 VDD VDD.n540 0.0942037
R3523 VDD.n537 VDD 0.0942037
R3524 VDD VDD.n1944 0.0942037
R3525 VDD VDD.n1940 0.0942037
R3526 VDD.n1941 VDD 0.0942037
R3527 VDD VDD.n788 0.0942037
R3528 VDD.n625 VDD 0.0942037
R3529 VDD VDD.n624 0.0942037
R3530 VDD.n786 VDD 0.0942037
R3531 VDD VDD.n782 0.0942037
R3532 VDD.n783 VDD 0.0942037
R3533 VDD VDD.n780 0.0942037
R3534 VDD VDD.n776 0.0942037
R3535 VDD.n777 VDD 0.0942037
R3536 VDD VDD.n770 0.0942037
R3537 VDD VDD.n766 0.0942037
R3538 VDD.n767 VDD 0.0942037
R3539 VDD VDD.n760 0.0942037
R3540 VDD VDD.n756 0.0942037
R3541 VDD.n757 VDD 0.0942037
R3542 VDD VDD.n750 0.0942037
R3543 VDD VDD.n746 0.0942037
R3544 VDD.n747 VDD 0.0942037
R3545 VDD VDD.n740 0.0942037
R3546 VDD VDD.n736 0.0942037
R3547 VDD.n737 VDD 0.0942037
R3548 VDD VDD.n730 0.0942037
R3549 VDD VDD.n726 0.0942037
R3550 VDD.n727 VDD 0.0942037
R3551 VDD VDD.n720 0.0942037
R3552 VDD VDD.n716 0.0942037
R3553 VDD.n717 VDD 0.0942037
R3554 VDD VDD.n710 0.0942037
R3555 VDD VDD.n706 0.0942037
R3556 VDD.n707 VDD 0.0942037
R3557 VDD VDD.n700 0.0942037
R3558 VDD VDD.n696 0.0942037
R3559 VDD.n697 VDD 0.0942037
R3560 VDD VDD.n690 0.0942037
R3561 VDD VDD.n686 0.0942037
R3562 VDD.n687 VDD 0.0942037
R3563 VDD VDD.n680 0.0942037
R3564 VDD VDD.n676 0.0942037
R3565 VDD.n677 VDD 0.0942037
R3566 VDD VDD.n658 0.0942037
R3567 VDD VDD.n654 0.0942037
R3568 VDD.n655 VDD 0.0942037
R3569 VDD VDD.n651 0.0942037
R3570 VDD VDD.n647 0.0942037
R3571 VDD.n648 VDD 0.0942037
R3572 VDD VDD.n644 0.0942037
R3573 VDD.n641 VDD 0.0942037
R3574 VDD VDD.n817 0.0942037
R3575 VDD.n794 VDD 0.0942037
R3576 VDD VDD.n793 0.0942037
R3577 VDD.n815 VDD 0.0942037
R3578 VDD VDD.n811 0.0942037
R3579 VDD.n812 VDD 0.0942037
R3580 VDD VDD.n807 0.0942037
R3581 VDD VDD.n803 0.0942037
R3582 VDD.n804 VDD 0.0942037
R3583 VDD VDD.n801 0.0942037
R3584 VDD.n798 VDD 0.0942037
R3585 VDD.n1924 VDD 0.0942037
R3586 VDD VDD.n1920 0.0942037
R3587 VDD.n1921 VDD 0.0942037
R3588 VDD VDD.n1916 0.0942037
R3589 VDD VDD.n1912 0.0942037
R3590 VDD.n1913 VDD 0.0942037
R3591 VDD VDD.n834 0.0942037
R3592 VDD VDD.n830 0.0942037
R3593 VDD.n831 VDD 0.0942037
R3594 VDD VDD.n828 0.0942037
R3595 VDD.n825 VDD 0.0942037
R3596 VDD VDD.n1900 0.0942037
R3597 VDD VDD.n1896 0.0942037
R3598 VDD.n1897 VDD 0.0942037
R3599 VDD VDD.n940 0.0942037
R3600 VDD.n841 VDD 0.0942037
R3601 VDD VDD.n840 0.0942037
R3602 VDD.n938 VDD 0.0942037
R3603 VDD VDD.n934 0.0942037
R3604 VDD.n935 VDD 0.0942037
R3605 VDD VDD.n932 0.0942037
R3606 VDD VDD.n928 0.0942037
R3607 VDD.n929 VDD 0.0942037
R3608 VDD VDD.n926 0.0942037
R3609 VDD VDD.n922 0.0942037
R3610 VDD.n923 VDD 0.0942037
R3611 VDD VDD.n920 0.0942037
R3612 VDD VDD.n916 0.0942037
R3613 VDD.n917 VDD 0.0942037
R3614 VDD VDD.n914 0.0942037
R3615 VDD VDD.n910 0.0942037
R3616 VDD.n911 VDD 0.0942037
R3617 VDD VDD.n908 0.0942037
R3618 VDD VDD.n904 0.0942037
R3619 VDD.n905 VDD 0.0942037
R3620 VDD VDD.n902 0.0942037
R3621 VDD VDD.n898 0.0942037
R3622 VDD.n899 VDD 0.0942037
R3623 VDD VDD.n896 0.0942037
R3624 VDD VDD.n892 0.0942037
R3625 VDD.n893 VDD 0.0942037
R3626 VDD VDD.n890 0.0942037
R3627 VDD VDD.n886 0.0942037
R3628 VDD.n887 VDD 0.0942037
R3629 VDD VDD.n884 0.0942037
R3630 VDD VDD.n853 0.0942037
R3631 VDD.n881 VDD 0.0942037
R3632 VDD VDD.n879 0.0942037
R3633 VDD VDD.n875 0.0942037
R3634 VDD.n876 VDD 0.0942037
R3635 VDD VDD.n873 0.0942037
R3636 VDD VDD.n869 0.0942037
R3637 VDD.n870 VDD 0.0942037
R3638 VDD VDD.n867 0.0942037
R3639 VDD VDD.n863 0.0942037
R3640 VDD.n864 VDD 0.0942037
R3641 VDD VDD.n860 0.0942037
R3642 VDD.n857 VDD 0.0942037
R3643 VDD VDD.n1617 0.0942037
R3644 VDD.n946 VDD 0.0942037
R3645 VDD VDD.n945 0.0942037
R3646 VDD.n1615 VDD 0.0942037
R3647 VDD VDD.n1611 0.0942037
R3648 VDD.n1612 VDD 0.0942037
R3649 VDD VDD.n1607 0.0942037
R3650 VDD VDD.n1603 0.0942037
R3651 VDD.n1604 VDD 0.0942037
R3652 VDD VDD.n1601 0.0942037
R3653 VDD VDD.n1597 0.0942037
R3654 VDD.n1598 VDD 0.0942037
R3655 VDD VDD.n1591 0.0942037
R3656 VDD VDD.n1587 0.0942037
R3657 VDD.n1588 VDD 0.0942037
R3658 VDD VDD.n1581 0.0942037
R3659 VDD VDD.n1577 0.0942037
R3660 VDD.n1578 VDD 0.0942037
R3661 VDD VDD.n1571 0.0942037
R3662 VDD VDD.n1567 0.0942037
R3663 VDD.n1568 VDD 0.0942037
R3664 VDD VDD.n1561 0.0942037
R3665 VDD VDD.n1557 0.0942037
R3666 VDD.n1558 VDD 0.0942037
R3667 VDD VDD.n1551 0.0942037
R3668 VDD VDD.n1547 0.0942037
R3669 VDD.n1548 VDD 0.0942037
R3670 VDD VDD.n1541 0.0942037
R3671 VDD VDD.n1537 0.0942037
R3672 VDD.n1538 VDD 0.0942037
R3673 VDD VDD.n1531 0.0942037
R3674 VDD VDD.n1527 0.0942037
R3675 VDD.n1528 VDD 0.0942037
R3676 VDD VDD.n1521 0.0942037
R3677 VDD VDD.n1517 0.0942037
R3678 VDD.n1518 VDD 0.0942037
R3679 VDD VDD.n1511 0.0942037
R3680 VDD VDD.n1507 0.0942037
R3681 VDD.n1508 VDD 0.0942037
R3682 VDD VDD.n990 0.0942037
R3683 VDD VDD.n986 0.0942037
R3684 VDD.n987 VDD 0.0942037
R3685 VDD VDD.n980 0.0942037
R3686 VDD VDD.n976 0.0942037
R3687 VDD.n977 VDD 0.0942037
R3688 VDD VDD.n973 0.0942037
R3689 VDD VDD.n969 0.0942037
R3690 VDD.n970 VDD 0.0942037
R3691 VDD VDD.n966 0.0942037
R3692 VDD.n963 VDD 0.0942037
R3693 VDD.n1880 VDD 0.0942037
R3694 VDD VDD.n1876 0.0942037
R3695 VDD.n1877 VDD 0.0942037
R3696 VDD VDD.n1872 0.0942037
R3697 VDD VDD.n1868 0.0942037
R3698 VDD.n1869 VDD 0.0942037
R3699 VDD VDD.n1634 0.0942037
R3700 VDD VDD.n1630 0.0942037
R3701 VDD.n1631 VDD 0.0942037
R3702 VDD VDD.n1628 0.0942037
R3703 VDD.n1625 VDD 0.0942037
R3704 VDD VDD.n1858 0.0942037
R3705 VDD VDD.n1854 0.0942037
R3706 VDD.n1855 VDD 0.0942037
R3707 VDD VDD.n1850 0.0942037
R3708 VDD.n1640 VDD 0.0942037
R3709 VDD VDD.n1639 0.0942037
R3710 VDD.n1848 VDD 0.0942037
R3711 VDD VDD.n1844 0.0942037
R3712 VDD.n1845 VDD 0.0942037
R3713 VDD VDD.n1646 0.0942037
R3714 VDD.n1643 VDD 0.0942037
R3715 VDD VDD.n142 0.0942037
R3716 VDD.n6 VDD 0.0942037
R3717 VDD VDD.n5 0.0942037
R3718 VDD.n140 VDD 0.0942037
R3719 VDD VDD.n136 0.0942037
R3720 VDD.n137 VDD 0.0942037
R3721 VDD VDD.n134 0.0942037
R3722 VDD VDD.n130 0.0942037
R3723 VDD.n131 VDD 0.0942037
R3724 VDD VDD.n128 0.0942037
R3725 VDD VDD.n124 0.0942037
R3726 VDD.n125 VDD 0.0942037
R3727 VDD VDD.n122 0.0942037
R3728 VDD VDD.n118 0.0942037
R3729 VDD.n119 VDD 0.0942037
R3730 VDD VDD.n116 0.0942037
R3731 VDD VDD.n112 0.0942037
R3732 VDD.n113 VDD 0.0942037
R3733 VDD VDD.n110 0.0942037
R3734 VDD VDD.n106 0.0942037
R3735 VDD.n107 VDD 0.0942037
R3736 VDD VDD.n104 0.0942037
R3737 VDD VDD.n100 0.0942037
R3738 VDD.n101 VDD 0.0942037
R3739 VDD VDD.n98 0.0942037
R3740 VDD VDD.n94 0.0942037
R3741 VDD.n95 VDD 0.0942037
R3742 VDD VDD.n92 0.0942037
R3743 VDD VDD.n88 0.0942037
R3744 VDD.n89 VDD 0.0942037
R3745 VDD VDD.n86 0.0942037
R3746 VDD VDD.n82 0.0942037
R3747 VDD.n83 VDD 0.0942037
R3748 VDD VDD.n80 0.0942037
R3749 VDD VDD.n76 0.0942037
R3750 VDD.n77 VDD 0.0942037
R3751 VDD VDD.n74 0.0942037
R3752 VDD VDD.n70 0.0942037
R3753 VDD.n71 VDD 0.0942037
R3754 VDD VDD.n68 0.0942037
R3755 VDD VDD.n64 0.0942037
R3756 VDD.n65 VDD 0.0942037
R3757 VDD VDD.n62 0.0942037
R3758 VDD VDD.n58 0.0942037
R3759 VDD.n59 VDD 0.0942037
R3760 VDD VDD.n25 0.0942037
R3761 VDD.n22 VDD 0.0942037
R3762 VDD.n2073 VDD 0.0942037
R3763 VDD VDD.n2072 0.0942037
R3764 VDD.n1650 VDD 0.0942037
R3765 VDD VDD.n1653 0.0942037
R3766 VDD.n1654 VDD 0.0942037
R3767 VDD VDD.n1662 0.0942037
R3768 VDD.n1663 VDD 0.0942037
R3769 VDD VDD.n1797 0.0942037
R3770 VDD.n1794 VDD 0.0942037
R3771 VDD VDD.n1793 0.0942037
R3772 VDD.n1783 VDD 0.0942037
R3773 VDD VDD.n1782 0.0942037
R3774 VDD VDD.n1775 0.0942037
R3775 VDD.n1772 VDD 0.0942037
R3776 VDD VDD.n1771 0.0942037
R3777 VDD.n1761 VDD 0.0942037
R3778 VDD VDD.n1760 0.0942037
R3779 VDD VDD.n1753 0.0942037
R3780 VDD.n1750 VDD 0.0942037
R3781 VDD VDD.n1749 0.0942037
R3782 VDD.n1739 VDD 0.0942037
R3783 VDD VDD.n1738 0.0942037
R3784 VDD VDD.n1731 0.0942037
R3785 VDD.n1728 VDD 0.0942037
R3786 VDD VDD.n1727 0.0942037
R3787 VDD.n1717 VDD 0.0942037
R3788 VDD VDD.n1716 0.0942037
R3789 VDD VDD.n1709 0.0942037
R3790 VDD.n1706 VDD 0.0942037
R3791 VDD VDD.n1705 0.0942037
R3792 VDD.n1695 VDD 0.0942037
R3793 VDD VDD.n1694 0.0942037
R3794 VDD VDD.n1687 0.0942037
R3795 VDD.n1684 VDD 0.0942037
R3796 VDD VDD.n1683 0.0942037
R3797 VDD.n1673 VDD 0.0942037
R3798 VDD VDD.n1672 0.0942037
R3799 VDD.n1669 VDD 0.0942037
R3800 VDD.n1665 VDD 0.0942037
R3801 VDD.n1313 VDD.n1281 0.080963
R3802 VDD.n1459 VDD.n1458 0.080963
R3803 VDD.n1371 VDD.n1246 0.080963
R3804 VDD.n673 VDD 0.0717963
R3805 VDD VDD.n1475 0.0687407
R3806 VDD VDD.n1060 0.0687407
R3807 VDD.n1355 VDD 0.0687407
R3808 VDD.n1363 VDD 0.0687407
R3809 VDD.n1337 VDD 0.0687407
R3810 VDD.n1305 VDD 0.0687407
R3811 VDD.n1294 VDD.n1293 0.0677222
R3812 VDD.n1427 VDD.n1426 0.0677222
R3813 VDD.n1259 VDD.n1258 0.0677222
R3814 VDD.n1132 VDD 0.0636481
R3815 VDD.n1252 VDD 0.0636481
R3816 VDD.n1287 VDD 0.0636481
R3817 VDD.n1485 VDD.n1003 0.0605926
R3818 VDD.n1345 VDD.n1344 0.0605926
R3819 VDD.n51 VDD.n50 0.058858
R3820 VDD.n48 VDD.n38 0.058858
R3821 VDD.n47 VDD.n46 0.058858
R3822 VDD.n44 VDD.n37 0.058858
R3823 VDD.n54 VDD.n53 0.058858
R3824 VDD.n47 VDD 0.058858
R3825 VDD VDD.n38 0.058858
R3826 VDD.n51 VDD 0.058858
R3827 VDD.n35 VDD.n34 0.058858
R3828 VDD.n2059 VDD.n2058 0.058858
R3829 VDD.n2054 VDD.n2053 0.058858
R3830 VDD.n2050 VDD.n2049 0.058858
R3831 VDD.n2046 VDD.n2045 0.058858
R3832 VDD.n164 VDD.n163 0.058858
R3833 VDD.n160 VDD.n159 0.058858
R3834 VDD.n1804 VDD.n157 0.058858
R3835 VDD.n2034 VDD.n2033 0.058858
R3836 VDD.n2030 VDD.n2029 0.058858
R3837 VDD.n188 VDD.n187 0.058858
R3838 VDD.n171 VDD.n169 0.058858
R3839 VDD.n2039 VDD.n2038 0.058858
R3840 VDD.n182 VDD.n181 0.058858
R3841 VDD.n1807 VDD.n179 0.058858
R3842 VDD.n342 VDD.n341 0.058858
R3843 VDD.n333 VDD.n332 0.058858
R3844 VDD.n302 VDD.n301 0.058858
R3845 VDD.n191 VDD.n190 0.058858
R3846 VDD.n2023 VDD.n2022 0.058858
R3847 VDD.n296 VDD.n295 0.058858
R3848 VDD.n292 VDD.n291 0.058858
R3849 VDD.n288 VDD.n287 0.058858
R3850 VDD.n1810 VDD.n285 0.058858
R3851 VDD.n282 VDD.n281 0.058858
R3852 VDD.n453 VDD.n279 0.058858
R3853 VDD.n276 VDD.n275 0.058858
R3854 VDD.n443 VDD.n273 0.058858
R3855 VDD.n270 VDD.n269 0.058858
R3856 VDD.n433 VDD.n267 0.058858
R3857 VDD.n264 VDD.n263 0.058858
R3858 VDD.n423 VDD.n261 0.058858
R3859 VDD.n258 VDD.n257 0.058858
R3860 VDD.n413 VDD.n255 0.058858
R3861 VDD.n252 VDD.n251 0.058858
R3862 VDD.n403 VDD.n249 0.058858
R3863 VDD.n246 VDD.n245 0.058858
R3864 VDD.n393 VDD.n243 0.058858
R3865 VDD.n240 VDD.n239 0.058858
R3866 VDD.n383 VDD.n237 0.058858
R3867 VDD.n235 VDD.n204 0.058858
R3868 VDD.n234 VDD.n233 0.058858
R3869 VDD.n373 VDD.n232 0.058858
R3870 VDD.n229 VDD.n228 0.058858
R3871 VDD.n363 VDD.n226 0.058858
R3872 VDD.n223 VDD.n222 0.058858
R3873 VDD.n353 VDD.n220 0.058858
R3874 VDD.n217 VDD.n216 0.058858
R3875 VDD.n214 VDD.n213 0.058858
R3876 VDD.n2015 VDD.n2014 0.058858
R3877 VDD.n2010 VDD.n2009 0.058858
R3878 VDD.n2006 VDD.n2005 0.058858
R3879 VDD.n2002 VDD.n2001 0.058858
R3880 VDD.n468 VDD.n467 0.058858
R3881 VDD.n464 VDD.n463 0.058858
R3882 VDD.n1813 VDD.n461 0.058858
R3883 VDD.n458 VDD.n457 0.058858
R3884 VDD.n452 VDD.n451 0.058858
R3885 VDD.n448 VDD.n447 0.058858
R3886 VDD.n442 VDD.n441 0.058858
R3887 VDD.n438 VDD.n437 0.058858
R3888 VDD.n432 VDD.n431 0.058858
R3889 VDD.n428 VDD.n427 0.058858
R3890 VDD.n422 VDD.n421 0.058858
R3891 VDD.n418 VDD.n417 0.058858
R3892 VDD.n412 VDD.n411 0.058858
R3893 VDD.n408 VDD.n407 0.058858
R3894 VDD.n402 VDD.n401 0.058858
R3895 VDD.n398 VDD.n397 0.058858
R3896 VDD.n392 VDD.n391 0.058858
R3897 VDD.n388 VDD.n387 0.058858
R3898 VDD.n382 VDD.n381 0.058858
R3899 VDD.n378 VDD.n377 0.058858
R3900 VDD.n372 VDD.n371 0.058858
R3901 VDD.n368 VDD.n367 0.058858
R3902 VDD.n362 VDD.n361 0.058858
R3903 VDD.n358 VDD.n357 0.058858
R3904 VDD.n352 VDD.n351 0.058858
R3905 VDD.n348 VDD.n347 0.058858
R3906 VDD.n325 VDD.n324 0.058858
R3907 VDD.n1990 VDD.n1989 0.058858
R3908 VDD.n1986 VDD.n1985 0.058858
R3909 VDD.n489 VDD.n488 0.058858
R3910 VDD.n472 VDD.n470 0.058858
R3911 VDD.n1995 VDD.n1994 0.058858
R3912 VDD.n483 VDD.n482 0.058858
R3913 VDD.n1816 VDD.n480 0.058858
R3914 VDD.n518 VDD.n517 0.058858
R3915 VDD.n492 VDD.n491 0.058858
R3916 VDD.n1979 VDD.n1978 0.058858
R3917 VDD.n512 VDD.n511 0.058858
R3918 VDD.n508 VDD.n507 0.058858
R3919 VDD.n504 VDD.n503 0.058858
R3920 VDD.n1819 VDD.n501 0.058858
R3921 VDD.n669 VDD.n668 0.058858
R3922 VDD.n672 VDD.n671 0.058858
R3923 VDD.n666 VDD.n665 0.058858
R3924 VDD.n666 VDD 0.058858
R3925 VDD.n671 VDD 0.058858
R3926 VDD.n669 VDD 0.058858
R3927 VDD.n1971 VDD.n1970 0.058858
R3928 VDD.n1966 VDD.n1965 0.058858
R3929 VDD.n1962 VDD.n1961 0.058858
R3930 VDD.n1958 VDD.n1957 0.058858
R3931 VDD.n620 VDD.n619 0.058858
R3932 VDD.n616 VDD.n615 0.058858
R3933 VDD.n1822 VDD.n613 0.058858
R3934 VDD.n610 VDD.n609 0.058858
R3935 VDD.n773 VDD.n607 0.058858
R3936 VDD.n604 VDD.n603 0.058858
R3937 VDD.n763 VDD.n601 0.058858
R3938 VDD.n598 VDD.n597 0.058858
R3939 VDD.n753 VDD.n595 0.058858
R3940 VDD.n592 VDD.n591 0.058858
R3941 VDD.n743 VDD.n589 0.058858
R3942 VDD.n586 VDD.n585 0.058858
R3943 VDD.n733 VDD.n583 0.058858
R3944 VDD.n580 VDD.n579 0.058858
R3945 VDD.n723 VDD.n577 0.058858
R3946 VDD.n574 VDD.n573 0.058858
R3947 VDD.n713 VDD.n571 0.058858
R3948 VDD.n568 VDD.n567 0.058858
R3949 VDD.n703 VDD.n565 0.058858
R3950 VDD.n563 VDD.n532 0.058858
R3951 VDD.n562 VDD.n561 0.058858
R3952 VDD.n693 VDD.n560 0.058858
R3953 VDD.n557 VDD.n556 0.058858
R3954 VDD.n683 VDD.n554 0.058858
R3955 VDD.n551 VDD.n550 0.058858
R3956 VDD.n661 VDD.n548 0.058858
R3957 VDD.n545 VDD.n544 0.058858
R3958 VDD.n542 VDD.n541 0.058858
R3959 VDD.n1946 VDD.n1945 0.058858
R3960 VDD.n1942 VDD.n1941 0.058858
R3961 VDD.n790 VDD.n789 0.058858
R3962 VDD.n624 VDD.n622 0.058858
R3963 VDD.n1951 VDD.n1950 0.058858
R3964 VDD.n784 VDD.n783 0.058858
R3965 VDD.n1825 VDD.n781 0.058858
R3966 VDD.n778 VDD.n777 0.058858
R3967 VDD.n772 VDD.n771 0.058858
R3968 VDD.n768 VDD.n767 0.058858
R3969 VDD.n762 VDD.n761 0.058858
R3970 VDD.n758 VDD.n757 0.058858
R3971 VDD.n752 VDD.n751 0.058858
R3972 VDD.n748 VDD.n747 0.058858
R3973 VDD.n742 VDD.n741 0.058858
R3974 VDD.n738 VDD.n737 0.058858
R3975 VDD.n732 VDD.n731 0.058858
R3976 VDD.n728 VDD.n727 0.058858
R3977 VDD.n722 VDD.n721 0.058858
R3978 VDD.n718 VDD.n717 0.058858
R3979 VDD.n712 VDD.n711 0.058858
R3980 VDD.n708 VDD.n707 0.058858
R3981 VDD.n702 VDD.n701 0.058858
R3982 VDD.n698 VDD.n697 0.058858
R3983 VDD.n692 VDD.n691 0.058858
R3984 VDD.n688 VDD.n687 0.058858
R3985 VDD.n682 VDD.n681 0.058858
R3986 VDD.n678 VDD.n677 0.058858
R3987 VDD.n660 VDD.n659 0.058858
R3988 VDD.n656 VDD.n655 0.058858
R3989 VDD.n653 VDD.n652 0.058858
R3990 VDD.n649 VDD.n648 0.058858
R3991 VDD.n646 VDD.n645 0.058858
R3992 VDD.n819 VDD.n818 0.058858
R3993 VDD.n793 VDD.n792 0.058858
R3994 VDD.n1935 VDD.n1934 0.058858
R3995 VDD.n813 VDD.n812 0.058858
R3996 VDD.n809 VDD.n808 0.058858
R3997 VDD.n805 VDD.n804 0.058858
R3998 VDD.n1828 VDD.n802 0.058858
R3999 VDD.n1927 VDD.n1926 0.058858
R4000 VDD.n1922 VDD.n1921 0.058858
R4001 VDD.n1918 VDD.n1917 0.058858
R4002 VDD.n1914 VDD.n1913 0.058858
R4003 VDD.n836 VDD.n835 0.058858
R4004 VDD.n832 VDD.n831 0.058858
R4005 VDD.n1831 VDD.n829 0.058858
R4006 VDD.n1326 VDD.n1323 0.058858
R4007 VDD.n1322 VDD.n1275 0.058858
R4008 VDD.n1332 VDD.n1331 0.058858
R4009 VDD.n1319 VDD.n1280 0.058858
R4010 VDD.n1302 VDD.n1301 0.058858
R4011 VDD.n1453 VDD.n1450 0.058858
R4012 VDD.n1449 VDD.n1446 0.058858
R4013 VDD.n1444 VDD.n1441 0.058858
R4014 VDD.n1440 VDD.n1437 0.058858
R4015 VDD.n1432 VDD.n1126 0.058858
R4016 VDD.n1492 VDD.n1491 0.058858
R4017 VDD.n1489 VDD.n1488 0.058858
R4018 VDD.n1496 VDD.n1495 0.058858
R4019 VDD.n1000 VDD.n999 0.058858
R4020 VDD.n1500 VDD.n1499 0.058858
R4021 VDD.n997 VDD.n996 0.058858
R4022 VDD.n1488 VDD 0.058858
R4023 VDD.n1492 VDD 0.058858
R4024 VDD VDD.n999 0.058858
R4025 VDD.n1496 VDD 0.058858
R4026 VDD.n996 VDD 0.058858
R4027 VDD.n1500 VDD 0.058858
R4028 VDD.n1384 VDD.n1381 0.058858
R4029 VDD.n1380 VDD.n1240 0.058858
R4030 VDD.n1390 VDD.n1389 0.058858
R4031 VDD.n1377 VDD.n1245 0.058858
R4032 VDD.n1267 VDD.n1266 0.058858
R4033 VDD.n1469 VDD.n1468 0.058858
R4034 VDD.n1466 VDD.n1065 0.058858
R4035 VDD.n1068 VDD.n1067 0.058858
R4036 VDD.n1464 VDD.n1463 0.058858
R4037 VDD.n1118 VDD.n1117 0.058858
R4038 VDD.n1075 VDD.n1074 0.058858
R4039 VDD.n1115 VDD.n1114 0.058858
R4040 VDD.n1112 VDD.n1111 0.058858
R4041 VDD.n1109 VDD.n1079 0.058858
R4042 VDD.n1106 VDD.n1081 0.058858
R4043 VDD.n1103 VDD.n1102 0.058858
R4044 VDD.n1100 VDD.n1083 0.058858
R4045 VDD.n1097 VDD.n1085 0.058858
R4046 VDD.n1096 VDD.n1095 0.058858
R4047 VDD.n1093 VDD.n1092 0.058858
R4048 VDD.n1090 VDD.n1089 0.058858
R4049 VDD VDD.n1093 0.058858
R4050 VDD VDD.n1096 0.058858
R4051 VDD VDD.n1085 0.058858
R4052 VDD VDD.n1083 0.058858
R4053 VDD.n1102 VDD 0.058858
R4054 VDD.n1105 VDD.n1104 0.058858
R4055 VDD VDD.n1081 0.058858
R4056 VDD VDD.n1079 0.058858
R4057 VDD.n1112 VDD 0.058858
R4058 VDD.n1115 VDD 0.058858
R4059 VDD VDD.n1075 0.058858
R4060 VDD.n1073 VDD.n1072 0.058858
R4061 VDD VDD.n1118 0.058858
R4062 VDD.n1464 VDD 0.058858
R4063 VDD VDD.n1068 0.058858
R4064 VDD VDD.n1065 0.058858
R4065 VDD.n1469 VDD 0.058858
R4066 VDD.n1420 VDD.n1419 0.058858
R4067 VDD.n1418 VDD.n1417 0.058858
R4068 VDD.n1189 VDD.n1188 0.058858
R4069 VDD.n1185 VDD.n1184 0.058858
R4070 VDD.n1182 VDD.n1181 0.058858
R4071 VDD.n1179 VDD.n1140 0.058858
R4072 VDD.n1142 VDD.n1141 0.058858
R4073 VDD.n1176 VDD.n1144 0.058858
R4074 VDD.n1173 VDD.n1146 0.058858
R4075 VDD.n1170 VDD.n1148 0.058858
R4076 VDD.n1169 VDD.n1168 0.058858
R4077 VDD.n1167 VDD.n1166 0.058858
R4078 VDD.n1164 VDD.n1163 0.058858
R4079 VDD.n1161 VDD.n1160 0.058858
R4080 VDD.n1158 VDD.n1157 0.058858
R4081 VDD.n1158 VDD 0.058858
R4082 VDD.n1161 VDD 0.058858
R4083 VDD.n1164 VDD 0.058858
R4084 VDD.n1166 VDD 0.058858
R4085 VDD VDD.n1148 0.058858
R4086 VDD VDD.n1146 0.058858
R4087 VDD VDD.n1144 0.058858
R4088 VDD VDD.n1142 0.058858
R4089 VDD.n1182 VDD 0.058858
R4090 VDD.n1185 VDD 0.058858
R4091 VDD.n1189 VDD 0.058858
R4092 VDD.n1417 VDD 0.058858
R4093 VDD.n1410 VDD.n1409 0.058858
R4094 VDD.n1407 VDD.n1190 0.058858
R4095 VDD.n1193 VDD.n1192 0.058858
R4096 VDD.n1405 VDD.n1404 0.058858
R4097 VDD.n1401 VDD.n1195 0.058858
R4098 VDD.n1200 VDD.n1199 0.058858
R4099 VDD.n1398 VDD.n1397 0.058858
R4100 VDD.n1237 VDD.n1236 0.058858
R4101 VDD.n1234 VDD.n1204 0.058858
R4102 VDD.n1233 VDD.n1232 0.058858
R4103 VDD.n1228 VDD.n1227 0.058858
R4104 VDD.n1225 VDD.n1208 0.058858
R4105 VDD.n1222 VDD.n1210 0.058858
R4106 VDD.n1221 VDD.n1220 0.058858
R4107 VDD.n1218 VDD.n1212 0.058858
R4108 VDD.n1215 VDD.n1214 0.058858
R4109 VDD VDD.n1212 0.058858
R4110 VDD VDD.n1221 0.058858
R4111 VDD VDD.n1210 0.058858
R4112 VDD VDD.n1208 0.058858
R4113 VDD.n1227 VDD 0.058858
R4114 VDD.n1230 VDD.n1229 0.058858
R4115 VDD.n1233 VDD 0.058858
R4116 VDD VDD.n1204 0.058858
R4117 VDD.n1237 VDD 0.058858
R4118 VDD.n1398 VDD 0.058858
R4119 VDD VDD.n1200 0.058858
R4120 VDD.n1198 VDD.n1197 0.058858
R4121 VDD VDD.n1195 0.058858
R4122 VDD.n1405 VDD 0.058858
R4123 VDD VDD.n1193 0.058858
R4124 VDD VDD.n1190 0.058858
R4125 VDD.n1410 VDD 0.058858
R4126 VDD.n1480 VDD.n1479 0.058858
R4127 VDD.n1478 VDD.n1477 0.058858
R4128 VDD.n1063 VDD.n1062 0.058858
R4129 VDD.n1059 VDD.n1058 0.058858
R4130 VDD.n1056 VDD.n1055 0.058858
R4131 VDD.n1053 VDD.n1014 0.058858
R4132 VDD.n1016 VDD.n1015 0.058858
R4133 VDD.n1050 VDD.n1018 0.058858
R4134 VDD.n1047 VDD.n1020 0.058858
R4135 VDD.n1044 VDD.n1022 0.058858
R4136 VDD.n1043 VDD.n1042 0.058858
R4137 VDD.n1041 VDD.n1040 0.058858
R4138 VDD.n1038 VDD.n1037 0.058858
R4139 VDD.n1035 VDD.n1034 0.058858
R4140 VDD.n1032 VDD.n1031 0.058858
R4141 VDD.n1032 VDD 0.058858
R4142 VDD.n1035 VDD 0.058858
R4143 VDD.n1038 VDD 0.058858
R4144 VDD.n1040 VDD 0.058858
R4145 VDD VDD.n1022 0.058858
R4146 VDD VDD.n1020 0.058858
R4147 VDD VDD.n1018 0.058858
R4148 VDD VDD.n1016 0.058858
R4149 VDD.n1056 VDD 0.058858
R4150 VDD.n1059 VDD 0.058858
R4151 VDD.n1063 VDD 0.058858
R4152 VDD.n1477 VDD 0.058858
R4153 VDD.n1902 VDD.n1901 0.058858
R4154 VDD.n1898 VDD.n1897 0.058858
R4155 VDD.n942 VDD.n941 0.058858
R4156 VDD.n840 VDD.n838 0.058858
R4157 VDD.n1907 VDD.n1906 0.058858
R4158 VDD.n936 VDD.n935 0.058858
R4159 VDD.n1834 VDD.n933 0.058858
R4160 VDD.n930 VDD.n929 0.058858
R4161 VDD.n1594 VDD.n927 0.058858
R4162 VDD.n924 VDD.n923 0.058858
R4163 VDD.n1584 VDD.n921 0.058858
R4164 VDD.n918 VDD.n917 0.058858
R4165 VDD.n1574 VDD.n915 0.058858
R4166 VDD.n912 VDD.n911 0.058858
R4167 VDD.n1564 VDD.n909 0.058858
R4168 VDD.n906 VDD.n905 0.058858
R4169 VDD.n1554 VDD.n903 0.058858
R4170 VDD.n900 VDD.n899 0.058858
R4171 VDD.n1544 VDD.n897 0.058858
R4172 VDD.n894 VDD.n893 0.058858
R4173 VDD.n1534 VDD.n891 0.058858
R4174 VDD.n888 VDD.n887 0.058858
R4175 VDD.n1524 VDD.n885 0.058858
R4176 VDD.n883 VDD.n852 0.058858
R4177 VDD.n882 VDD.n881 0.058858
R4178 VDD.n1514 VDD.n880 0.058858
R4179 VDD.n877 VDD.n876 0.058858
R4180 VDD.n993 VDD.n874 0.058858
R4181 VDD.n871 VDD.n870 0.058858
R4182 VDD.n983 VDD.n868 0.058858
R4183 VDD.n865 VDD.n864 0.058858
R4184 VDD.n862 VDD.n861 0.058858
R4185 VDD.n1619 VDD.n1618 0.058858
R4186 VDD.n945 VDD.n944 0.058858
R4187 VDD.n1891 VDD.n1890 0.058858
R4188 VDD.n1613 VDD.n1612 0.058858
R4189 VDD.n1609 VDD.n1608 0.058858
R4190 VDD.n1605 VDD.n1604 0.058858
R4191 VDD.n1837 VDD.n1602 0.058858
R4192 VDD.n1599 VDD.n1598 0.058858
R4193 VDD.n1593 VDD.n1592 0.058858
R4194 VDD.n1589 VDD.n1588 0.058858
R4195 VDD.n1583 VDD.n1582 0.058858
R4196 VDD.n1579 VDD.n1578 0.058858
R4197 VDD.n1573 VDD.n1572 0.058858
R4198 VDD.n1569 VDD.n1568 0.058858
R4199 VDD.n1563 VDD.n1562 0.058858
R4200 VDD.n1559 VDD.n1558 0.058858
R4201 VDD.n1553 VDD.n1552 0.058858
R4202 VDD.n1549 VDD.n1548 0.058858
R4203 VDD.n1543 VDD.n1542 0.058858
R4204 VDD.n1539 VDD.n1538 0.058858
R4205 VDD.n1533 VDD.n1532 0.058858
R4206 VDD.n1529 VDD.n1528 0.058858
R4207 VDD.n1523 VDD.n1522 0.058858
R4208 VDD.n1519 VDD.n1518 0.058858
R4209 VDD.n1513 VDD.n1512 0.058858
R4210 VDD.n1509 VDD.n1508 0.058858
R4211 VDD.n992 VDD.n991 0.058858
R4212 VDD.n988 VDD.n987 0.058858
R4213 VDD.n982 VDD.n981 0.058858
R4214 VDD.n978 VDD.n977 0.058858
R4215 VDD.n975 VDD.n974 0.058858
R4216 VDD.n971 VDD.n970 0.058858
R4217 VDD.n968 VDD.n967 0.058858
R4218 VDD.n1883 VDD.n1882 0.058858
R4219 VDD.n1878 VDD.n1877 0.058858
R4220 VDD.n1874 VDD.n1873 0.058858
R4221 VDD.n1870 VDD.n1869 0.058858
R4222 VDD.n1636 VDD.n1635 0.058858
R4223 VDD.n1632 VDD.n1631 0.058858
R4224 VDD.n1840 VDD.n1629 0.058858
R4225 VDD.n1860 VDD.n1859 0.058858
R4226 VDD.n1856 VDD.n1855 0.058858
R4227 VDD.n1852 VDD.n1851 0.058858
R4228 VDD.n1639 VDD.n1637 0.058858
R4229 VDD.n1864 VDD.n1863 0.058858
R4230 VDD.n1846 VDD.n1845 0.058858
R4231 VDD.n1648 VDD.n1647 0.058858
R4232 VDD.n144 VDD.n143 0.058858
R4233 VDD.n5 VDD.n4 0.058858
R4234 VDD.n2067 VDD.n2066 0.058858
R4235 VDD.n138 VDD.n137 0.058858
R4236 VDD.n165 VDD.n135 0.058858
R4237 VDD.n132 VDD.n131 0.058858
R4238 VDD.n1801 VDD.n129 0.058858
R4239 VDD.n126 VDD.n125 0.058858
R4240 VDD.n1789 VDD.n123 0.058858
R4241 VDD.n120 VDD.n119 0.058858
R4242 VDD.n1778 VDD.n117 0.058858
R4243 VDD.n114 VDD.n113 0.058858
R4244 VDD.n1767 VDD.n111 0.058858
R4245 VDD.n108 VDD.n107 0.058858
R4246 VDD.n1756 VDD.n105 0.058858
R4247 VDD.n102 VDD.n101 0.058858
R4248 VDD.n1745 VDD.n99 0.058858
R4249 VDD.n96 VDD.n95 0.058858
R4250 VDD.n1734 VDD.n93 0.058858
R4251 VDD.n90 VDD.n89 0.058858
R4252 VDD.n1723 VDD.n87 0.058858
R4253 VDD.n84 VDD.n83 0.058858
R4254 VDD.n1712 VDD.n81 0.058858
R4255 VDD.n78 VDD.n77 0.058858
R4256 VDD.n1701 VDD.n75 0.058858
R4257 VDD.n72 VDD.n71 0.058858
R4258 VDD.n1690 VDD.n69 0.058858
R4259 VDD.n66 VDD.n65 0.058858
R4260 VDD.n1679 VDD.n63 0.058858
R4261 VDD.n60 VDD.n59 0.058858
R4262 VDD.n27 VDD.n26 0.058858
R4263 VDD.n2076 VDD.n2075 0.058858
R4264 VDD.n2074 VDD.n2073 0.058858
R4265 VDD.n1649 VDD.n2 0.058858
R4266 VDD.n1660 VDD.n1659 0.058858
R4267 VDD.n1662 VDD.n1661 0.058858
R4268 VDD.n1799 VDD.n1798 0.058858
R4269 VDD.n1786 VDD.n1785 0.058858
R4270 VDD.n1784 VDD.n1783 0.058858
R4271 VDD.n1777 VDD.n1776 0.058858
R4272 VDD.n1764 VDD.n1763 0.058858
R4273 VDD.n1762 VDD.n1761 0.058858
R4274 VDD.n1755 VDD.n1754 0.058858
R4275 VDD.n1742 VDD.n1741 0.058858
R4276 VDD.n1740 VDD.n1739 0.058858
R4277 VDD.n1733 VDD.n1732 0.058858
R4278 VDD.n1720 VDD.n1719 0.058858
R4279 VDD.n1718 VDD.n1717 0.058858
R4280 VDD.n1711 VDD.n1710 0.058858
R4281 VDD.n1708 VDD.n1707 0.058858
R4282 VDD.n1698 VDD.n1697 0.058858
R4283 VDD.n1696 VDD.n1695 0.058858
R4284 VDD.n1689 VDD.n1688 0.058858
R4285 VDD.n1676 VDD.n1675 0.058858
R4286 VDD.n1674 VDD.n1673 0.058858
R4287 VDD.n1668 VDD.n1667 0.058858
R4288 VDD.n1666 VDD.n1665 0.058858
R4289 VDD.n1683 VDD.n1682 0.058858
R4290 VDD.n1705 VDD.n1704 0.058858
R4291 VDD.n1727 VDD.n1726 0.058858
R4292 VDD.n1749 VDD.n1748 0.058858
R4293 VDD.n1771 VDD.n1770 0.058858
R4294 VDD.n1793 VDD.n1792 0.058858
R4295 VDD.n1655 VDD.n1654 0.058858
R4296 VDD.n146 VDD.n0 0.058858
R4297 VDD.n2072 VDD.n2071 0.058858
R4298 VDD.n1658 VDD.n1657 0.058858
R4299 VDD.n1664 VDD.n1663 0.058858
R4300 VDD.n1788 VDD.n1787 0.058858
R4301 VDD.n1782 VDD.n1781 0.058858
R4302 VDD.n1766 VDD.n1765 0.058858
R4303 VDD.n1760 VDD.n1759 0.058858
R4304 VDD.n1744 VDD.n1743 0.058858
R4305 VDD.n1738 VDD.n1737 0.058858
R4306 VDD.n1722 VDD.n1721 0.058858
R4307 VDD.n1716 VDD.n1715 0.058858
R4308 VDD.n1700 VDD.n1699 0.058858
R4309 VDD.n1694 VDD.n1693 0.058858
R4310 VDD.n1678 VDD.n1677 0.058858
R4311 VDD.n55 VDD.n54 0.0585556
R4312 VDD.n36 VDD.n35 0.0585556
R4313 VDD.n2060 VDD.n2059 0.0585556
R4314 VDD.n2051 VDD.n2050 0.0585556
R4315 VDD.n2043 VDD.n164 0.0585556
R4316 VDD.n1805 VDD.n1804 0.0585556
R4317 VDD.n2035 VDD.n2034 0.0585556
R4318 VDD.n2027 VDD.n188 0.0585556
R4319 VDD.n2040 VDD.n2039 0.0585556
R4320 VDD.n1808 VDD.n1807 0.0585556
R4321 VDD.n343 VDD.n342 0.0585556
R4322 VDD.n334 VDD.n333 0.0585556
R4323 VDD.n2019 VDD.n302 0.0585556
R4324 VDD.n2024 VDD.n2023 0.0585556
R4325 VDD.n293 VDD.n292 0.0585556
R4326 VDD.n1811 VDD.n1810 0.0585556
R4327 VDD.n454 VDD.n453 0.0585556
R4328 VDD.n444 VDD.n443 0.0585556
R4329 VDD.n434 VDD.n433 0.0585556
R4330 VDD.n424 VDD.n423 0.0585556
R4331 VDD.n414 VDD.n413 0.0585556
R4332 VDD.n404 VDD.n403 0.0585556
R4333 VDD.n394 VDD.n393 0.0585556
R4334 VDD.n384 VDD.n383 0.0585556
R4335 VDD.n374 VDD.n373 0.0585556
R4336 VDD.n364 VDD.n363 0.0585556
R4337 VDD.n354 VDD.n353 0.0585556
R4338 VDD.n2016 VDD.n2015 0.0585556
R4339 VDD.n2007 VDD.n2006 0.0585556
R4340 VDD.n1999 VDD.n468 0.0585556
R4341 VDD.n1814 VDD.n1813 0.0585556
R4342 VDD.n455 VDD.n452 0.0585556
R4343 VDD.n445 VDD.n442 0.0585556
R4344 VDD.n435 VDD.n432 0.0585556
R4345 VDD.n425 VDD.n422 0.0585556
R4346 VDD.n415 VDD.n412 0.0585556
R4347 VDD.n405 VDD.n402 0.0585556
R4348 VDD.n395 VDD.n392 0.0585556
R4349 VDD.n385 VDD.n382 0.0585556
R4350 VDD.n375 VDD.n372 0.0585556
R4351 VDD.n365 VDD.n362 0.0585556
R4352 VDD.n355 VDD.n352 0.0585556
R4353 VDD.n345 VDD.n325 0.0585556
R4354 VDD.n1991 VDD.n1990 0.0585556
R4355 VDD.n1983 VDD.n489 0.0585556
R4356 VDD.n1996 VDD.n1995 0.0585556
R4357 VDD.n1817 VDD.n1816 0.0585556
R4358 VDD.n1975 VDD.n518 0.0585556
R4359 VDD.n1980 VDD.n1979 0.0585556
R4360 VDD.n509 VDD.n508 0.0585556
R4361 VDD.n1820 VDD.n1819 0.0585556
R4362 VDD.n1972 VDD.n1971 0.0585556
R4363 VDD.n1963 VDD.n1962 0.0585556
R4364 VDD.n1955 VDD.n620 0.0585556
R4365 VDD.n1823 VDD.n1822 0.0585556
R4366 VDD.n774 VDD.n773 0.0585556
R4367 VDD.n764 VDD.n763 0.0585556
R4368 VDD.n754 VDD.n753 0.0585556
R4369 VDD.n744 VDD.n743 0.0585556
R4370 VDD.n734 VDD.n733 0.0585556
R4371 VDD.n724 VDD.n723 0.0585556
R4372 VDD.n714 VDD.n713 0.0585556
R4373 VDD.n704 VDD.n703 0.0585556
R4374 VDD.n694 VDD.n693 0.0585556
R4375 VDD.n684 VDD.n683 0.0585556
R4376 VDD.n662 VDD.n661 0.0585556
R4377 VDD.n1947 VDD.n1946 0.0585556
R4378 VDD.n1939 VDD.n790 0.0585556
R4379 VDD.n1952 VDD.n1951 0.0585556
R4380 VDD.n1826 VDD.n1825 0.0585556
R4381 VDD.n775 VDD.n772 0.0585556
R4382 VDD.n765 VDD.n762 0.0585556
R4383 VDD.n755 VDD.n752 0.0585556
R4384 VDD.n745 VDD.n742 0.0585556
R4385 VDD.n735 VDD.n732 0.0585556
R4386 VDD.n725 VDD.n722 0.0585556
R4387 VDD.n715 VDD.n712 0.0585556
R4388 VDD.n705 VDD.n702 0.0585556
R4389 VDD.n695 VDD.n692 0.0585556
R4390 VDD.n685 VDD.n682 0.0585556
R4391 VDD.n675 VDD.n660 0.0585556
R4392 VDD.n1931 VDD.n819 0.0585556
R4393 VDD.n1936 VDD.n1935 0.0585556
R4394 VDD.n810 VDD.n809 0.0585556
R4395 VDD.n1829 VDD.n1828 0.0585556
R4396 VDD.n1928 VDD.n1927 0.0585556
R4397 VDD.n1919 VDD.n1918 0.0585556
R4398 VDD.n1911 VDD.n836 0.0585556
R4399 VDD.n1832 VDD.n1831 0.0585556
R4400 VDD VDD.n1487 0.0585556
R4401 VDD.n1270 VDD 0.0585556
R4402 VDD.n1503 VDD 0.0585556
R4403 VDD.n1465 VDD 0.0585556
R4404 VDD.n1472 VDD 0.0585556
R4405 VDD VDD.n1462 0.0585556
R4406 VDD VDD.n1077 0.0585556
R4407 VDD.n1238 VDD 0.0585556
R4408 VDD.n1365 VDD 0.0585556
R4409 VDD.n1099 VDD 0.0585556
R4410 VDD.n1335 VDD 0.0585556
R4411 VDD.n1307 VDD 0.0585556
R4412 VDD.n1406 VDD 0.0585556
R4413 VDD VDD.n1202 0.0585556
R4414 VDD.n1224 VDD 0.0585556
R4415 VDD.n1903 VDD.n1902 0.0585556
R4416 VDD.n1895 VDD.n942 0.0585556
R4417 VDD.n1908 VDD.n1907 0.0585556
R4418 VDD.n1835 VDD.n1834 0.0585556
R4419 VDD.n1595 VDD.n1594 0.0585556
R4420 VDD.n1585 VDD.n1584 0.0585556
R4421 VDD.n1575 VDD.n1574 0.0585556
R4422 VDD.n1565 VDD.n1564 0.0585556
R4423 VDD.n1555 VDD.n1554 0.0585556
R4424 VDD.n1545 VDD.n1544 0.0585556
R4425 VDD.n1535 VDD.n1534 0.0585556
R4426 VDD.n1525 VDD.n1524 0.0585556
R4427 VDD.n1515 VDD.n1514 0.0585556
R4428 VDD.n994 VDD.n993 0.0585556
R4429 VDD.n984 VDD.n983 0.0585556
R4430 VDD.n1887 VDD.n1619 0.0585556
R4431 VDD.n1892 VDD.n1891 0.0585556
R4432 VDD.n1610 VDD.n1609 0.0585556
R4433 VDD.n1838 VDD.n1837 0.0585556
R4434 VDD.n1596 VDD.n1593 0.0585556
R4435 VDD.n1586 VDD.n1583 0.0585556
R4436 VDD.n1576 VDD.n1573 0.0585556
R4437 VDD.n1566 VDD.n1563 0.0585556
R4438 VDD.n1556 VDD.n1553 0.0585556
R4439 VDD.n1546 VDD.n1543 0.0585556
R4440 VDD.n1536 VDD.n1533 0.0585556
R4441 VDD.n1526 VDD.n1523 0.0585556
R4442 VDD.n1516 VDD.n1513 0.0585556
R4443 VDD.n1506 VDD.n992 0.0585556
R4444 VDD.n985 VDD.n982 0.0585556
R4445 VDD.n1884 VDD.n1883 0.0585556
R4446 VDD.n1875 VDD.n1874 0.0585556
R4447 VDD.n1867 VDD.n1636 0.0585556
R4448 VDD.n1841 VDD.n1840 0.0585556
R4449 VDD.n1859 VDD.n1620 0.0585556
R4450 VDD.n1853 VDD.n1852 0.0585556
R4451 VDD.n1865 VDD.n1864 0.0585556
R4452 VDD.n1843 VDD.n1648 0.0585556
R4453 VDD.n2063 VDD.n144 0.0585556
R4454 VDD.n2068 VDD.n2067 0.0585556
R4455 VDD.n166 VDD.n165 0.0585556
R4456 VDD.n1802 VDD.n1801 0.0585556
R4457 VDD.n1790 VDD.n1789 0.0585556
R4458 VDD.n1779 VDD.n1778 0.0585556
R4459 VDD.n1768 VDD.n1767 0.0585556
R4460 VDD.n1757 VDD.n1756 0.0585556
R4461 VDD.n1746 VDD.n1745 0.0585556
R4462 VDD.n1735 VDD.n1734 0.0585556
R4463 VDD.n1724 VDD.n1723 0.0585556
R4464 VDD.n1713 VDD.n1712 0.0585556
R4465 VDD.n1702 VDD.n1701 0.0585556
R4466 VDD.n1691 VDD.n1690 0.0585556
R4467 VDD.n1680 VDD.n1679 0.0585556
R4468 VDD.n57 VDD.n27 0.0585556
R4469 VDD.n147 VDD.n146 0.0585556
R4470 VDD.n2070 VDD.n2 0.0585556
R4471 VDD.n1657 VDD.n1656 0.0585556
R4472 VDD.n1800 VDD.n1799 0.0585556
R4473 VDD.n1791 VDD.n1788 0.0585556
R4474 VDD.n1780 VDD.n1777 0.0585556
R4475 VDD.n1769 VDD.n1766 0.0585556
R4476 VDD.n1758 VDD.n1755 0.0585556
R4477 VDD.n1747 VDD.n1744 0.0585556
R4478 VDD.n1736 VDD.n1733 0.0585556
R4479 VDD.n1725 VDD.n1722 0.0585556
R4480 VDD.n1714 VDD.n1711 0.0585556
R4481 VDD.n1703 VDD.n1700 0.0585556
R4482 VDD.n1692 VDD.n1689 0.0585556
R4483 VDD.n1681 VDD.n1678 0.0585556
R4484 VDD.n1333 VDD.n1332 0.0544815
R4485 VDD.n1445 VDD.n1444 0.0544815
R4486 VDD.n1391 VDD.n1390 0.0544815
R4487 VDD.n1413 VDD 0.053463
R4488 VDD.n1403 VDD 0.053463
R4489 VDD.n1395 VDD 0.053463
R4490 VDD.n1367 VDD 0.053463
R4491 VDD.n1272 VDD 0.053463
R4492 VDD.n1309 VDD 0.053463
R4493 VDD VDD.n1415 0.0514259
R4494 VDD VDD.n1186 0.0514259
R4495 VDD.n1393 VDD 0.0514259
R4496 VDD.n1368 VDD 0.0514259
R4497 VDD.n1273 VDD 0.0514259
R4498 VDD.n1310 VDD 0.0514259
R4499 VDD.n1423 VDD 0.0483704
R4500 VDD.n1255 VDD 0.0483704
R4501 VDD.n1290 VDD 0.0483704
R4502 VDD.n1423 VDD 0.0463333
R4503 VDD.n1255 VDD 0.0463333
R4504 VDD.n1290 VDD 0.0463333
R4505 VDD.n1415 VDD 0.0432778
R4506 VDD.n1186 VDD 0.0432778
R4507 VDD.n1393 VDD 0.0432778
R4508 VDD.n1368 VDD 0.0432778
R4509 VDD.n1273 VDD 0.0432778
R4510 VDD.n1310 VDD 0.0432778
R4511 VDD.n1413 VDD 0.0412407
R4512 VDD VDD.n1403 0.0412407
R4513 VDD VDD.n1395 0.0412407
R4514 VDD.n1367 VDD 0.0412407
R4515 VDD.n1272 VDD 0.0412407
R4516 VDD.n1309 VDD 0.0412407
R4517 VDD.n1314 VDD.n1313 0.0361481
R4518 VDD.n1459 VDD.n1123 0.0361481
R4519 VDD.n1487 VDD 0.0361481
R4520 VDD.n1270 VDD 0.0361481
R4521 VDD.n1503 VDD 0.0361481
R4522 VDD.n1372 VDD.n1371 0.0361481
R4523 VDD.n1472 VDD 0.0361481
R4524 VDD.n1462 VDD 0.0361481
R4525 VDD.n1238 VDD 0.0361481
R4526 VDD.n1365 VDD 0.0361481
R4527 VDD.n1335 VDD 0.0361481
R4528 VDD.n1307 VDD 0.0361481
R4529 VDD.n1132 VDD 0.0310556
R4530 VDD.n1252 VDD 0.0310556
R4531 VDD.n1287 VDD 0.0310556
R4532 VDD.n1475 VDD 0.025963
R4533 VDD.n1060 VDD 0.025963
R4534 VDD.n1355 VDD 0.025963
R4535 VDD.n1363 VDD 0.025963
R4536 VDD.n1337 VDD 0.025963
R4537 VDD.n1305 VDD 0.025963
R4538 VDD VDD.n49 0.0229074
R4539 VDD.n39 VDD 0.0229074
R4540 VDD VDD.n45 0.0229074
R4541 VDD VDD.n667 0.0229074
R4542 VDD.n663 VDD 0.0229074
R4543 VDD VDD.n664 0.0229074
R4544 VDD VDD.n1490 0.0229074
R4545 VDD.n1494 VDD 0.0229074
R4546 VDD VDD.n1001 0.0229074
R4547 VDD.n1498 VDD 0.0229074
R4548 VDD VDD.n998 0.0229074
R4549 VDD VDD.n1502 0.0229074
R4550 VDD VDD.n1467 0.0229074
R4551 VDD.n1066 VDD 0.0229074
R4552 VDD VDD.n1471 0.0229074
R4553 VDD.n1069 VDD 0.0229074
R4554 VDD VDD.n1119 0.0229074
R4555 VDD VDD.n1071 0.0229074
R4556 VDD VDD.n1116 0.0229074
R4557 VDD.n1076 VDD 0.0229074
R4558 VDD VDD.n1113 0.0229074
R4559 VDD VDD.n1078 0.0229074
R4560 VDD VDD.n1110 0.0229074
R4561 VDD VDD.n1080 0.0229074
R4562 VDD.n1107 VDD 0.0229074
R4563 VDD VDD.n1082 0.0229074
R4564 VDD VDD.n1101 0.0229074
R4565 VDD.n1084 VDD 0.0229074
R4566 VDD VDD.n1098 0.0229074
R4567 VDD.n1086 VDD 0.0229074
R4568 VDD VDD.n1094 0.0229074
R4569 VDD VDD.n1088 0.0229074
R4570 VDD VDD.n1091 0.0229074
R4571 VDD VDD.n1416 0.0229074
R4572 VDD VDD.n1136 0.0229074
R4573 VDD VDD.n1187 0.0229074
R4574 VDD VDD.n1138 0.0229074
R4575 VDD VDD.n1183 0.0229074
R4576 VDD VDD.n1422 0.0229074
R4577 VDD VDD.n1180 0.0229074
R4578 VDD.n1143 VDD 0.0229074
R4579 VDD VDD.n1177 0.0229074
R4580 VDD.n1145 VDD 0.0229074
R4581 VDD VDD.n1174 0.0229074
R4582 VDD.n1147 VDD 0.0229074
R4583 VDD VDD.n1171 0.0229074
R4584 VDD.n1149 VDD 0.0229074
R4585 VDD VDD.n1165 0.0229074
R4586 VDD VDD.n1151 0.0229074
R4587 VDD VDD.n1162 0.0229074
R4588 VDD VDD.n1153 0.0229074
R4589 VDD VDD.n1159 0.0229074
R4590 VDD VDD.n1155 0.0229074
R4591 VDD VDD.n1156 0.0229074
R4592 VDD VDD.n1408 0.0229074
R4593 VDD.n1191 VDD 0.0229074
R4594 VDD VDD.n1412 0.0229074
R4595 VDD.n1194 VDD 0.0229074
R4596 VDD VDD.n1402 0.0229074
R4597 VDD.n1196 VDD 0.0229074
R4598 VDD.n1399 VDD 0.0229074
R4599 VDD.n1201 VDD 0.0229074
R4600 VDD VDD.n1396 0.0229074
R4601 VDD VDD.n1203 0.0229074
R4602 VDD VDD.n1235 0.0229074
R4603 VDD VDD.n1205 0.0229074
R4604 VDD VDD.n1231 0.0229074
R4605 VDD VDD.n1207 0.0229074
R4606 VDD VDD.n1226 0.0229074
R4607 VDD.n1209 VDD 0.0229074
R4608 VDD VDD.n1223 0.0229074
R4609 VDD.n1211 VDD 0.0229074
R4610 VDD VDD.n1219 0.0229074
R4611 VDD.n1213 VDD 0.0229074
R4612 VDD.n1216 VDD 0.0229074
R4613 VDD VDD.n1476 0.0229074
R4614 VDD VDD.n1009 0.0229074
R4615 VDD VDD.n1061 0.0229074
R4616 VDD VDD.n1011 0.0229074
R4617 VDD VDD.n1057 0.0229074
R4618 VDD VDD.n1013 0.0229074
R4619 VDD VDD.n1054 0.0229074
R4620 VDD.n1017 VDD 0.0229074
R4621 VDD VDD.n1051 0.0229074
R4622 VDD.n1019 VDD 0.0229074
R4623 VDD VDD.n1048 0.0229074
R4624 VDD.n1021 VDD 0.0229074
R4625 VDD VDD.n1045 0.0229074
R4626 VDD.n1023 VDD 0.0229074
R4627 VDD VDD.n1039 0.0229074
R4628 VDD VDD.n1025 0.0229074
R4629 VDD VDD.n1036 0.0229074
R4630 VDD VDD.n1027 0.0229074
R4631 VDD VDD.n1033 0.0229074
R4632 VDD VDD.n1029 0.0229074
R4633 VDD VDD.n1030 0.0229074
R4634 VDD.n673 VDD 0.0178148
R4635 VDD VDD.n1134 0.0178148
R4636 VDD.n1254 VDD 0.0178148
R4637 VDD.n1289 VDD 0.0178148
R4638 VDD.n205 VDD 0.0167963
R4639 VDD.n533 VDD 0.0167963
R4640 VDD.n853 VDD 0.0167963
R4641 VDD VDD.n1706 0.0167963
R4642 VDD.n50 VDD 0.00559259
R4643 VDD.n49 VDD 0.00559259
R4644 VDD VDD.n48 0.00559259
R4645 VDD VDD.n39 0.00559259
R4646 VDD.n46 VDD 0.00559259
R4647 VDD.n45 VDD 0.00559259
R4648 VDD.n668 VDD 0.00559259
R4649 VDD.n667 VDD 0.00559259
R4650 VDD VDD.n672 0.00559259
R4651 VDD VDD.n663 0.00559259
R4652 VDD.n665 VDD 0.00559259
R4653 VDD.n664 VDD 0.00559259
R4654 VDD.n1491 VDD 0.00559259
R4655 VDD.n1490 VDD 0.00559259
R4656 VDD VDD.n1489 0.00559259
R4657 VDD VDD.n1494 0.00559259
R4658 VDD.n1495 VDD 0.00559259
R4659 VDD.n1001 VDD 0.00559259
R4660 VDD VDD.n1000 0.00559259
R4661 VDD VDD.n1498 0.00559259
R4662 VDD.n1499 VDD 0.00559259
R4663 VDD.n998 VDD 0.00559259
R4664 VDD VDD.n997 0.00559259
R4665 VDD.n1502 VDD 0.00559259
R4666 VDD.n1468 VDD 0.00559259
R4667 VDD.n1467 VDD 0.00559259
R4668 VDD VDD.n1466 0.00559259
R4669 VDD VDD.n1066 0.00559259
R4670 VDD.n1465 VDD 0.00559259
R4671 VDD.n1471 VDD 0.00559259
R4672 VDD.n1067 VDD 0.00559259
R4673 VDD VDD.n1069 0.00559259
R4674 VDD.n1463 VDD 0.00559259
R4675 VDD.n1119 VDD 0.00559259
R4676 VDD VDD.n1070 0.00559259
R4677 VDD VDD.n1071 0.00559259
R4678 VDD.n1117 VDD 0.00559259
R4679 VDD.n1116 VDD 0.00559259
R4680 VDD.n1074 VDD 0.00559259
R4681 VDD VDD.n1076 0.00559259
R4682 VDD.n1114 VDD 0.00559259
R4683 VDD.n1113 VDD 0.00559259
R4684 VDD VDD.n1077 0.00559259
R4685 VDD VDD.n1078 0.00559259
R4686 VDD.n1111 VDD 0.00559259
R4687 VDD.n1110 VDD 0.00559259
R4688 VDD VDD.n1109 0.00559259
R4689 VDD VDD.n1080 0.00559259
R4690 VDD.n1108 VDD 0.00559259
R4691 VDD.n1107 VDD 0.00559259
R4692 VDD VDD.n1106 0.00559259
R4693 VDD VDD.n1082 0.00559259
R4694 VDD VDD.n1103 0.00559259
R4695 VDD.n1101 VDD 0.00559259
R4696 VDD VDD.n1100 0.00559259
R4697 VDD VDD.n1084 0.00559259
R4698 VDD.n1099 VDD 0.00559259
R4699 VDD.n1098 VDD 0.00559259
R4700 VDD VDD.n1097 0.00559259
R4701 VDD VDD.n1086 0.00559259
R4702 VDD.n1095 VDD 0.00559259
R4703 VDD.n1094 VDD 0.00559259
R4704 VDD VDD.n1087 0.00559259
R4705 VDD VDD.n1088 0.00559259
R4706 VDD.n1092 VDD 0.00559259
R4707 VDD.n1091 VDD 0.00559259
R4708 VDD VDD.n1418 0.00559259
R4709 VDD.n1416 VDD 0.00559259
R4710 VDD VDD.n1135 0.00559259
R4711 VDD VDD.n1136 0.00559259
R4712 VDD.n1188 VDD 0.00559259
R4713 VDD.n1187 VDD 0.00559259
R4714 VDD VDD.n1137 0.00559259
R4715 VDD VDD.n1138 0.00559259
R4716 VDD.n1184 VDD 0.00559259
R4717 VDD.n1183 VDD 0.00559259
R4718 VDD VDD.n1139 0.00559259
R4719 VDD.n1422 VDD 0.00559259
R4720 VDD.n1181 VDD 0.00559259
R4721 VDD.n1180 VDD 0.00559259
R4722 VDD.n1141 VDD 0.00559259
R4723 VDD VDD.n1143 0.00559259
R4724 VDD.n1178 VDD 0.00559259
R4725 VDD.n1177 VDD 0.00559259
R4726 VDD VDD.n1176 0.00559259
R4727 VDD VDD.n1145 0.00559259
R4728 VDD.n1175 VDD 0.00559259
R4729 VDD.n1174 VDD 0.00559259
R4730 VDD VDD.n1173 0.00559259
R4731 VDD VDD.n1147 0.00559259
R4732 VDD.n1172 VDD 0.00559259
R4733 VDD.n1171 VDD 0.00559259
R4734 VDD VDD.n1170 0.00559259
R4735 VDD VDD.n1149 0.00559259
R4736 VDD VDD.n1167 0.00559259
R4737 VDD.n1165 VDD 0.00559259
R4738 VDD VDD.n1150 0.00559259
R4739 VDD VDD.n1151 0.00559259
R4740 VDD.n1163 VDD 0.00559259
R4741 VDD.n1162 VDD 0.00559259
R4742 VDD VDD.n1152 0.00559259
R4743 VDD VDD.n1153 0.00559259
R4744 VDD.n1160 VDD 0.00559259
R4745 VDD.n1159 VDD 0.00559259
R4746 VDD VDD.n1154 0.00559259
R4747 VDD VDD.n1155 0.00559259
R4748 VDD.n1157 VDD 0.00559259
R4749 VDD.n1156 VDD 0.00559259
R4750 VDD.n1409 VDD 0.00559259
R4751 VDD.n1408 VDD 0.00559259
R4752 VDD VDD.n1407 0.00559259
R4753 VDD VDD.n1191 0.00559259
R4754 VDD.n1406 VDD 0.00559259
R4755 VDD.n1412 VDD 0.00559259
R4756 VDD.n1192 VDD 0.00559259
R4757 VDD VDD.n1194 0.00559259
R4758 VDD.n1404 VDD 0.00559259
R4759 VDD.n1402 VDD 0.00559259
R4760 VDD VDD.n1401 0.00559259
R4761 VDD VDD.n1196 0.00559259
R4762 VDD.n1400 VDD 0.00559259
R4763 VDD.n1399 VDD 0.00559259
R4764 VDD.n1199 VDD 0.00559259
R4765 VDD VDD.n1201 0.00559259
R4766 VDD.n1397 VDD 0.00559259
R4767 VDD.n1396 VDD 0.00559259
R4768 VDD VDD.n1202 0.00559259
R4769 VDD VDD.n1203 0.00559259
R4770 VDD.n1236 VDD 0.00559259
R4771 VDD.n1235 VDD 0.00559259
R4772 VDD VDD.n1234 0.00559259
R4773 VDD VDD.n1205 0.00559259
R4774 VDD.n1232 VDD 0.00559259
R4775 VDD.n1231 VDD 0.00559259
R4776 VDD VDD.n1206 0.00559259
R4777 VDD VDD.n1207 0.00559259
R4778 VDD VDD.n1228 0.00559259
R4779 VDD.n1226 VDD 0.00559259
R4780 VDD VDD.n1225 0.00559259
R4781 VDD VDD.n1209 0.00559259
R4782 VDD.n1224 VDD 0.00559259
R4783 VDD.n1223 VDD 0.00559259
R4784 VDD VDD.n1222 0.00559259
R4785 VDD VDD.n1211 0.00559259
R4786 VDD.n1220 VDD 0.00559259
R4787 VDD.n1219 VDD 0.00559259
R4788 VDD VDD.n1218 0.00559259
R4789 VDD VDD.n1213 0.00559259
R4790 VDD.n1217 VDD 0.00559259
R4791 VDD.n1216 VDD 0.00559259
R4792 VDD VDD.n1478 0.00559259
R4793 VDD.n1476 VDD 0.00559259
R4794 VDD VDD.n1008 0.00559259
R4795 VDD VDD.n1009 0.00559259
R4796 VDD.n1062 VDD 0.00559259
R4797 VDD.n1061 VDD 0.00559259
R4798 VDD VDD.n1010 0.00559259
R4799 VDD VDD.n1011 0.00559259
R4800 VDD.n1058 VDD 0.00559259
R4801 VDD.n1057 VDD 0.00559259
R4802 VDD VDD.n1012 0.00559259
R4803 VDD VDD.n1013 0.00559259
R4804 VDD.n1055 VDD 0.00559259
R4805 VDD.n1054 VDD 0.00559259
R4806 VDD.n1015 VDD 0.00559259
R4807 VDD VDD.n1017 0.00559259
R4808 VDD.n1052 VDD 0.00559259
R4809 VDD.n1051 VDD 0.00559259
R4810 VDD VDD.n1050 0.00559259
R4811 VDD VDD.n1019 0.00559259
R4812 VDD.n1049 VDD 0.00559259
R4813 VDD.n1048 VDD 0.00559259
R4814 VDD VDD.n1047 0.00559259
R4815 VDD VDD.n1021 0.00559259
R4816 VDD.n1046 VDD 0.00559259
R4817 VDD.n1045 VDD 0.00559259
R4818 VDD VDD.n1044 0.00559259
R4819 VDD VDD.n1023 0.00559259
R4820 VDD VDD.n1041 0.00559259
R4821 VDD.n1039 VDD 0.00559259
R4822 VDD VDD.n1024 0.00559259
R4823 VDD VDD.n1025 0.00559259
R4824 VDD.n1037 VDD 0.00559259
R4825 VDD.n1036 VDD 0.00559259
R4826 VDD VDD.n1026 0.00559259
R4827 VDD VDD.n1027 0.00559259
R4828 VDD.n1034 VDD 0.00559259
R4829 VDD.n1033 VDD 0.00559259
R4830 VDD VDD.n1028 0.00559259
R4831 VDD VDD.n1029 0.00559259
R4832 VDD.n1031 VDD 0.00559259
R4833 VDD.n1030 VDD 0.00559259
R4834 VDD VDD.n1073 0.00457407
R4835 VDD.n1104 VDD 0.00457407
R4836 VDD.n1089 VDD 0.00457407
R4837 VDD.n1419 VDD 0.00457407
R4838 VDD VDD.n1179 0.00457407
R4839 VDD.n1168 VDD 0.00457407
R4840 VDD VDD.n1198 0.00457407
R4841 VDD.n1229 VDD 0.00457407
R4842 VDD.n1214 VDD 0.00457407
R4843 VDD.n1479 VDD 0.00457407
R4844 VDD VDD.n1053 0.00457407
R4845 VDD.n1042 VDD 0.00457407
R4846 VDD VDD.n1070 0.00253704
R4847 VDD.n1108 VDD 0.00253704
R4848 VDD VDD.n1087 0.00253704
R4849 VDD.n1340 VDD.t464 0.00175
R4850 VDD.n1343 VDD.t48 0.00175
R4851 VDD.n1350 VDD.t82 0.00175
R4852 VDD.n1352 VDD.t330 0.00175
R4853 VDD.t85 VDD.n1004 0.00175
R4854 VDD.t80 VDD.n1006 0.00162501
R4855 VDD.n1482 VDD.t89 0.00160001
R4856 VDD.n1354 VDD.t78 0.00160001
R4857 VDD.n1347 VDD.t57 0.00160001
R4858 VDD.n1347 VDD.t464 0.00139998
R4859 VDD.n1354 VDD.t82 0.00139998
R4860 VDD.n1482 VDD.t85 0.00139998
R4861 VDD.t440 VDD.n1006 0.00137498
R4862 VDD.t87 VDD.n1004 0.00124998
R4863 VDD.n1352 VDD.t451 0.00124998
R4864 VDD.n1350 VDD.t80 0.00124998
R4865 VDD.n1343 VDD.t51 0.00124998
R4866 VDD.n1340 VDD.t330 0.00124998
R4867 VDD.n1341 VDD.t57 0.001
R4868 VDD.n1351 VDD.t78 0.001
R4869 VDD.t89 VDD.n1005 0.001
R4870 VDD.t440 VDD.n1005 0.001
R4871 VDD.n1351 VDD.t451 0.001
R4872 VDD.n1341 VDD.t51 0.001
R4873 VSS.n2997 VSS.n2996 129762
R4874 VSS.n2988 VSS.n1186 129314
R4875 VSS.n2997 VSS.n2988 102882
R4876 VSS.n3244 VSS.n3243 4206.97
R4877 VSS.n3380 VSS.n3379 1582.07
R4878 VSS.n3381 VSS.n3380 1582.07
R4879 VSS.n3384 VSS.n3383 1582.07
R4880 VSS.n3385 VSS.n3384 1582.07
R4881 VSS.n908 VSS.n907 1549.87
R4882 VSS.n33 VSS.n26 1382.31
R4883 VSS.n3768 VSS.n3767 1382.31
R4884 VSS.n498 VSS.n58 1382.31
R4885 VSS.n3783 VSS.n3782 1382.31
R4886 VSS.n492 VSS.n21 1382.31
R4887 VSS.n517 VSS.n516 1382.31
R4888 VSS.n893 VSS.n892 1382.31
R4889 VSS.n2006 VSS.n2005 1382.31
R4890 VSS.n1990 VSS.n1988 1382.31
R4891 VSS.n3753 VSS.n3752 1382.31
R4892 VSS.n2220 VSS.n2219 1382.31
R4893 VSS.n2303 VSS.n2302 1382.31
R4894 VSS.n2259 VSS.n1944 1382.31
R4895 VSS.n2065 VSS.n2064 1382.31
R4896 VSS.n2031 VSS.n2029 1382.31
R4897 VSS.n2039 VSS.n2037 1382.31
R4898 VSS.n3734 VSS.n3733 1382.31
R4899 VSS.n97 VSS.n82 1382.31
R4900 VSS.n3708 VSS.n3707 1382.31
R4901 VSS.n139 VSS.n115 1382.31
R4902 VSS.n3682 VSS.n3681 1382.31
R4903 VSS.n181 VSS.n157 1382.31
R4904 VSS.n3656 VSS.n3655 1382.31
R4905 VSS.n223 VSS.n199 1382.31
R4906 VSS.n3630 VSS.n3629 1382.31
R4907 VSS.n265 VSS.n241 1382.31
R4908 VSS.n3604 VSS.n3603 1382.31
R4909 VSS.n321 VSS.n277 1382.31
R4910 VSS.n1962 VSS.n1961 1382.31
R4911 VSS.n1956 VSS.n1947 1382.31
R4912 VSS.n2288 VSS.n2287 1382.31
R4913 VSS.n2196 VSS.n2195 1382.31
R4914 VSS.n2190 VSS.n2189 1382.31
R4915 VSS.n2184 VSS.n1923 1382.31
R4916 VSS.n2163 VSS.n2162 1382.31
R4917 VSS.n2147 VSS.n2145 1382.31
R4918 VSS.n2341 VSS.n2340 1382.31
R4919 VSS.n1538 VSS.n1536 1382.31
R4920 VSS.n1586 VSS.n1544 1382.31
R4921 VSS.n1892 VSS.n1891 1382.31
R4922 VSS.n1628 VSS.n1604 1382.31
R4923 VSS.n1866 VSS.n1865 1382.31
R4924 VSS.n1670 VSS.n1646 1382.31
R4925 VSS.n1840 VSS.n1839 1382.31
R4926 VSS.n1712 VSS.n1688 1382.31
R4927 VSS.n1814 VSS.n1813 1382.31
R4928 VSS.n1732 VSS.n1730 1382.31
R4929 VSS.n1740 VSS.n1738 1382.31
R4930 VSS.n1745 VSS.n1743 1382.31
R4931 VSS.n2496 VSS.n2495 1382.31
R4932 VSS.n2490 VSS.n2489 1382.31
R4933 VSS.n2484 VSS.n1404 1382.31
R4934 VSS.n1424 VSS.n1417 1382.31
R4935 VSS.n2562 VSS.n2561 1382.31
R4936 VSS.n2556 VSS.n1391 1382.31
R4937 VSS.n2122 VSS.n2121 1382.31
R4938 VSS.n2356 VSS.n2355 1382.31
R4939 VSS.n1553 VSS.n1523 1382.31
R4940 VSS.n2371 VSS.n2364 1382.31
R4941 VSS.n2397 VSS.n2396 1382.31
R4942 VSS.n2439 VSS.n2438 1382.31
R4943 VSS.n2098 VSS.n2097 1382.31
R4944 VSS.n2092 VSS.n2091 1382.31
R4945 VSS.n2086 VSS.n1502 1382.31
R4946 VSS.n2463 VSS.n2462 1382.31
R4947 VSS.n1453 VSS.n1451 1382.31
R4948 VSS.n1461 VSS.n1459 1382.31
R4949 VSS.n1469 VSS.n1467 1382.31
R4950 VSS.n1473 VSS.n1370 1382.31
R4951 VSS.n2978 VSS.n2977 1382.31
R4952 VSS.n2778 VSS.n2661 1382.31
R4953 VSS.n2946 VSS.n2945 1382.31
R4954 VSS.n2828 VSS.n2796 1382.31
R4955 VSS.n2829 VSS.n2822 1382.31
R4956 VSS.n2903 VSS.n2902 1382.31
R4957 VSS.n2859 VSS.n2857 1382.31
R4958 VSS.n2863 VSS.n976 1382.31
R4959 VSS.n3486 VSS.n3485 1382.31
R4960 VSS.n3480 VSS.n956 1382.31
R4961 VSS.n556 VSS.n555 1382.31
R4962 VSS.n573 VSS.n572 1382.31
R4963 VSS.n567 VSS.n540 1382.31
R4964 VSS.n603 VSS.n602 1382.31
R4965 VSS.n597 VSS.n475 1382.31
R4966 VSS.n654 VSS.n653 1382.31
R4967 VSS.n648 VSS.n457 1382.31
R4968 VSS.n704 VSS.n703 1382.31
R4969 VSS.n698 VSS.n439 1382.31
R4970 VSS.n754 VSS.n753 1382.31
R4971 VSS.n748 VSS.n421 1382.31
R4972 VSS.n804 VSS.n803 1382.31
R4973 VSS.n798 VSS.n403 1382.31
R4974 VSS.n851 VSS.n850 1382.31
R4975 VSS.n845 VSS.n340 1382.31
R4976 VSS.n3401 VSS.n3400 1369.73
R4977 VSS.n1084 VSS.n1052 1369.73
R4978 VSS.n3361 VSS.n3360 1369.73
R4979 VSS.n3353 VSS.n3352 1369.73
R4980 VSS.n3328 VSS.n3327 1369.73
R4981 VSS.n3320 VSS.n3319 1369.73
R4982 VSS.n393 VSS.n388 1365.97
R4983 VSS.n3530 VSS.n943 1365.97
R4984 VSS.n36 VSS.n35 1349.63
R4985 VSS.n49 VSS.n48 1349.63
R4986 VSS.n3765 VSS.n3764 1349.63
R4987 VSS.n507 VSS.n506 1349.63
R4988 VSS.n875 VSS.n874 1349.63
R4989 VSS.n373 VSS.n372 1349.63
R4990 VSS.n12 VSS.n11 1349.63
R4991 VSS.n3780 VSS.n3779 1349.63
R4992 VSS.n520 VSS.n519 1349.63
R4993 VSS.n514 VSS.n513 1349.63
R4994 VSS.n397 VSS.n349 1349.63
R4995 VSS.n890 VSS.n889 1349.63
R4996 VSS.n1979 VSS.n1978 1349.63
R4997 VSS.n2003 VSS.n2002 1349.63
R4998 VSS.n1994 VSS.n63 1349.63
R4999 VSS.n3750 VSS.n3749 1349.63
R5000 VSS.n2210 VSS.n2209 1349.63
R5001 VSS.n2217 VSS.n1935 1349.63
R5002 VSS.n2300 VSS.n2299 1349.63
R5003 VSS.n2268 VSS.n2267 1349.63
R5004 VSS.n2020 VSS.n2019 1349.63
R5005 VSS.n2062 VSS.n2061 1349.63
R5006 VSS.n2052 VSS.n2051 1349.63
R5007 VSS.n2043 VSS.n73 1349.63
R5008 VSS.n3731 VSS.n3730 1349.63
R5009 VSS.n106 VSS.n105 1349.63
R5010 VSS.n3705 VSS.n3704 1349.63
R5011 VSS.n148 VSS.n147 1349.63
R5012 VSS.n3679 VSS.n3678 1349.63
R5013 VSS.n190 VSS.n189 1349.63
R5014 VSS.n3653 VSS.n3652 1349.63
R5015 VSS.n232 VSS.n231 1349.63
R5016 VSS.n3627 VSS.n3626 1349.63
R5017 VSS.n274 VSS.n273 1349.63
R5018 VSS.n3601 VSS.n3600 1349.63
R5019 VSS.n330 VSS.n329 1349.63
R5020 VSS.n1965 VSS.n1964 1349.63
R5021 VSS.n1959 VSS.n1958 1349.63
R5022 VSS.n2243 VSS.n2242 1349.63
R5023 VSS.n2285 VSS.n2284 1349.63
R5024 VSS.n314 VSS.n313 1349.63
R5025 VSS.n3570 VSS.n3569 1349.63
R5026 VSS.n3583 VSS.n3582 1349.63
R5027 VSS.n2177 VSS.n2176 1349.63
R5028 VSS.n2193 VSS.n2192 1349.63
R5029 VSS.n2187 VSS.n2186 1349.63
R5030 VSS.n2326 VSS.n2325 1349.63
R5031 VSS.n2136 VSS.n2135 1349.63
R5032 VSS.n2160 VSS.n2159 1349.63
R5033 VSS.n2151 VSS.n1527 1349.63
R5034 VSS.n2338 VSS.n2337 1349.63
R5035 VSS.n1915 VSS.n1914 1349.63
R5036 VSS.n1595 VSS.n1594 1349.63
R5037 VSS.n1889 VSS.n1888 1349.63
R5038 VSS.n1637 VSS.n1636 1349.63
R5039 VSS.n1863 VSS.n1862 1349.63
R5040 VSS.n1679 VSS.n1678 1349.63
R5041 VSS.n1837 VSS.n1836 1349.63
R5042 VSS.n1721 VSS.n1720 1349.63
R5043 VSS.n1811 VSS.n1810 1349.63
R5044 VSS.n1776 VSS.n1775 1349.63
R5045 VSS.n1766 VSS.n1765 1349.63
R5046 VSS.n1755 VSS.n1754 1349.63
R5047 VSS.n2477 VSS.n2476 1349.63
R5048 VSS.n2493 VSS.n2492 1349.63
R5049 VSS.n2487 VSS.n2486 1349.63
R5050 VSS.n2585 VSS.n2584 1349.63
R5051 VSS.n1427 VSS.n1426 1349.63
R5052 VSS.n2549 VSS.n2548 1349.63
R5053 VSS.n2559 VSS.n2558 1349.63
R5054 VSS.n2616 VSS.n2615 1349.63
R5055 VSS.n3001 VSS.n3000 1349.63
R5056 VSS.n3009 VSS.n3008 1349.63
R5057 VSS.n3040 VSS.n3039 1349.63
R5058 VSS.n3054 VSS.n3053 1349.63
R5059 VSS.n3048 VSS.n1304 1349.63
R5060 VSS.n3100 VSS.n3099 1349.63
R5061 VSS.n3111 VSS.n3110 1349.63
R5062 VSS.n3279 VSS.n3278 1349.63
R5063 VSS.n1234 VSS.n1232 1349.63
R5064 VSS.n3271 VSS.n3270 1349.63
R5065 VSS.n3264 VSS.n3263 1349.63
R5066 VSS.n1009 VSS.n1008 1349.63
R5067 VSS.n3453 VSS.n3452 1349.63
R5068 VSS.n2961 VSS.n2960 1349.63
R5069 VSS.n2692 VSS.n2691 1349.63
R5070 VSS.n2699 VSS.n2698 1349.63
R5071 VSS.n2754 VSS.n2753 1349.63
R5072 VSS.n2738 VSS.n2737 1349.63
R5073 VSS.n2718 VSS.n2716 1349.63
R5074 VSS.n2730 VSS.n2729 1349.63
R5075 VSS.n3442 VSS.n3441 1349.63
R5076 VSS.n3426 VSS.n3425 1349.63
R5077 VSS.n1033 VSS.n1031 1349.63
R5078 VSS.n3418 VSS.n3417 1349.63
R5079 VSS.n3181 VSS.n3180 1349.63
R5080 VSS.n2112 VSS.n2111 1349.63
R5081 VSS.n2119 VSS.n1514 1349.63
R5082 VSS.n2353 VSS.n2352 1349.63
R5083 VSS.n1558 VSS.n1557 1349.63
R5084 VSS.n2374 VSS.n2373 1349.63
R5085 VSS.n2387 VSS.n2386 1349.63
R5086 VSS.n2394 VSS.n1492 1349.63
R5087 VSS.n2436 VSS.n2435 1349.63
R5088 VSS.n2079 VSS.n2078 1349.63
R5089 VSS.n2095 VSS.n2094 1349.63
R5090 VSS.n2089 VSS.n2088 1349.63
R5091 VSS.n2420 VSS.n2419 1349.63
R5092 VSS.n3524 VSS.n3523 1349.63
R5093 VSS.n1442 VSS.n1441 1349.63
R5094 VSS.n2460 VSS.n2459 1349.63
R5095 VSS.n2451 VSS.n2450 1349.63
R5096 VSS.n1485 VSS.n1484 1349.63
R5097 VSS.n1476 VSS.n1475 1349.63
R5098 VSS.n2652 VSS.n2651 1349.63
R5099 VSS.n2975 VSS.n2974 1349.63
R5100 VSS.n2787 VSS.n2786 1349.63
R5101 VSS.n2943 VSS.n2942 1349.63
R5102 VSS.n2832 VSS.n2831 1349.63
R5103 VSS.n2848 VSS.n2847 1349.63
R5104 VSS.n2900 VSS.n2899 1349.63
R5105 VSS.n2866 VSS.n2865 1349.63
R5106 VSS.n3473 VSS.n3472 1349.63
R5107 VSS.n3483 VSS.n3482 1349.63
R5108 VSS.n3510 VSS.n3509 1349.63
R5109 VSS.n553 VSS.n552 1349.63
R5110 VSS.n566 VSS.n565 1349.63
R5111 VSS.n570 VSS.n569 1349.63
R5112 VSS.n590 VSS.n589 1349.63
R5113 VSS.n600 VSS.n599 1349.63
R5114 VSS.n641 VSS.n640 1349.63
R5115 VSS.n651 VSS.n650 1349.63
R5116 VSS.n691 VSS.n690 1349.63
R5117 VSS.n701 VSS.n700 1349.63
R5118 VSS.n741 VSS.n740 1349.63
R5119 VSS.n751 VSS.n750 1349.63
R5120 VSS.n791 VSS.n790 1349.63
R5121 VSS.n801 VSS.n800 1349.63
R5122 VSS.n838 VSS.n837 1349.63
R5123 VSS.n848 VSS.n847 1349.63
R5124 VSS.n905 VSS.n904 1349.63
R5125 VSS.n3348 VSS.n3347 1177.15
R5126 VSS.n3315 VSS.n3314 1177.15
R5127 VSS.n3031 VSS.n3030 1171.97
R5128 VSS.n3073 VSS.n3072 1171.97
R5129 VSS.n3076 VSS.n3075 1171.97
R5130 VSS.n3079 VSS.n3078 1171.97
R5131 VSS.n3121 VSS.n3120 1171.97
R5132 VSS.n3129 VSS.n3128 1171.97
R5133 VSS.n3132 VSS.n3131 1171.97
R5134 VSS.n3135 VSS.n3134 1171.97
R5135 VSS.n3200 VSS.n3199 1171.97
R5136 VSS.n3206 VSS.n3205 1171.97
R5137 VSS.n3209 VSS.n3208 1171.97
R5138 VSS.n1087 VSS.n1086 1042.18
R5139 VSS.n3560 VSS.n915 1023.21
R5140 VSS.n3306 VSS.n1041 982.63
R5141 VSS.n3409 VSS.n3408 982.63
R5142 VSS.n3404 VSS.n3403 982.63
R5143 VSS.n3396 VSS.n3395 982.63
R5144 VSS.n3375 VSS.n1185 982.63
R5145 VSS.n3369 VSS.n3368 982.63
R5146 VSS.n3364 VSS.n3363 982.63
R5147 VSS.n3356 VSS.n3355 982.63
R5148 VSS.n3339 VSS.n3338 982.63
R5149 VSS.n3336 VSS.n3335 982.63
R5150 VSS.n3331 VSS.n3330 982.63
R5151 VSS.n3323 VSS.n3322 982.63
R5152 VSS.n3005 VSS.n1338 968.216
R5153 VSS.n3043 VSS.n3042 968.216
R5154 VSS.n3063 VSS.n3062 968.216
R5155 VSS.n3059 VSS.n3058 968.216
R5156 VSS.n3103 VSS.n3102 968.216
R5157 VSS.n3107 VSS.n1227 968.216
R5158 VSS.n3288 VSS.n3287 968.216
R5159 VSS.n3284 VSS.n3283 968.216
R5160 VSS.n3267 VSS.n3266 968.216
R5161 VSS.n3260 VSS.n3259 968.216
R5162 VSS.n3254 VSS.n3253 968.216
R5163 VSS.n3250 VSS.n3249 968.216
R5164 VSS.n2702 VSS.n2701 968.216
R5165 VSS.n2750 VSS.n2749 968.216
R5166 VSS.n2747 VSS.n2746 968.216
R5167 VSS.n2743 VSS.n2742 968.216
R5168 VSS.n2723 VSS.n1020 968.216
R5169 VSS.n3438 VSS.n3437 968.216
R5170 VSS.n3435 VSS.n3434 968.216
R5171 VSS.n3431 VSS.n3430 968.216
R5172 VSS.n3154 VSS.n1037 968.216
R5173 VSS.n3177 VSS.n3176 968.216
R5174 VSS.n3172 VSS.n3171 968.216
R5175 VSS.n3168 VSS.n3167 968.216
R5176 VSS.n3560 VSS.n3559 958.269
R5177 VSS.n3561 VSS.n3560 876.957
R5178 VSS.n909 VSS.n908 858.718
R5179 VSS.n910 VSS.n909 858.718
R5180 VSS.n911 VSS.n910 858.718
R5181 VSS.n912 VSS.n911 858.718
R5182 VSS.n913 VSS.n912 858.718
R5183 VSS.n3562 VSS.n913 858.718
R5184 VSS.n3562 VSS.n3561 858.718
R5185 VSS.n2992 VSS.n1352 840.764
R5186 VSS.n3019 VSS.n3018 840.764
R5187 VSS.n3022 VSS.n3021 840.764
R5188 VSS.n3026 VSS.n1324 840.764
R5189 VSS.n3082 VSS.n3081 840.764
R5190 VSS.n3091 VSS.n3090 840.764
R5191 VSS.n3086 VSS.n1290 840.764
R5192 VSS.n3124 VSS.n3123 840.764
R5193 VSS.n3138 VSS.n3137 840.764
R5194 VSS.n3146 VSS.n3145 840.764
R5195 VSS.n3149 VSS.n3148 840.764
R5196 VSS.n3203 VSS.n3202 840.764
R5197 VSS.n510 VSS.n509 691.154
R5198 VSS.n376 VSS.n357 691.154
R5199 VSS.n909 VSS.n334 691.154
R5200 VSS.n376 VSS.n375 691.154
R5201 VSS.n910 VSS.n333 691.154
R5202 VSS.n511 VSS.n510 691.154
R5203 VSS.n908 VSS.n335 691.154
R5204 VSS.n510 VSS.n66 691.154
R5205 VSS.n2271 VSS.n2270 691.154
R5206 VSS.n911 VSS.n332 691.154
R5207 VSS.n2271 VSS.n2252 691.154
R5208 VSS.n3586 VSS.n292 691.154
R5209 VSS.n912 VSS.n316 691.154
R5210 VSS.n3586 VSS.n293 691.154
R5211 VSS.n3563 VSS.n3562 691.154
R5212 VSS.n3586 VSS.n3585 691.154
R5213 VSS.n913 VSS.n296 691.154
R5214 VSS.n2271 VSS.n1922 691.154
R5215 VSS.n3561 VSS.n914 691.154
R5216 VSS.n2588 VSS.n2587 691.154
R5217 VSS.n2588 VSS.n1390 691.154
R5218 VSS.n1555 VSS.n1554 691.154
R5219 VSS.n1554 VSS.n1495 691.154
R5220 VSS.n1554 VSS.n1501 691.154
R5221 VSS.n3521 VSS.n3520 691.154
R5222 VSS.n3513 VSS.n3512 691.154
R5223 VSS.n2998 VSS.n2997 674.817
R5224 VSS.n3245 VSS.n3244 674.817
R5225 VSS.n3460 VSS.n3459 674.817
R5226 VSS.n1004 VSS.n1003 674.817
R5227 VSS.n2926 VSS.n1015 674.817
R5228 VSS.n2913 VSS.n1011 674.817
R5229 VSS.n2964 VSS.n2963 674.817
R5230 VSS.n2956 VSS.n2955 674.817
R5231 VSS.n2988 VSS.n1364 674.817
R5232 VSS.n3163 VSS.n966 674.817
R5233 VSS.n3244 VSS.n3211 585.987
R5234 VSS.t819 VSS.t825 519.758
R5235 VSS.t815 VSS.t810 519.758
R5236 VSS.t830 VSS.t808 519.758
R5237 VSS.t499 VSS.t812 519.758
R5238 VSS.t495 VSS.t822 519.758
R5239 VSS.t493 VSS.t1938 519.758
R5240 VSS.t497 VSS.t1928 519.758
R5241 VSS.t1947 VSS.t1930 519.758
R5242 VSS.t1936 VSS.t1943 519.758
R5243 VSS.t1932 VSS.t1939 519.758
R5244 VSS.t208 VSS.t234 519.758
R5245 VSS.t218 VSS.t228 519.758
R5246 VSS.t222 VSS.t212 519.758
R5247 VSS.t220 VSS.t214 519.758
R5248 VSS.t224 VSS.t210 519.758
R5249 VSS.t500 VSS.t1152 519.758
R5250 VSS.t494 VSS.t1134 519.758
R5251 VSS.t1140 VSS.t1154 519.758
R5252 VSS.t1159 VSS.t1148 519.758
R5253 VSS.t1137 VSS.t1145 519.758
R5254 VSS.t712 VSS.t700 519.758
R5255 VSS.t708 VSS.t693 519.758
R5256 VSS.t697 VSS.t715 519.758
R5257 VSS.t491 VSS.t695 519.758
R5258 VSS.t496 VSS.t717 519.758
R5259 VSS.t498 VSS.t1683 519.758
R5260 VSS.t492 VSS.t1689 519.758
R5261 VSS.t1687 VSS.t1696 519.758
R5262 VSS.t1703 VSS.t1693 519.758
R5263 VSS.t1685 VSS.t1691 519.758
R5264 VSS.n865 VSS.n864 497.298
R5265 VSS.n3535 VSS.n3534 497.298
R5266 VSS.t569 VSS.n33 434.43
R5267 VSS.t603 VSS.n26 434.43
R5268 VSS.n3768 VSS.t591 434.43
R5269 VSS.n3767 VSS.t593 434.43
R5270 VSS.n58 VSS.t529 434.43
R5271 VSS.t533 VSS.n498 434.43
R5272 VSS.n509 VSS.t549 434.43
R5273 VSS.t170 VSS.n357 434.43
R5274 VSS.t172 VSS.n334 434.43
R5275 VSS.n375 VSS.t1675 434.43
R5276 VSS.t1671 VSS.n333 434.43
R5277 VSS.n3783 VSS.t631 434.43
R5278 VSS.n3782 VSS.t537 434.43
R5279 VSS.n21 VSS.t651 434.43
R5280 VSS.t525 VSS.n492 434.43
R5281 VSS.t583 VSS.n517 434.43
R5282 VSS.n516 VSS.t587 434.43
R5283 VSS.t611 VSS.n511 434.43
R5284 VSS.t20 VSS.n393 434.43
R5285 VSS.n893 VSS.t22 434.43
R5286 VSS.n892 VSS.t1361 434.43
R5287 VSS.t1365 VSS.n335 434.43
R5288 VSS.n2006 VSS.t599 434.43
R5289 VSS.n2005 VSS.t637 434.43
R5290 VSS.n1988 VSS.t589 434.43
R5291 VSS.t619 VSS.n1990 434.43
R5292 VSS.n3753 VSS.t555 434.43
R5293 VSS.n3752 VSS.t557 434.43
R5294 VSS.n66 VSS.t577 434.43
R5295 VSS.n2220 VSS.t435 434.43
R5296 VSS.n2219 VSS.t391 434.43
R5297 VSS.n2303 VSS.t433 434.43
R5298 VSS.n2302 VSS.t429 434.43
R5299 VSS.n1944 VSS.t389 434.43
R5300 VSS.t385 VSS.n2259 434.43
R5301 VSS.n2270 VSS.t339 434.43
R5302 VSS.n2065 VSS.t417 434.43
R5303 VSS.n2064 VSS.t363 434.43
R5304 VSS.n2029 VSS.t349 434.43
R5305 VSS.t333 VSS.n2031 434.43
R5306 VSS.n2037 VSS.t409 434.43
R5307 VSS.t359 VSS.n2039 434.43
R5308 VSS.n3734 VSS.t457 434.43
R5309 VSS.n3733 VSS.t1483 434.43
R5310 VSS.n82 VSS.t1467 434.43
R5311 VSS.t1493 VSS.n97 434.43
R5312 VSS.n3708 VSS.t1473 434.43
R5313 VSS.n3707 VSS.t1469 434.43
R5314 VSS.n115 VSS.t1455 434.43
R5315 VSS.t1451 VSS.n139 434.43
R5316 VSS.n3682 VSS.t1491 434.43
R5317 VSS.n3681 VSS.t1205 434.43
R5318 VSS.n157 VSS.t1213 434.43
R5319 VSS.t1217 VSS.n181 434.43
R5320 VSS.n3656 VSS.t1235 434.43
R5321 VSS.n3655 VSS.t1211 434.43
R5322 VSS.n199 VSS.t1187 434.43
R5323 VSS.t1177 VSS.n223 434.43
R5324 VSS.n3630 VSS.t1201 434.43
R5325 VSS.n3629 VSS.t1557 434.43
R5326 VSS.n241 VSS.t1555 434.43
R5327 VSS.t1545 VSS.n265 434.43
R5328 VSS.n3604 VSS.t1563 434.43
R5329 VSS.n3603 VSS.t1543 434.43
R5330 VSS.n277 VSS.t1539 434.43
R5331 VSS.t1533 VSS.n321 434.43
R5332 VSS.n332 VSS.t1549 434.43
R5333 VSS.t371 VSS.n1962 434.43
R5334 VSS.n1961 VSS.t395 434.43
R5335 VSS.t419 VSS.n1956 434.43
R5336 VSS.t343 VSS.n1947 434.43
R5337 VSS.n2288 VSS.t453 434.43
R5338 VSS.n2287 VSS.t401 434.43
R5339 VSS.n2252 VSS.t413 434.43
R5340 VSS.t1565 VSS.n292 434.43
R5341 VSS.n316 VSS.t1575 434.43
R5342 VSS.t1657 VSS.n293 434.43
R5343 VSS.n3563 VSS.t1663 434.43
R5344 VSS.n3585 VSS.t130 434.43
R5345 VSS.n296 VSS.t132 434.43
R5346 VSS.n2196 VSS.t425 434.43
R5347 VSS.n2195 VSS.t375 434.43
R5348 VSS.t357 VSS.n2190 434.43
R5349 VSS.n2189 VSS.t353 434.43
R5350 VSS.t447 VSS.n2184 434.43
R5351 VSS.t367 VSS.n1923 434.43
R5352 VSS.n1922 VSS.t403 434.43
R5353 VSS.n2163 VSS.t926 434.43
R5354 VSS.n2162 VSS.t962 434.43
R5355 VSS.n2145 VSS.t950 434.43
R5356 VSS.t952 VSS.n2147 434.43
R5357 VSS.n2341 VSS.t882 434.43
R5358 VSS.n2340 VSS.t884 434.43
R5359 VSS.n1536 VSS.t906 434.43
R5360 VSS.t1890 VSS.n1538 434.43
R5361 VSS.n1544 VSS.t1908 434.43
R5362 VSS.t1926 VSS.n1586 434.43
R5363 VSS.n1892 VSS.t1916 434.43
R5364 VSS.n1891 VSS.t1872 434.43
R5365 VSS.n1604 VSS.t1884 434.43
R5366 VSS.t1886 VSS.n1628 434.43
R5367 VSS.n1866 VSS.t1896 434.43
R5368 VSS.n1865 VSS.t1784 434.43
R5369 VSS.n1646 VSS.t1728 434.43
R5370 VSS.t1732 VSS.n1670 434.43
R5371 VSS.n1840 VSS.t1738 434.43
R5372 VSS.n1839 VSS.t1764 434.43
R5373 VSS.n1688 VSS.t1766 434.43
R5374 VSS.t1772 VSS.n1712 434.43
R5375 VSS.n1814 VSS.t1774 434.43
R5376 VSS.n1813 VSS.t303 434.43
R5377 VSS.n1730 VSS.t299 434.43
R5378 VSS.t327 VSS.n1732 434.43
R5379 VSS.n1738 VSS.t321 434.43
R5380 VSS.t325 VSS.n1740 434.43
R5381 VSS.n1743 VSS.t309 434.43
R5382 VSS.t317 VSS.n1745 434.43
R5383 VSS.t313 VSS.n914 434.43
R5384 VSS.n2496 VSS.t1056 434.43
R5385 VSS.n2495 VSS.t1008 434.43
R5386 VSS.t1048 VSS.n2490 434.43
R5387 VSS.n2489 VSS.t1032 434.43
R5388 VSS.t1128 VSS.n2484 434.43
R5389 VSS.t1122 VSS.n1404 434.43
R5390 VSS.n2587 VSS.t1120 434.43
R5391 VSS.t1086 VSS.n1424 434.43
R5392 VSS.t1040 VSS.n1417 434.43
R5393 VSS.n2562 VSS.t1074 434.43
R5394 VSS.n2561 VSS.t1062 434.43
R5395 VSS.t1028 VSS.n2556 434.43
R5396 VSS.t1018 VSS.n1391 434.43
R5397 VSS.n1390 VSS.t1016 434.43
R5398 VSS.n2122 VSS.t960 434.43
R5399 VSS.n2121 VSS.t868 434.43
R5400 VSS.n2356 VSS.t852 434.43
R5401 VSS.n2355 VSS.t854 434.43
R5402 VSS.n1523 VSS.t910 434.43
R5403 VSS.t916 VSS.n1553 434.43
R5404 VSS.t940 VSS.n1555 434.43
R5405 VSS.t930 VSS.n2371 434.43
R5406 VSS.t880 VSS.n2364 434.43
R5407 VSS.n2397 VSS.t914 434.43
R5408 VSS.n2396 VSS.t898 434.43
R5409 VSS.n2439 VSS.t874 434.43
R5410 VSS.n2438 VSS.t862 434.43
R5411 VSS.n1495 VSS.t860 434.43
R5412 VSS.n2098 VSS.t902 434.43
R5413 VSS.n2097 VSS.t864 434.43
R5414 VSS.t890 VSS.n2092 434.43
R5415 VSS.n2091 VSS.t878 434.43
R5416 VSS.t850 VSS.n2086 434.43
R5417 VSS.t968 VSS.n1502 434.43
R5418 VSS.n1501 VSS.t966 434.43
R5419 VSS.t64 VSS.n943 434.43
R5420 VSS.t66 VSS.n3521 434.43
R5421 VSS.n2463 VSS.t1024 434.43
R5422 VSS.n2462 VSS.t1106 434.43
R5423 VSS.n1451 VSS.t1012 434.43
R5424 VSS.t1132 VSS.n1453 434.43
R5425 VSS.n1459 VSS.t1098 434.43
R5426 VSS.t1090 VSS.n1461 434.43
R5427 VSS.n1467 VSS.t1082 434.43
R5428 VSS.t1329 VSS.n1469 434.43
R5429 VSS.t1317 VSS.n1473 434.43
R5430 VSS.t1301 VSS.n1370 434.43
R5431 VSS.n2978 VSS.t1309 434.43
R5432 VSS.n2977 VSS.t1349 434.43
R5433 VSS.n2661 VSS.t1353 434.43
R5434 VSS.t1357 VSS.n2778 434.43
R5435 VSS.n2946 VSS.t1299 434.43
R5436 VSS.n2945 VSS.t1842 434.43
R5437 VSS.n2796 VSS.t1846 434.43
R5438 VSS.t1850 VSS.n2828 434.43
R5439 VSS.t1808 VSS.n2829 434.43
R5440 VSS.t1806 VSS.n2822 434.43
R5441 VSS.n2903 VSS.t1832 434.43
R5442 VSS.n2902 VSS.t1800 434.43
R5443 VSS.n2857 VSS.t1828 434.43
R5444 VSS.t1509 VSS.n2859 434.43
R5445 VSS.t1527 VSS.n2863 434.43
R5446 VSS.t1513 VSS.n976 434.43
R5447 VSS.n3486 VSS.t1531 434.43
R5448 VSS.n3485 VSS.t1503 434.43
R5449 VSS.t1521 VSS.n3480 434.43
R5450 VSS.t1507 VSS.n956 434.43
R5451 VSS.n3512 VSS.t1517 434.43
R5452 VSS.n555 VSS.t609 434.43
R5453 VSS.t643 VSS.n556 434.43
R5454 VSS.n573 VSS.t625 434.43
R5455 VSS.n572 VSS.t629 434.43
R5456 VSS.t561 VSS.n567 434.43
R5457 VSS.t563 VSS.n540 434.43
R5458 VSS.n603 VSS.t581 434.43
R5459 VSS.n602 VSS.t1395 434.43
R5460 VSS.t1419 VSS.n597 434.43
R5461 VSS.t1413 VSS.n475 434.43
R5462 VSS.n654 VSS.t1383 434.43
R5463 VSS.n653 VSS.t1421 434.43
R5464 VSS.t1373 VSS.n648 434.43
R5465 VSS.t1397 VSS.n457 434.43
R5466 VSS.n704 VSS.t1435 434.43
R5467 VSS.n703 VSS.t1607 434.43
R5468 VSS.t1621 VSS.n698 434.43
R5469 VSS.t1649 VSS.n439 434.43
R5470 VSS.n754 VSS.t1601 434.43
R5471 VSS.n753 VSS.t1613 434.43
R5472 VSS.t1643 VSS.n748 434.43
R5473 VSS.t1635 VSS.n421 434.43
R5474 VSS.n804 VSS.t1599 434.43
R5475 VSS.n803 VSS.t1279 434.43
R5476 VSS.t1255 VSS.n798 434.43
R5477 VSS.t1271 VSS.n403 434.43
R5478 VSS.n851 VSS.t1285 434.43
R5479 VSS.n850 VSS.t1269 434.43
R5480 VSS.t1277 VSS.n845 434.43
R5481 VSS.t1265 VSS.n340 434.43
R5482 VSS.n907 VSS.t1261 434.43
R5483 VSS.t613 VSS.n32 426.264
R5484 VSS.n6 VSS.t545 426.264
R5485 VSS.n1973 VSS.t639 426.264
R5486 VSS.n2204 VSS.t335 426.264
R5487 VSS.n2014 VSS.t379 426.264
R5488 VSS.t443 VSS.n1955 426.264
R5489 VSS.n2171 VSS.t441 426.264
R5490 VSS.n2130 VSS.t970 426.264
R5491 VSS.n2471 VSS.t1116 426.264
R5492 VSS.t1014 VSS.n1423 426.264
R5493 VSS.n2106 VSS.t870 426.264
R5494 VSS.t858 VSS.n2370 426.264
R5495 VSS.n2073 VSS.t964 426.264
R5496 VSS.n1436 VSS.t1076 426.264
R5497 VSS.n549 VSS.t647 426.264
R5498 VSS.n3306 VSS.t792 424.318
R5499 VSS.n1041 VSS.t802 424.318
R5500 VSS.t802 VSS.n1039 424.318
R5501 VSS.t804 VSS.n1039 424.318
R5502 VSS.n3409 VSS.t804 424.318
R5503 VSS.n3408 VSS.t800 424.318
R5504 VSS.n1042 VSS.t800 424.318
R5505 VSS.t794 VSS.n1042 424.318
R5506 VSS.n3404 VSS.t794 424.318
R5507 VSS.n3403 VSS.t806 424.318
R5508 VSS.n1044 VSS.t806 424.318
R5509 VSS.t796 VSS.n1044 424.318
R5510 VSS.n3401 VSS.t796 424.318
R5511 VSS.n3400 VSS.t42 424.318
R5512 VSS.n1048 VSS.t42 424.318
R5513 VSS.t46 VSS.n1048 424.318
R5514 VSS.n3396 VSS.t46 424.318
R5515 VSS.n3395 VSS.t44 424.318
R5516 VSS.n1050 VSS.t44 424.318
R5517 VSS.t40 VSS.n1050 424.318
R5518 VSS.n1052 VSS.t40 424.318
R5519 VSS.n1084 VSS.t1173 424.318
R5520 VSS.t1173 VSS.n1076 424.318
R5521 VSS.n1076 VSS.t1171 424.318
R5522 VSS.n1086 VSS.t1171 424.318
R5523 VSS.t774 VSS.n3375 424.318
R5524 VSS.t768 VSS.n1185 424.318
R5525 VSS.n1189 VSS.t768 424.318
R5526 VSS.t770 VSS.n1189 424.318
R5527 VSS.n3369 VSS.t770 424.318
R5528 VSS.n3368 VSS.t782 424.318
R5529 VSS.n1191 VSS.t782 424.318
R5530 VSS.t776 VSS.n1191 424.318
R5531 VSS.n3364 VSS.t776 424.318
R5532 VSS.n3363 VSS.t772 424.318
R5533 VSS.n1193 VSS.t772 424.318
R5534 VSS.t778 VSS.n1193 424.318
R5535 VSS.n3361 VSS.t778 424.318
R5536 VSS.n3360 VSS.t465 424.318
R5537 VSS.n1197 VSS.t465 424.318
R5538 VSS.t459 VSS.n1197 424.318
R5539 VSS.n3356 VSS.t459 424.318
R5540 VSS.n3355 VSS.t461 424.318
R5541 VSS.n1199 VSS.t461 424.318
R5542 VSS.t463 VSS.n1199 424.318
R5543 VSS.n3353 VSS.t463 424.318
R5544 VSS.n3352 VSS.t293 424.318
R5545 VSS.n1203 VSS.t293 424.318
R5546 VSS.t295 VSS.n1203 424.318
R5547 VSS.n3348 VSS.t295 424.318
R5548 VSS.n3339 VSS.t267 424.318
R5549 VSS.n3338 VSS.t265 424.318
R5550 VSS.n1207 VSS.t265 424.318
R5551 VSS.t273 VSS.n1207 424.318
R5552 VSS.n3336 VSS.t273 424.318
R5553 VSS.n3335 VSS.t271 424.318
R5554 VSS.n1211 VSS.t271 424.318
R5555 VSS.t277 VSS.n1211 424.318
R5556 VSS.n3331 VSS.t277 424.318
R5557 VSS.n3330 VSS.t279 424.318
R5558 VSS.n1213 VSS.t279 424.318
R5559 VSS.t269 VSS.n1213 424.318
R5560 VSS.n3328 VSS.t269 424.318
R5561 VSS.n3327 VSS.t2 424.318
R5562 VSS.n1218 VSS.t2 424.318
R5563 VSS.t6 VSS.n1218 424.318
R5564 VSS.n3323 VSS.t6 424.318
R5565 VSS.n3322 VSS.t4 424.318
R5566 VSS.n1220 VSS.t4 424.318
R5567 VSS.t0 VSS.n1220 424.318
R5568 VSS.n3320 VSS.t0 424.318
R5569 VSS.n3319 VSS.t786 424.318
R5570 VSS.n3301 VSS.t786 424.318
R5571 VSS.t784 VSS.n3301 424.318
R5572 VSS.n3315 VSS.t784 424.318
R5573 VSS.n3377 VSS.n3376 419.454
R5574 VSS.n1088 VSS.n1087 419.454
R5575 VSS.n36 VSS.t613 418.094
R5576 VSS.n35 VSS.t641 418.094
R5577 VSS.t641 VSS.n34 418.094
R5578 VSS.n34 VSS.t569 418.094
R5579 VSS.n30 VSS.t603 418.094
R5580 VSS.n30 VSS.t633 418.094
R5581 VSS.n48 VSS.t633 418.094
R5582 VSS.n49 VSS.t547 418.094
R5583 VSS.t547 VSS.n25 418.094
R5584 VSS.t591 VSS.n25 418.094
R5585 VSS.t593 VSS.n3766 418.094
R5586 VSS.n3766 VSS.t565 418.094
R5587 VSS.t565 VSS.n3765 418.094
R5588 VSS.n3764 VSS.t595 418.094
R5589 VSS.n51 VSS.t595 418.094
R5590 VSS.t529 VSS.n51 418.094
R5591 VSS.n502 VSS.t533 418.094
R5592 VSS.n502 VSS.t585 418.094
R5593 VSS.n506 VSS.t585 418.094
R5594 VSS.n507 VSS.t615 418.094
R5595 VSS.t615 VSS.n493 418.094
R5596 VSS.n493 VSS.t549 418.094
R5597 VSS.n361 VSS.t170 418.094
R5598 VSS.n361 VSS.t174 418.094
R5599 VSS.n874 VSS.t174 418.094
R5600 VSS.n875 VSS.t168 418.094
R5601 VSS.t168 VSS.n356 418.094
R5602 VSS.n356 VSS.t172 418.094
R5603 VSS.t1675 VSS.n374 418.094
R5604 VSS.n374 VSS.t1673 418.094
R5605 VSS.t1673 VSS.n373 418.094
R5606 VSS.n372 VSS.t1669 418.094
R5607 VSS.n364 VSS.t1669 418.094
R5608 VSS.n364 VSS.t1671 418.094
R5609 VSS.n11 VSS.t545 418.094
R5610 VSS.n12 VSS.t571 418.094
R5611 VSS.t571 VSS.n5 418.094
R5612 VSS.t631 VSS.n5 418.094
R5613 VSS.t537 VSS.n3781 418.094
R5614 VSS.n3781 VSS.t559 418.094
R5615 VSS.t559 VSS.n3780 418.094
R5616 VSS.n3779 VSS.t607 418.094
R5617 VSS.n14 VSS.t607 418.094
R5618 VSS.t651 VSS.n14 418.094
R5619 VSS.n521 VSS.t525 418.094
R5620 VSS.n521 VSS.t627 418.094
R5621 VSS.t627 VSS.n520 418.094
R5622 VSS.n519 VSS.t531 418.094
R5623 VSS.t531 VSS.n518 418.094
R5624 VSS.n518 VSS.t583 418.094
R5625 VSS.t587 VSS.n515 418.094
R5626 VSS.n515 VSS.t649 418.094
R5627 VSS.t649 VSS.n514 418.094
R5628 VSS.n513 VSS.t551 418.094
R5629 VSS.t551 VSS.n512 418.094
R5630 VSS.n512 VSS.t611 418.094
R5631 VSS.n398 VSS.t20 418.094
R5632 VSS.n398 VSS.t12 418.094
R5633 VSS.t12 VSS.n397 418.094
R5634 VSS.n349 VSS.t18 418.094
R5635 VSS.t18 VSS.n348 418.094
R5636 VSS.t22 VSS.n348 418.094
R5637 VSS.t1361 VSS.n891 418.094
R5638 VSS.n891 VSS.t1363 418.094
R5639 VSS.t1363 VSS.n890 418.094
R5640 VSS.n889 VSS.t1367 418.094
R5641 VSS.n351 VSS.t1367 418.094
R5642 VSS.n351 VSS.t1365 418.094
R5643 VSS.n1978 VSS.t639 418.094
R5644 VSS.n1979 VSS.t543 418.094
R5645 VSS.t543 VSS.n1972 418.094
R5646 VSS.t599 VSS.n1972 418.094
R5647 VSS.t637 VSS.n2004 418.094
R5648 VSS.n2004 VSS.t535 418.094
R5649 VSS.t535 VSS.n2003 418.094
R5650 VSS.n2002 VSS.t573 418.094
R5651 VSS.n1981 VSS.t573 418.094
R5652 VSS.t589 VSS.n1981 418.094
R5653 VSS.n1995 VSS.t619 418.094
R5654 VSS.n1995 VSS.t597 418.094
R5655 VSS.t597 VSS.n1994 418.094
R5656 VSS.n63 VSS.t621 418.094
R5657 VSS.t621 VSS.n62 418.094
R5658 VSS.t555 VSS.n62 418.094
R5659 VSS.t557 VSS.n3751 418.094
R5660 VSS.n3751 VSS.t617 418.094
R5661 VSS.t617 VSS.n3750 418.094
R5662 VSS.n3749 VSS.t645 418.094
R5663 VSS.n65 VSS.t645 418.094
R5664 VSS.t577 VSS.n65 418.094
R5665 VSS.n2209 VSS.t335 418.094
R5666 VSS.n2210 VSS.t437 418.094
R5667 VSS.t437 VSS.n2203 418.094
R5668 VSS.t435 VSS.n2203 418.094
R5669 VSS.t391 VSS.n2218 418.094
R5670 VSS.n2218 VSS.t393 418.094
R5671 VSS.t393 VSS.n2217 418.094
R5672 VSS.n1935 VSS.t431 418.094
R5673 VSS.t431 VSS.n1934 418.094
R5674 VSS.t433 VSS.n1934 418.094
R5675 VSS.t429 VSS.n2301 418.094
R5676 VSS.n2301 VSS.t427 418.094
R5677 VSS.t427 VSS.n2300 418.094
R5678 VSS.n2299 VSS.t387 418.094
R5679 VSS.n1937 VSS.t387 418.094
R5680 VSS.t389 VSS.n1937 418.094
R5681 VSS.n2263 VSS.t385 418.094
R5682 VSS.n2263 VSS.t383 418.094
R5683 VSS.n2267 VSS.t383 418.094
R5684 VSS.n2268 VSS.t341 418.094
R5685 VSS.t341 VSS.n2254 418.094
R5686 VSS.n2254 VSS.t339 418.094
R5687 VSS.n2019 VSS.t379 418.094
R5688 VSS.n2020 VSS.t415 418.094
R5689 VSS.t415 VSS.n2013 418.094
R5690 VSS.t417 VSS.n2013 418.094
R5691 VSS.t363 VSS.n2063 418.094
R5692 VSS.n2063 VSS.t365 418.094
R5693 VSS.t365 VSS.n2062 418.094
R5694 VSS.n2061 VSS.t347 418.094
R5695 VSS.n2022 VSS.t347 418.094
R5696 VSS.t349 VSS.n2022 418.094
R5697 VSS.n2053 VSS.t333 418.094
R5698 VSS.n2053 VSS.t331 418.094
R5699 VSS.t331 VSS.n2052 418.094
R5700 VSS.n2051 VSS.t407 418.094
R5701 VSS.n2033 VSS.t407 418.094
R5702 VSS.t409 VSS.n2033 418.094
R5703 VSS.n2044 VSS.t359 418.094
R5704 VSS.n2044 VSS.t361 418.094
R5705 VSS.t361 VSS.n2043 418.094
R5706 VSS.n73 VSS.t455 418.094
R5707 VSS.t455 VSS.n72 418.094
R5708 VSS.t457 VSS.n72 418.094
R5709 VSS.t1483 VSS.n3732 418.094
R5710 VSS.n3732 VSS.t1481 418.094
R5711 VSS.t1481 VSS.n3731 418.094
R5712 VSS.n3730 VSS.t1465 418.094
R5713 VSS.n75 VSS.t1465 418.094
R5714 VSS.t1467 VSS.n75 418.094
R5715 VSS.n101 VSS.t1493 418.094
R5716 VSS.n101 VSS.t1495 418.094
R5717 VSS.n105 VSS.t1495 418.094
R5718 VSS.n106 VSS.t1475 418.094
R5719 VSS.t1475 VSS.n96 418.094
R5720 VSS.t1473 VSS.n96 418.094
R5721 VSS.t1469 VSS.n3706 418.094
R5722 VSS.n3706 VSS.t1471 418.094
R5723 VSS.t1471 VSS.n3705 418.094
R5724 VSS.n3704 VSS.t1453 418.094
R5725 VSS.n108 VSS.t1453 418.094
R5726 VSS.t1455 VSS.n108 418.094
R5727 VSS.n143 VSS.t1451 418.094
R5728 VSS.n143 VSS.t1449 418.094
R5729 VSS.n147 VSS.t1449 418.094
R5730 VSS.n148 VSS.t1489 418.094
R5731 VSS.t1489 VSS.n138 418.094
R5732 VSS.t1491 VSS.n138 418.094
R5733 VSS.t1205 VSS.n3680 418.094
R5734 VSS.n3680 VSS.t1207 418.094
R5735 VSS.t1207 VSS.n3679 418.094
R5736 VSS.n3678 VSS.t1215 418.094
R5737 VSS.n150 VSS.t1215 418.094
R5738 VSS.t1213 VSS.n150 418.094
R5739 VSS.n185 VSS.t1217 418.094
R5740 VSS.n185 VSS.t1219 418.094
R5741 VSS.n189 VSS.t1219 418.094
R5742 VSS.n190 VSS.t1233 418.094
R5743 VSS.t1233 VSS.n180 418.094
R5744 VSS.t1235 VSS.n180 418.094
R5745 VSS.t1211 VSS.n3654 418.094
R5746 VSS.n3654 VSS.t1209 418.094
R5747 VSS.t1209 VSS.n3653 418.094
R5748 VSS.n3652 VSS.t1185 418.094
R5749 VSS.n192 VSS.t1185 418.094
R5750 VSS.t1187 VSS.n192 418.094
R5751 VSS.n227 VSS.t1177 418.094
R5752 VSS.n227 VSS.t1179 418.094
R5753 VSS.n231 VSS.t1179 418.094
R5754 VSS.n232 VSS.t1203 418.094
R5755 VSS.t1203 VSS.n222 418.094
R5756 VSS.t1201 VSS.n222 418.094
R5757 VSS.t1557 VSS.n3628 418.094
R5758 VSS.n3628 VSS.t1559 418.094
R5759 VSS.t1559 VSS.n3627 418.094
R5760 VSS.n3626 VSS.t1553 418.094
R5761 VSS.n234 VSS.t1553 418.094
R5762 VSS.t1555 VSS.n234 418.094
R5763 VSS.n269 VSS.t1545 418.094
R5764 VSS.n269 VSS.t1547 418.094
R5765 VSS.n273 VSS.t1547 418.094
R5766 VSS.n274 VSS.t1561 418.094
R5767 VSS.t1561 VSS.n264 418.094
R5768 VSS.t1563 VSS.n264 418.094
R5769 VSS.t1543 VSS.n3602 418.094
R5770 VSS.n3602 VSS.t1541 418.094
R5771 VSS.t1541 VSS.n3601 418.094
R5772 VSS.n3600 VSS.t1537 418.094
R5773 VSS.n276 VSS.t1537 418.094
R5774 VSS.t1539 VSS.n276 418.094
R5775 VSS.n325 VSS.t1533 418.094
R5776 VSS.n325 VSS.t1535 418.094
R5777 VSS.n329 VSS.t1535 418.094
R5778 VSS.n330 VSS.t1551 418.094
R5779 VSS.t1551 VSS.n317 418.094
R5780 VSS.n317 VSS.t1549 418.094
R5781 VSS.n1965 VSS.t443 418.094
R5782 VSS.n1964 VSS.t373 418.094
R5783 VSS.t373 VSS.n1963 418.094
R5784 VSS.n1963 VSS.t371 418.094
R5785 VSS.t395 VSS.n1960 418.094
R5786 VSS.n1960 VSS.t397 418.094
R5787 VSS.t397 VSS.n1959 418.094
R5788 VSS.n1958 VSS.t421 418.094
R5789 VSS.t421 VSS.n1957 418.094
R5790 VSS.n1957 VSS.t419 418.094
R5791 VSS.n1951 VSS.t343 418.094
R5792 VSS.n1951 VSS.t345 418.094
R5793 VSS.n2242 VSS.t345 418.094
R5794 VSS.n2243 VSS.t451 418.094
R5795 VSS.t451 VSS.n1946 418.094
R5796 VSS.t453 VSS.n1946 418.094
R5797 VSS.t401 VSS.n2286 418.094
R5798 VSS.n2286 VSS.t399 418.094
R5799 VSS.t399 VSS.n2285 418.094
R5800 VSS.n2284 VSS.t411 418.094
R5801 VSS.n2245 VSS.t411 418.094
R5802 VSS.t413 VSS.n2245 418.094
R5803 VSS.n309 VSS.t1565 418.094
R5804 VSS.n309 VSS.t1567 418.094
R5805 VSS.n313 VSS.t1567 418.094
R5806 VSS.n314 VSS.t1573 418.094
R5807 VSS.t1573 VSS.n302 418.094
R5808 VSS.n302 VSS.t1575 418.094
R5809 VSS.n3567 VSS.t1657 418.094
R5810 VSS.n3567 VSS.t1659 418.094
R5811 VSS.n3569 VSS.t1659 418.094
R5812 VSS.n3570 VSS.t1661 418.094
R5813 VSS.t1661 VSS.n301 418.094
R5814 VSS.t1663 VSS.n301 418.094
R5815 VSS.t130 VSS.n3584 418.094
R5816 VSS.n3584 VSS.t134 418.094
R5817 VSS.t134 VSS.n3583 418.094
R5818 VSS.n3582 VSS.t128 418.094
R5819 VSS.n295 VSS.t128 418.094
R5820 VSS.t132 VSS.n295 418.094
R5821 VSS.n2176 VSS.t441 418.094
R5822 VSS.n2177 VSS.t423 418.094
R5823 VSS.t423 VSS.n2170 418.094
R5824 VSS.t425 VSS.n2170 418.094
R5825 VSS.t375 VSS.n2194 418.094
R5826 VSS.n2194 VSS.t377 418.094
R5827 VSS.t377 VSS.n2193 418.094
R5828 VSS.n2192 VSS.t355 418.094
R5829 VSS.t355 VSS.n2191 418.094
R5830 VSS.n2191 VSS.t357 418.094
R5831 VSS.t353 VSS.n2188 418.094
R5832 VSS.n2188 VSS.t351 418.094
R5833 VSS.t351 VSS.n2187 418.094
R5834 VSS.n2186 VSS.t449 418.094
R5835 VSS.t449 VSS.n2185 418.094
R5836 VSS.n2185 VSS.t447 418.094
R5837 VSS.n1927 VSS.t367 418.094
R5838 VSS.n1927 VSS.t369 418.094
R5839 VSS.n2325 VSS.t369 418.094
R5840 VSS.n2326 VSS.t405 418.094
R5841 VSS.t405 VSS.n1921 418.094
R5842 VSS.t403 VSS.n1921 418.094
R5843 VSS.n2135 VSS.t970 418.094
R5844 VSS.n2136 VSS.t872 418.094
R5845 VSS.t872 VSS.n2129 418.094
R5846 VSS.t926 VSS.n2129 418.094
R5847 VSS.t962 VSS.n2161 418.094
R5848 VSS.n2161 VSS.t866 418.094
R5849 VSS.t866 VSS.n2160 418.094
R5850 VSS.n2159 VSS.t896 418.094
R5851 VSS.n2138 VSS.t896 418.094
R5852 VSS.t950 VSS.n2138 418.094
R5853 VSS.n2152 VSS.t952 418.094
R5854 VSS.n2152 VSS.t922 418.094
R5855 VSS.t922 VSS.n2151 418.094
R5856 VSS.n1527 VSS.t954 418.094
R5857 VSS.t954 VSS.n1526 418.094
R5858 VSS.t882 VSS.n1526 418.094
R5859 VSS.t884 VSS.n2339 418.094
R5860 VSS.n2339 VSS.t946 418.094
R5861 VSS.t946 VSS.n2338 418.094
R5862 VSS.n2337 VSS.t846 418.094
R5863 VSS.n1529 VSS.t846 418.094
R5864 VSS.t906 VSS.n1529 418.094
R5865 VSS.n1916 VSS.t1890 418.094
R5866 VSS.n1916 VSS.t1878 418.094
R5867 VSS.t1878 VSS.n1915 418.094
R5868 VSS.n1914 VSS.t1892 418.094
R5869 VSS.n1540 VSS.t1892 418.094
R5870 VSS.t1908 VSS.n1540 418.094
R5871 VSS.n1590 VSS.t1926 418.094
R5872 VSS.n1590 VSS.t1874 418.094
R5873 VSS.n1594 VSS.t1874 418.094
R5874 VSS.n1595 VSS.t1902 418.094
R5875 VSS.t1902 VSS.n1585 418.094
R5876 VSS.t1916 VSS.n1585 418.094
R5877 VSS.t1872 VSS.n1890 418.094
R5878 VSS.n1890 VSS.t1904 418.094
R5879 VSS.t1904 VSS.n1889 418.094
R5880 VSS.n1888 VSS.t1920 418.094
R5881 VSS.n1597 VSS.t1920 418.094
R5882 VSS.t1884 VSS.n1597 418.094
R5883 VSS.n1632 VSS.t1886 418.094
R5884 VSS.n1632 VSS.t1914 418.094
R5885 VSS.n1636 VSS.t1914 418.094
R5886 VSS.n1637 VSS.t1864 418.094
R5887 VSS.t1864 VSS.n1627 418.094
R5888 VSS.t1896 VSS.n1627 418.094
R5889 VSS.t1784 VSS.n1864 418.094
R5890 VSS.n1864 VSS.t1742 418.094
R5891 VSS.t1742 VSS.n1863 418.094
R5892 VSS.n1862 VSS.t1758 418.094
R5893 VSS.n1639 VSS.t1758 418.094
R5894 VSS.t1728 VSS.n1639 418.094
R5895 VSS.n1674 VSS.t1732 418.094
R5896 VSS.n1674 VSS.t1762 418.094
R5897 VSS.n1678 VSS.t1762 418.094
R5898 VSS.n1679 VSS.t1786 418.094
R5899 VSS.t1786 VSS.n1669 418.094
R5900 VSS.t1738 VSS.n1669 418.094
R5901 VSS.t1764 VSS.n1838 418.094
R5902 VSS.n1838 VSS.t1778 418.094
R5903 VSS.t1778 VSS.n1837 418.094
R5904 VSS.n1836 VSS.t1754 418.094
R5905 VSS.n1681 VSS.t1754 418.094
R5906 VSS.t1766 VSS.n1681 418.094
R5907 VSS.n1716 VSS.t1772 418.094
R5908 VSS.n1716 VSS.t1724 418.094
R5909 VSS.n1720 VSS.t1724 418.094
R5910 VSS.n1721 VSS.t1750 418.094
R5911 VSS.t1750 VSS.n1711 418.094
R5912 VSS.t1774 VSS.n1711 418.094
R5913 VSS.t303 VSS.n1812 418.094
R5914 VSS.n1812 VSS.t305 418.094
R5915 VSS.t305 VSS.n1811 418.094
R5916 VSS.n1810 VSS.t301 418.094
R5917 VSS.n1723 VSS.t301 418.094
R5918 VSS.t299 VSS.n1723 418.094
R5919 VSS.n1777 VSS.t327 418.094
R5920 VSS.n1777 VSS.t329 418.094
R5921 VSS.t329 VSS.n1776 418.094
R5922 VSS.n1775 VSS.t319 418.094
R5923 VSS.n1734 VSS.t319 418.094
R5924 VSS.t321 VSS.n1734 418.094
R5925 VSS.n1767 VSS.t325 418.094
R5926 VSS.n1767 VSS.t323 418.094
R5927 VSS.t323 VSS.n1766 418.094
R5928 VSS.n1765 VSS.t307 418.094
R5929 VSS.n1742 VSS.t307 418.094
R5930 VSS.t309 VSS.n1742 418.094
R5931 VSS.n1756 VSS.t317 418.094
R5932 VSS.n1756 VSS.t315 418.094
R5933 VSS.t315 VSS.n1755 418.094
R5934 VSS.n1754 VSS.t311 418.094
R5935 VSS.n1747 VSS.t311 418.094
R5936 VSS.n1747 VSS.t313 418.094
R5937 VSS.n2476 VSS.t1116 418.094
R5938 VSS.n2477 VSS.t1078 418.094
R5939 VSS.t1078 VSS.n2470 418.094
R5940 VSS.t1056 VSS.n2470 418.094
R5941 VSS.t1008 VSS.n2494 418.094
R5942 VSS.n2494 VSS.t1100 418.094
R5943 VSS.t1100 VSS.n2493 418.094
R5944 VSS.n2492 VSS.t1072 418.094
R5945 VSS.t1072 VSS.n2491 418.094
R5946 VSS.n2491 VSS.t1048 418.094
R5947 VSS.t1032 VSS.n2488 418.094
R5948 VSS.n2488 VSS.t1054 418.094
R5949 VSS.t1054 VSS.n2487 418.094
R5950 VSS.n2486 VSS.t1068 418.094
R5951 VSS.t1068 VSS.n2485 418.094
R5952 VSS.n2485 VSS.t1128 418.094
R5953 VSS.n1408 VSS.t1122 418.094
R5954 VSS.n1408 VSS.t1044 418.094
R5955 VSS.n2584 VSS.t1044 418.094
R5956 VSS.t1060 VSS.n2585 418.094
R5957 VSS.n2586 VSS.t1060 418.094
R5958 VSS.t1120 VSS.n2586 418.094
R5959 VSS.n1427 VSS.t1014 418.094
R5960 VSS.n1426 VSS.t1118 418.094
R5961 VSS.t1118 VSS.n1425 418.094
R5962 VSS.n1425 VSS.t1086 418.094
R5963 VSS.n1421 VSS.t1040 418.094
R5964 VSS.n1421 VSS.t1130 418.094
R5965 VSS.n2548 VSS.t1130 418.094
R5966 VSS.n2549 VSS.t1104 418.094
R5967 VSS.t1104 VSS.n1416 418.094
R5968 VSS.t1074 VSS.n1416 418.094
R5969 VSS.t1062 VSS.n2560 418.094
R5970 VSS.n2560 VSS.t1084 418.094
R5971 VSS.t1084 VSS.n2559 418.094
R5972 VSS.n2558 VSS.t1102 418.094
R5973 VSS.t1102 VSS.n2557 418.094
R5974 VSS.n2557 VSS.t1028 418.094
R5975 VSS.n1395 VSS.t1018 418.094
R5976 VSS.n1395 VSS.t1070 418.094
R5977 VSS.n2615 VSS.t1070 418.094
R5978 VSS.n2616 VSS.t1092 418.094
R5979 VSS.t1092 VSS.n1389 418.094
R5980 VSS.t1016 VSS.n1389 418.094
R5981 VSS.n2998 VSS.t1287 418.094
R5982 VSS.n3000 VSS.t1287 418.094
R5983 VSS.n3001 VSS.t50 418.094
R5984 VSS.t50 VSS.n1358 418.094
R5985 VSS.t48 VSS.n1358 418.094
R5986 VSS.n3009 VSS.t48 418.094
R5987 VSS.n3008 VSS.t1295 418.094
R5988 VSS.n3002 VSS.t1295 418.094
R5989 VSS.t1291 VSS.n3002 418.094
R5990 VSS.n3005 VSS.t1291 418.094
R5991 VSS.n1338 VSS.t1289 418.094
R5992 VSS.t1289 VSS.n1336 418.094
R5993 VSS.n1336 VSS.t1293 418.094
R5994 VSS.n3039 VSS.t1293 418.094
R5995 VSS.n3040 VSS.t1589 418.094
R5996 VSS.t1589 VSS.n1332 418.094
R5997 VSS.n1332 VSS.t1583 418.094
R5998 VSS.n3042 VSS.t1583 418.094
R5999 VSS.n3043 VSS.t1579 418.094
R6000 VSS.t1579 VSS.n1330 418.094
R6001 VSS.t1591 VSS.n1330 418.094
R6002 VSS.n3063 VSS.t1591 418.094
R6003 VSS.n3062 VSS.t1585 418.094
R6004 VSS.n3044 VSS.t1585 418.094
R6005 VSS.t1577 VSS.n3044 418.094
R6006 VSS.n3059 VSS.t1577 418.094
R6007 VSS.n3058 VSS.t1581 418.094
R6008 VSS.n3046 VSS.t1581 418.094
R6009 VSS.t1587 VSS.n3046 418.094
R6010 VSS.n3054 VSS.t1587 418.094
R6011 VSS.n3053 VSS.t1253 418.094
R6012 VSS.n3048 VSS.t1253 418.094
R6013 VSS.n1304 VSS.t160 418.094
R6014 VSS.t160 VSS.n1302 418.094
R6015 VSS.n1302 VSS.t162 418.094
R6016 VSS.n3099 VSS.t162 418.094
R6017 VSS.n3100 VSS.t106 418.094
R6018 VSS.t106 VSS.n1298 418.094
R6019 VSS.n1298 VSS.t100 418.094
R6020 VSS.n3102 VSS.t100 418.094
R6021 VSS.n3103 VSS.t102 418.094
R6022 VSS.t102 VSS.n1296 418.094
R6023 VSS.t104 VSS.n1296 418.094
R6024 VSS.n3111 VSS.t104 418.094
R6025 VSS.n3110 VSS.t984 418.094
R6026 VSS.n3104 VSS.t984 418.094
R6027 VSS.t974 VSS.n3104 418.094
R6028 VSS.n3107 VSS.t974 418.094
R6029 VSS.n1227 VSS.t986 418.094
R6030 VSS.t986 VSS.n1225 418.094
R6031 VSS.t978 VSS.n1225 418.094
R6032 VSS.n3288 VSS.t978 418.094
R6033 VSS.n3287 VSS.t976 418.094
R6034 VSS.n1228 VSS.t976 418.094
R6035 VSS.t982 VSS.n1228 418.094
R6036 VSS.n3284 VSS.t982 418.094
R6037 VSS.n3283 VSS.t988 418.094
R6038 VSS.n1230 VSS.t988 418.094
R6039 VSS.t980 VSS.n1230 418.094
R6040 VSS.n3279 VSS.t980 418.094
R6041 VSS.n3278 VSS.t297 418.094
R6042 VSS.n1232 VSS.t297 418.094
R6043 VSS.n1234 VSS.t283 418.094
R6044 VSS.t283 VSS.n1233 418.094
R6045 VSS.t281 VSS.n1233 418.094
R6046 VSS.n3271 VSS.t281 418.094
R6047 VSS.n3270 VSS.t154 418.094
R6048 VSS.n1236 VSS.t154 418.094
R6049 VSS.t158 VSS.n1236 418.094
R6050 VSS.n3267 VSS.t158 418.094
R6051 VSS.n3266 VSS.t156 418.094
R6052 VSS.n1238 VSS.t156 418.094
R6053 VSS.t152 VSS.n1238 418.094
R6054 VSS.n3264 VSS.t152 418.094
R6055 VSS.n3263 VSS.t196 418.094
R6056 VSS.n1242 VSS.t196 418.094
R6057 VSS.t204 VSS.n1242 418.094
R6058 VSS.n3260 VSS.t204 418.094
R6059 VSS.n3259 VSS.t198 418.094
R6060 VSS.n1244 VSS.t198 418.094
R6061 VSS.t192 VSS.n1244 418.094
R6062 VSS.n3254 VSS.t192 418.094
R6063 VSS.n3253 VSS.t206 418.094
R6064 VSS.n1246 VSS.t206 418.094
R6065 VSS.t202 VSS.n1246 418.094
R6066 VSS.n3250 VSS.t202 418.094
R6067 VSS.n3249 VSS.t200 418.094
R6068 VSS.n1248 VSS.t200 418.094
R6069 VSS.t194 VSS.n1248 418.094
R6070 VSS.n3245 VSS.t194 418.094
R6071 VSS.n3459 VSS.t1860 418.094
R6072 VSS.n987 VSS.t1860 418.094
R6073 VSS.t1862 VSS.n987 418.094
R6074 VSS.n1009 VSS.t1862 418.094
R6075 VSS.n1008 VSS.t1241 418.094
R6076 VSS.n989 VSS.t1241 418.094
R6077 VSS.t1247 VSS.n989 418.094
R6078 VSS.n1004 VSS.t1247 418.094
R6079 VSS.n1015 VSS.t1369 418.094
R6080 VSS.t1369 VSS.n1013 418.094
R6081 VSS.n1013 VSS.t1371 418.094
R6082 VSS.n3452 VSS.t1371 418.094
R6083 VSS.n3453 VSS.t1569 418.094
R6084 VSS.t1569 VSS.n1010 418.094
R6085 VSS.t1571 VSS.n1010 418.094
R6086 VSS.n1011 VSS.t1571 418.094
R6087 VSS.n2963 VSS.t1665 418.094
R6088 VSS.n2674 VSS.t1665 418.094
R6089 VSS.t1667 VSS.n2674 418.094
R6090 VSS.n2961 VSS.t1667 418.094
R6091 VSS.n2960 VSS.t1677 418.094
R6092 VSS.n2761 VSS.t1677 418.094
R6093 VSS.t1679 VSS.n2761 418.094
R6094 VSS.n2956 VSS.t1679 418.094
R6095 VSS.t1720 VSS.n1364 418.094
R6096 VSS.n2691 VSS.t1720 418.094
R6097 VSS.n2692 VSS.t1002 418.094
R6098 VSS.t1002 VSS.n2685 418.094
R6099 VSS.n2685 VSS.t1004 418.094
R6100 VSS.n2698 VSS.t1004 418.094
R6101 VSS.n2699 VSS.t126 418.094
R6102 VSS.t126 VSS.n2681 418.094
R6103 VSS.n2681 VSS.t124 418.094
R6104 VSS.n2701 VSS.t124 418.094
R6105 VSS.n2702 VSS.t122 418.094
R6106 VSS.t122 VSS.n2679 418.094
R6107 VSS.t120 VSS.n2679 418.094
R6108 VSS.n2754 VSS.t120 418.094
R6109 VSS.n2753 VSS.t655 418.094
R6110 VSS.n2703 VSS.t655 418.094
R6111 VSS.t657 VSS.n2703 418.094
R6112 VSS.n2750 VSS.t657 418.094
R6113 VSS.n2749 VSS.t659 418.094
R6114 VSS.n2705 VSS.t659 418.094
R6115 VSS.t665 VSS.n2705 418.094
R6116 VSS.n2747 VSS.t665 418.094
R6117 VSS.n2746 VSS.t663 418.094
R6118 VSS.n2712 VSS.t663 418.094
R6119 VSS.t653 VSS.n2712 418.094
R6120 VSS.n2743 VSS.t653 418.094
R6121 VSS.n2742 VSS.t661 418.094
R6122 VSS.n2714 VSS.t661 418.094
R6123 VSS.t667 VSS.n2714 418.094
R6124 VSS.n2738 VSS.t667 418.094
R6125 VSS.n2737 VSS.t1954 418.094
R6126 VSS.n2716 VSS.t1954 418.094
R6127 VSS.n2718 VSS.t164 418.094
R6128 VSS.t164 VSS.n2717 418.094
R6129 VSS.t166 VSS.n2717 418.094
R6130 VSS.n2730 VSS.t166 418.094
R6131 VSS.n2729 VSS.t118 418.094
R6132 VSS.n2720 VSS.t118 418.094
R6133 VSS.t112 VSS.n2720 418.094
R6134 VSS.n2723 VSS.t112 418.094
R6135 VSS.n1020 VSS.t114 418.094
R6136 VSS.t114 VSS.n1018 418.094
R6137 VSS.t116 VSS.n1018 418.094
R6138 VSS.n3442 VSS.t116 418.094
R6139 VSS.n3441 VSS.t677 418.094
R6140 VSS.n1021 VSS.t677 418.094
R6141 VSS.t669 VSS.n1021 418.094
R6142 VSS.n3438 VSS.t669 418.094
R6143 VSS.n3437 VSS.t681 418.094
R6144 VSS.n1023 VSS.t681 418.094
R6145 VSS.t671 VSS.n1023 418.094
R6146 VSS.n3435 VSS.t671 418.094
R6147 VSS.n3434 VSS.t675 418.094
R6148 VSS.n1027 VSS.t675 418.094
R6149 VSS.t679 VSS.n1027 418.094
R6150 VSS.n3431 VSS.t679 418.094
R6151 VSS.n3430 VSS.t683 418.094
R6152 VSS.n1029 VSS.t683 418.094
R6153 VSS.t673 VSS.n1029 418.094
R6154 VSS.n3426 VSS.t673 418.094
R6155 VSS.n3425 VSS.t1142 418.094
R6156 VSS.n1031 VSS.t1142 418.094
R6157 VSS.n1033 VSS.t511 418.094
R6158 VSS.t511 VSS.n1032 418.094
R6159 VSS.t509 VSS.n1032 418.094
R6160 VSS.n3418 VSS.t509 418.094
R6161 VSS.n3417 VSS.t736 418.094
R6162 VSS.n1035 VSS.t736 418.094
R6163 VSS.t732 VSS.n1035 418.094
R6164 VSS.n1037 VSS.t732 418.094
R6165 VSS.n3154 VSS.t738 418.094
R6166 VSS.t738 VSS.n3151 418.094
R6167 VSS.t734 VSS.n3151 418.094
R6168 VSS.n3181 VSS.t734 418.094
R6169 VSS.n3180 VSS.t72 418.094
R6170 VSS.n3155 VSS.t72 418.094
R6171 VSS.t80 VSS.n3155 418.094
R6172 VSS.n3177 VSS.t80 418.094
R6173 VSS.n3176 VSS.t78 418.094
R6174 VSS.n3157 VSS.t78 418.094
R6175 VSS.t68 VSS.n3157 418.094
R6176 VSS.n3172 VSS.t68 418.094
R6177 VSS.n3171 VSS.t82 418.094
R6178 VSS.n3159 VSS.t82 418.094
R6179 VSS.t76 VSS.n3159 418.094
R6180 VSS.n3168 VSS.t76 418.094
R6181 VSS.n3167 VSS.t74 418.094
R6182 VSS.n3161 VSS.t74 418.094
R6183 VSS.t70 VSS.n3161 418.094
R6184 VSS.n3163 VSS.t70 418.094
R6185 VSS.n2111 VSS.t870 418.094
R6186 VSS.n2112 VSS.t894 418.094
R6187 VSS.t894 VSS.n2105 418.094
R6188 VSS.t960 VSS.n2105 418.094
R6189 VSS.t868 VSS.n2120 418.094
R6190 VSS.n2120 VSS.t886 418.094
R6191 VSS.t886 VSS.n2119 418.094
R6192 VSS.n1514 VSS.t936 418.094
R6193 VSS.t936 VSS.n1513 418.094
R6194 VSS.t852 VSS.n1513 418.094
R6195 VSS.t854 VSS.n2354 418.094
R6196 VSS.n2354 VSS.t956 418.094
R6197 VSS.t956 VSS.n2353 418.094
R6198 VSS.n2352 VSS.t856 418.094
R6199 VSS.n1516 VSS.t856 418.094
R6200 VSS.t910 VSS.n1516 418.094
R6201 VSS.n1559 VSS.t916 418.094
R6202 VSS.n1559 VSS.t848 418.094
R6203 VSS.t848 VSS.n1558 418.094
R6204 VSS.n1557 VSS.t876 418.094
R6205 VSS.t876 VSS.n1556 418.094
R6206 VSS.n1556 VSS.t940 418.094
R6207 VSS.n2374 VSS.t858 418.094
R6208 VSS.n2373 VSS.t958 418.094
R6209 VSS.t958 VSS.n2372 418.094
R6210 VSS.n2372 VSS.t930 418.094
R6211 VSS.n2368 VSS.t880 418.094
R6212 VSS.n2368 VSS.t972 418.094
R6213 VSS.n2386 VSS.t972 418.094
R6214 VSS.n2387 VSS.t944 418.094
R6215 VSS.t944 VSS.n2363 418.094
R6216 VSS.t914 VSS.n2363 418.094
R6217 VSS.t898 VSS.n2395 418.094
R6218 VSS.n2395 VSS.t928 418.094
R6219 VSS.t928 VSS.n2394 418.094
R6220 VSS.n1492 VSS.t942 418.094
R6221 VSS.t942 VSS.n1491 418.094
R6222 VSS.t874 VSS.n1491 418.094
R6223 VSS.t862 VSS.n2437 418.094
R6224 VSS.n2437 VSS.t912 418.094
R6225 VSS.t912 VSS.n2436 418.094
R6226 VSS.n2435 VSS.t934 418.094
R6227 VSS.n1494 VSS.t934 418.094
R6228 VSS.t860 VSS.n1494 418.094
R6229 VSS.n2078 VSS.t964 418.094
R6230 VSS.n2079 VSS.t938 418.094
R6231 VSS.t938 VSS.n2072 418.094
R6232 VSS.t902 VSS.n2072 418.094
R6233 VSS.t864 VSS.n2096 418.094
R6234 VSS.n2096 VSS.t948 418.094
R6235 VSS.t948 VSS.n2095 418.094
R6236 VSS.n2094 VSS.t920 418.094
R6237 VSS.t920 VSS.n2093 418.094
R6238 VSS.n2093 VSS.t890 418.094
R6239 VSS.t878 VSS.n2090 418.094
R6240 VSS.n2090 VSS.t900 418.094
R6241 VSS.t900 VSS.n2089 418.094
R6242 VSS.n2088 VSS.t918 418.094
R6243 VSS.t918 VSS.n2087 418.094
R6244 VSS.n2087 VSS.t850 418.094
R6245 VSS.n1506 VSS.t968 418.094
R6246 VSS.n1506 VSS.t888 418.094
R6247 VSS.n2419 VSS.t888 418.094
R6248 VSS.n2420 VSS.t908 418.094
R6249 VSS.t908 VSS.n1500 418.094
R6250 VSS.t966 VSS.n1500 418.094
R6251 VSS.n3525 VSS.t64 418.094
R6252 VSS.n3525 VSS.t56 418.094
R6253 VSS.t56 VSS.n3524 418.094
R6254 VSS.n3523 VSS.t60 418.094
R6255 VSS.t60 VSS.n3522 418.094
R6256 VSS.n3522 VSS.t66 418.094
R6257 VSS.n1441 VSS.t1076 418.094
R6258 VSS.n1442 VSS.t1052 418.094
R6259 VSS.t1052 VSS.n1435 418.094
R6260 VSS.t1024 VSS.n1435 418.094
R6261 VSS.t1106 VSS.n2461 418.094
R6262 VSS.n2461 VSS.t1066 418.094
R6263 VSS.t1066 VSS.n2460 418.094
R6264 VSS.n2459 VSS.t1046 418.094
R6265 VSS.n1444 VSS.t1046 418.094
R6266 VSS.t1012 VSS.n1444 418.094
R6267 VSS.n2452 VSS.t1132 418.094
R6268 VSS.n2452 VSS.t1022 418.094
R6269 VSS.t1022 VSS.n2451 418.094
R6270 VSS.n2450 VSS.t1042 418.094
R6271 VSS.n1455 VSS.t1042 418.094
R6272 VSS.t1098 VSS.n1455 418.094
R6273 VSS.n1486 VSS.t1090 418.094
R6274 VSS.n1486 VSS.t1010 418.094
R6275 VSS.t1010 VSS.n1485 418.094
R6276 VSS.n1484 VSS.t1030 418.094
R6277 VSS.n1463 VSS.t1030 418.094
R6278 VSS.t1082 VSS.n1463 418.094
R6279 VSS.n1477 VSS.t1329 418.094
R6280 VSS.n1477 VSS.t1331 418.094
R6281 VSS.t1331 VSS.n1476 418.094
R6282 VSS.n1475 VSS.t1319 418.094
R6283 VSS.t1319 VSS.n1474 418.094
R6284 VSS.n1474 VSS.t1317 418.094
R6285 VSS.n1374 VSS.t1301 418.094
R6286 VSS.n1374 VSS.t1303 418.094
R6287 VSS.n2651 VSS.t1303 418.094
R6288 VSS.n2652 VSS.t1311 418.094
R6289 VSS.t1311 VSS.n1369 418.094
R6290 VSS.t1309 VSS.n1369 418.094
R6291 VSS.t1349 VSS.n2976 418.094
R6292 VSS.n2976 VSS.t1351 418.094
R6293 VSS.t1351 VSS.n2975 418.094
R6294 VSS.n2974 VSS.t1355 418.094
R6295 VSS.n2654 VSS.t1355 418.094
R6296 VSS.t1353 VSS.n2654 418.094
R6297 VSS.n2782 VSS.t1357 418.094
R6298 VSS.n2782 VSS.t1359 418.094
R6299 VSS.n2786 VSS.t1359 418.094
R6300 VSS.n2787 VSS.t1297 418.094
R6301 VSS.t1297 VSS.n2777 418.094
R6302 VSS.t1299 VSS.n2777 418.094
R6303 VSS.t1842 VSS.n2944 418.094
R6304 VSS.n2944 VSS.t1840 418.094
R6305 VSS.t1840 VSS.n2943 418.094
R6306 VSS.n2942 VSS.t1844 418.094
R6307 VSS.n2789 VSS.t1844 418.094
R6308 VSS.t1846 VSS.n2789 418.094
R6309 VSS.n2833 VSS.t1850 418.094
R6310 VSS.n2833 VSS.t1848 418.094
R6311 VSS.t1848 VSS.n2832 418.094
R6312 VSS.n2831 VSS.t1810 418.094
R6313 VSS.t1810 VSS.n2830 418.094
R6314 VSS.n2830 VSS.t1808 418.094
R6315 VSS.n2826 VSS.t1806 418.094
R6316 VSS.n2826 VSS.t1804 418.094
R6317 VSS.n2847 VSS.t1804 418.094
R6318 VSS.n2848 VSS.t1834 418.094
R6319 VSS.t1834 VSS.n2821 418.094
R6320 VSS.t1832 VSS.n2821 418.094
R6321 VSS.t1800 VSS.n2901 418.094
R6322 VSS.n2901 VSS.t1802 418.094
R6323 VSS.t1802 VSS.n2900 418.094
R6324 VSS.n2899 VSS.t1830 418.094
R6325 VSS.n2850 VSS.t1830 418.094
R6326 VSS.t1828 VSS.n2850 418.094
R6327 VSS.n2867 VSS.t1509 418.094
R6328 VSS.n2867 VSS.t1511 418.094
R6329 VSS.t1511 VSS.n2866 418.094
R6330 VSS.n2865 VSS.t1525 418.094
R6331 VSS.t1525 VSS.n2864 418.094
R6332 VSS.n2864 VSS.t1527 418.094
R6333 VSS.n980 VSS.t1513 418.094
R6334 VSS.n980 VSS.t1515 418.094
R6335 VSS.n3472 VSS.t1515 418.094
R6336 VSS.n3473 VSS.t1529 418.094
R6337 VSS.t1529 VSS.n975 418.094
R6338 VSS.t1531 VSS.n975 418.094
R6339 VSS.t1503 VSS.n3484 418.094
R6340 VSS.n3484 VSS.t1501 418.094
R6341 VSS.t1501 VSS.n3483 418.094
R6342 VSS.n3482 VSS.t1523 418.094
R6343 VSS.t1523 VSS.n3481 418.094
R6344 VSS.n3481 VSS.t1521 418.094
R6345 VSS.n960 VSS.t1507 418.094
R6346 VSS.n960 VSS.t1505 418.094
R6347 VSS.n3509 VSS.t1505 418.094
R6348 VSS.n3510 VSS.t1519 418.094
R6349 VSS.t1519 VSS.n952 418.094
R6350 VSS.n952 VSS.t1517 418.094
R6351 VSS.n552 VSS.t647 418.094
R6352 VSS.t553 VSS.n553 418.094
R6353 VSS.n554 VSS.t553 418.094
R6354 VSS.t609 VSS.n554 418.094
R6355 VSS.n560 VSS.t643 418.094
R6356 VSS.n560 VSS.t541 418.094
R6357 VSS.n565 VSS.t541 418.094
R6358 VSS.n566 VSS.t579 418.094
R6359 VSS.t579 VSS.n547 418.094
R6360 VSS.t625 VSS.n547 418.094
R6361 VSS.t629 VSS.n571 418.094
R6362 VSS.n571 VSS.t605 418.094
R6363 VSS.t605 VSS.n570 418.094
R6364 VSS.n569 VSS.t635 418.094
R6365 VSS.t635 VSS.n568 418.094
R6366 VSS.n568 VSS.t561 418.094
R6367 VSS.n544 VSS.t563 418.094
R6368 VSS.n544 VSS.t623 418.094
R6369 VSS.n589 VSS.t623 418.094
R6370 VSS.n590 VSS.t527 418.094
R6371 VSS.t527 VSS.n539 418.094
R6372 VSS.t581 VSS.n539 418.094
R6373 VSS.t1395 VSS.n601 418.094
R6374 VSS.n601 VSS.t1393 418.094
R6375 VSS.t1393 VSS.n600 418.094
R6376 VSS.n599 VSS.t1417 418.094
R6377 VSS.t1417 VSS.n598 418.094
R6378 VSS.n598 VSS.t1419 418.094
R6379 VSS.n479 VSS.t1413 418.094
R6380 VSS.n479 VSS.t1415 418.094
R6381 VSS.n640 VSS.t1415 418.094
R6382 VSS.n641 VSS.t1381 418.094
R6383 VSS.t1381 VSS.n474 418.094
R6384 VSS.t1383 VSS.n474 418.094
R6385 VSS.t1421 VSS.n652 418.094
R6386 VSS.n652 VSS.t1423 418.094
R6387 VSS.t1423 VSS.n651 418.094
R6388 VSS.n650 VSS.t1375 418.094
R6389 VSS.t1375 VSS.n649 418.094
R6390 VSS.n649 VSS.t1373 418.094
R6391 VSS.n461 VSS.t1397 418.094
R6392 VSS.n461 VSS.t1399 418.094
R6393 VSS.n690 VSS.t1399 418.094
R6394 VSS.n691 VSS.t1433 418.094
R6395 VSS.t1433 VSS.n456 418.094
R6396 VSS.t1435 VSS.n456 418.094
R6397 VSS.t1607 VSS.n702 418.094
R6398 VSS.n702 VSS.t1605 418.094
R6399 VSS.t1605 VSS.n701 418.094
R6400 VSS.n700 VSS.t1623 418.094
R6401 VSS.t1623 VSS.n699 418.094
R6402 VSS.n699 VSS.t1621 418.094
R6403 VSS.n443 VSS.t1649 418.094
R6404 VSS.n443 VSS.t1651 418.094
R6405 VSS.n740 VSS.t1651 418.094
R6406 VSS.n741 VSS.t1603 418.094
R6407 VSS.t1603 VSS.n438 418.094
R6408 VSS.t1601 VSS.n438 418.094
R6409 VSS.t1613 VSS.n752 418.094
R6410 VSS.n752 VSS.t1615 418.094
R6411 VSS.t1615 VSS.n751 418.094
R6412 VSS.n750 VSS.t1641 418.094
R6413 VSS.t1641 VSS.n749 418.094
R6414 VSS.n749 VSS.t1643 418.094
R6415 VSS.n425 VSS.t1635 418.094
R6416 VSS.n425 VSS.t1633 418.094
R6417 VSS.n790 VSS.t1633 418.094
R6418 VSS.n791 VSS.t1597 418.094
R6419 VSS.t1597 VSS.n420 418.094
R6420 VSS.t1599 VSS.n420 418.094
R6421 VSS.t1279 VSS.n802 418.094
R6422 VSS.n802 VSS.t1281 418.094
R6423 VSS.t1281 VSS.n801 418.094
R6424 VSS.n800 VSS.t1257 418.094
R6425 VSS.t1257 VSS.n799 418.094
R6426 VSS.n799 VSS.t1255 418.094
R6427 VSS.n407 VSS.t1271 418.094
R6428 VSS.n407 VSS.t1273 418.094
R6429 VSS.n837 VSS.t1273 418.094
R6430 VSS.n838 VSS.t1283 418.094
R6431 VSS.t1283 VSS.n402 418.094
R6432 VSS.t1285 VSS.n402 418.094
R6433 VSS.t1269 VSS.n849 418.094
R6434 VSS.n849 VSS.t1267 418.094
R6435 VSS.t1267 VSS.n848 418.094
R6436 VSS.n847 VSS.t1275 418.094
R6437 VSS.t1275 VSS.n846 418.094
R6438 VSS.n846 VSS.t1277 418.094
R6439 VSS.n344 VSS.t1265 418.094
R6440 VSS.n344 VSS.t1263 418.094
R6441 VSS.n904 VSS.t1263 418.094
R6442 VSS.n905 VSS.t1259 418.094
R6443 VSS.t1259 VSS.n336 418.094
R6444 VSS.n336 VSS.t1261 418.094
R6445 VSS.n995 VSS.n984 383.053
R6446 VSS.n2917 VSS.n2916 383.053
R6447 VSS.n2996 VSS.t477 363.058
R6448 VSS.n2989 VSS.t477 363.058
R6449 VSS.t481 VSS.n2989 363.058
R6450 VSS.n2992 VSS.t481 363.058
R6451 VSS.n1352 VSS.t487 363.058
R6452 VSS.t487 VSS.n1350 363.058
R6453 VSS.n1350 VSS.t489 363.058
R6454 VSS.n3018 VSS.t489 363.058
R6455 VSS.n3019 VSS.t483 363.058
R6456 VSS.t483 VSS.n1346 363.058
R6457 VSS.n1346 VSS.t485 363.058
R6458 VSS.n3021 VSS.t485 363.058
R6459 VSS.n3022 VSS.t475 363.058
R6460 VSS.t475 VSS.n1344 363.058
R6461 VSS.t479 VSS.n1344 363.058
R6462 VSS.n3031 VSS.t479 363.058
R6463 VSS.n3030 VSS.t471 363.058
R6464 VSS.n3023 VSS.t471 363.058
R6465 VSS.t473 VSS.n3023 363.058
R6466 VSS.n3026 VSS.t473 363.058
R6467 VSS.n1324 VSS.t467 363.058
R6468 VSS.t467 VSS.n1322 363.058
R6469 VSS.n1322 VSS.t469 363.058
R6470 VSS.n3072 VSS.t469 363.058
R6471 VSS.n3073 VSS.t740 363.058
R6472 VSS.t740 VSS.n1319 363.058
R6473 VSS.n1319 VSS.t742 363.058
R6474 VSS.n3075 VSS.t742 363.058
R6475 VSS.n3076 VSS.t702 363.058
R6476 VSS.n3078 VSS.t702 363.058
R6477 VSS.n3079 VSS.t263 363.058
R6478 VSS.t263 VSS.n1312 363.058
R6479 VSS.n1312 VSS.t251 363.058
R6480 VSS.n3081 VSS.t251 363.058
R6481 VSS.n3082 VSS.t257 363.058
R6482 VSS.t257 VSS.n1310 363.058
R6483 VSS.t255 VSS.n1310 363.058
R6484 VSS.n3091 VSS.t255 363.058
R6485 VSS.n3090 VSS.t249 363.058
R6486 VSS.n3083 VSS.t249 363.058
R6487 VSS.t253 VSS.n3083 363.058
R6488 VSS.n3086 VSS.t253 363.058
R6489 VSS.n1290 VSS.t259 363.058
R6490 VSS.t259 VSS.n1288 363.058
R6491 VSS.n1288 VSS.t261 363.058
R6492 VSS.n3120 VSS.t261 363.058
R6493 VSS.n3121 VSS.t289 363.058
R6494 VSS.t289 VSS.n1284 363.058
R6495 VSS.n1284 VSS.t291 363.058
R6496 VSS.n3123 VSS.t291 363.058
R6497 VSS.n3124 VSS.t285 363.058
R6498 VSS.t285 VSS.n1282 363.058
R6499 VSS.n1282 VSS.t287 363.058
R6500 VSS.n3128 VSS.t287 363.058
R6501 VSS.n3129 VSS.t108 363.058
R6502 VSS.t108 VSS.n1279 363.058
R6503 VSS.n1279 VSS.t110 363.058
R6504 VSS.n3131 VSS.t110 363.058
R6505 VSS.n3132 VSS.t834 363.058
R6506 VSS.n3134 VSS.t834 363.058
R6507 VSS.n3135 VSS.t750 363.058
R6508 VSS.t750 VSS.n1272 363.058
R6509 VSS.n1272 VSS.t756 363.058
R6510 VSS.n3137 VSS.t756 363.058
R6511 VSS.n3138 VSS.t746 363.058
R6512 VSS.t746 VSS.n1270 363.058
R6513 VSS.n1270 VSS.t744 363.058
R6514 VSS.n3145 VSS.t744 363.058
R6515 VSS.n3146 VSS.t754 363.058
R6516 VSS.t754 VSS.n1266 363.058
R6517 VSS.n1266 VSS.t758 363.058
R6518 VSS.n3148 VSS.t758 363.058
R6519 VSS.n3149 VSS.t748 363.058
R6520 VSS.t748 VSS.n1264 363.058
R6521 VSS.n1264 VSS.t752 363.058
R6522 VSS.n3199 VSS.t752 363.058
R6523 VSS.n3200 VSS.t685 363.058
R6524 VSS.t685 VSS.n1260 363.058
R6525 VSS.n1260 VSS.t687 363.058
R6526 VSS.n3202 VSS.t687 363.058
R6527 VSS.n3203 VSS.t689 363.058
R6528 VSS.t689 VSS.n1255 363.058
R6529 VSS.n1255 VSS.t691 363.058
R6530 VSS.n3205 VSS.t691 363.058
R6531 VSS.n3206 VSS.t788 363.058
R6532 VSS.t788 VSS.n1252 363.058
R6533 VSS.n1252 VSS.t790 363.058
R6534 VSS.n3208 VSS.t790 363.058
R6535 VSS.n3209 VSS.t230 363.058
R6536 VSS.n3211 VSS.t230 363.058
R6537 VSS.n868 VSS.n867 356.757
R6538 VSS.n3538 VSS.n3537 356.757
R6539 VSS.n2767 VSS.n2764 353.62
R6540 VSS.n629 VSS.n628 333.618
R6541 VSS.n623 VSS.n466 333.618
R6542 VSS.n679 VSS.n678 333.618
R6543 VSS.n673 VSS.n448 333.618
R6544 VSS.n729 VSS.n728 333.618
R6545 VSS.n723 VSS.n430 333.618
R6546 VSS.n779 VSS.n778 333.618
R6547 VSS.n773 VSS.n412 333.618
R6548 VSS.n826 VSS.n825 333.618
R6549 VSS.n3721 VSS.n3720 333.618
R6550 VSS.n118 VSS.n94 333.618
R6551 VSS.n3695 VSS.n3694 333.618
R6552 VSS.n160 VSS.n136 333.618
R6553 VSS.n3669 VSS.n3668 333.618
R6554 VSS.n202 VSS.n178 333.618
R6555 VSS.n3643 VSS.n3642 333.618
R6556 VSS.n244 VSS.n220 333.618
R6557 VSS.n3617 VSS.n3616 333.618
R6558 VSS.n282 VSS.n262 333.618
R6559 VSS.n1905 VSS.n1904 333.618
R6560 VSS.n1607 VSS.n1583 333.618
R6561 VSS.n1879 VSS.n1878 333.618
R6562 VSS.n1649 VSS.n1625 333.618
R6563 VSS.n1853 VSS.n1852 333.618
R6564 VSS.n1691 VSS.n1667 333.618
R6565 VSS.n1827 VSS.n1826 333.618
R6566 VSS.n1782 VSS.n1709 333.618
R6567 VSS.n1801 VSS.n1800 333.618
R6568 VSS.n2914 VSS.n2913 307.495
R6569 VSS.n616 VSS.n615 304.805
R6570 VSS.n626 VSS.n625 304.805
R6571 VSS.n666 VSS.n665 304.805
R6572 VSS.n676 VSS.n675 304.805
R6573 VSS.n716 VSS.n715 304.805
R6574 VSS.n726 VSS.n725 304.805
R6575 VSS.n766 VSS.n765 304.805
R6576 VSS.n776 VSS.n775 304.805
R6577 VSS.n816 VSS.n815 304.805
R6578 VSS.n823 VSS.n391 304.805
R6579 VSS.n2276 VSS.n85 304.805
R6580 VSS.n3718 VSS.n3717 304.805
R6581 VSS.n127 VSS.n126 304.805
R6582 VSS.n3692 VSS.n3691 304.805
R6583 VSS.n169 VSS.n168 304.805
R6584 VSS.n3666 VSS.n3665 304.805
R6585 VSS.n211 VSS.n210 304.805
R6586 VSS.n3640 VSS.n3639 304.805
R6587 VSS.n253 VSS.n252 304.805
R6588 VSS.n3614 VSS.n3613 304.805
R6589 VSS.n291 VSS.n290 304.805
R6590 VSS.n1574 VSS.n1573 304.805
R6591 VSS.n1902 VSS.n1901 304.805
R6592 VSS.n1616 VSS.n1615 304.805
R6593 VSS.n1876 VSS.n1875 304.805
R6594 VSS.n1658 VSS.n1657 304.805
R6595 VSS.n1850 VSS.n1849 304.805
R6596 VSS.n1700 VSS.n1699 304.805
R6597 VSS.n1824 VSS.n1823 304.805
R6598 VSS.n1791 VSS.n1790 304.805
R6599 VSS.n1798 VSS.n944 304.805
R6600 VSS.n3517 VSS.n3516 304.805
R6601 VSS.n3380 VSS.n1147 297.546
R6602 VSS.n3384 VSS.n1110 297.546
R6603 VSS.n861 VSS.n388 293.399
R6604 VSS.n3531 VSS.n3530 293.399
R6605 VSS.n2964 VSS.n2673 283.776
R6606 VSS.n2872 VSS.n2819 271.791
R6607 VSS.n2890 VSS.n2889 271.791
R6608 VSS.n2799 VSS.n2766 271.791
R6609 VSS.n2933 VSS.n2932 271.791
R6610 VSS.n3380 VSS.n1148 266.872
R6611 VSS.n3384 VSS.n1111 266.872
R6612 VSS.n3377 VSS.t819 259.878
R6613 VSS.t825 VSS.n1149 259.878
R6614 VSS.t810 VSS.n1149 259.878
R6615 VSS.n1180 VSS.t815 259.878
R6616 VSS.n1180 VSS.t830 259.878
R6617 VSS.t808 VSS.n1150 259.878
R6618 VSS.t812 VSS.n1150 259.878
R6619 VSS.n1173 VSS.t499 259.878
R6620 VSS.n1173 VSS.t495 259.878
R6621 VSS.t822 VSS.n1152 259.878
R6622 VSS.t1938 VSS.n1152 259.878
R6623 VSS.n1172 VSS.t493 259.878
R6624 VSS.n1172 VSS.t497 259.878
R6625 VSS.t1928 VSS.n1156 259.878
R6626 VSS.t1930 VSS.n1156 259.878
R6627 VSS.n1167 VSS.t1947 259.878
R6628 VSS.n1167 VSS.t1936 259.878
R6629 VSS.t1943 VSS.n1157 259.878
R6630 VSS.n1157 VSS.t1932 259.878
R6631 VSS.n3379 VSS.t1939 259.878
R6632 VSS.n3381 VSS.t208 259.878
R6633 VSS.t234 VSS.n1112 259.878
R6634 VSS.t228 VSS.n1112 259.878
R6635 VSS.n1143 VSS.t218 259.878
R6636 VSS.n1143 VSS.t222 259.878
R6637 VSS.t212 VSS.n1113 259.878
R6638 VSS.t214 VSS.n1113 259.878
R6639 VSS.n1136 VSS.t220 259.878
R6640 VSS.n1136 VSS.t224 259.878
R6641 VSS.t210 VSS.n1115 259.878
R6642 VSS.t1152 VSS.n1115 259.878
R6643 VSS.n1135 VSS.t500 259.878
R6644 VSS.n1135 VSS.t494 259.878
R6645 VSS.t1134 VSS.n1119 259.878
R6646 VSS.t1154 VSS.n1119 259.878
R6647 VSS.n1130 VSS.t1140 259.878
R6648 VSS.n1130 VSS.t1159 259.878
R6649 VSS.t1148 VSS.n1120 259.878
R6650 VSS.n1120 VSS.t1137 259.878
R6651 VSS.n3383 VSS.t1145 259.878
R6652 VSS.n3385 VSS.t712 259.878
R6653 VSS.t700 VSS.n1063 259.878
R6654 VSS.t693 VSS.n1063 259.878
R6655 VSS.n1102 VSS.t708 259.878
R6656 VSS.n1102 VSS.t697 259.878
R6657 VSS.t715 VSS.n1064 259.878
R6658 VSS.t695 VSS.n1064 259.878
R6659 VSS.n1095 VSS.t491 259.878
R6660 VSS.n1095 VSS.t496 259.878
R6661 VSS.t717 VSS.n1066 259.878
R6662 VSS.t1683 VSS.n1066 259.878
R6663 VSS.n1094 VSS.t498 259.878
R6664 VSS.n1094 VSS.t492 259.878
R6665 VSS.t1689 VSS.n1070 259.878
R6666 VSS.t1696 VSS.n1070 259.878
R6667 VSS.n1089 VSS.t1687 259.878
R6668 VSS.n1089 VSS.t1703 259.878
R6669 VSS.t1693 VSS.n1071 259.878
R6670 VSS.t1691 VSS.n1071 259.878
R6671 VSS.n1088 VSS.t1685 259.878
R6672 VSS.n862 VSS.n861 248.649
R6673 VSS.n377 VSS.n376 248.649
R6674 VSS.n3532 VSS.n3531 248.649
R6675 VSS.n3520 VSS.n933 248.649
R6676 VSS.n994 VSS.n993 244.032
R6677 VSS.n2881 VSS.n2880 244.032
R6678 VSS.n3461 VSS.n986 244.032
R6679 VSS.n2808 VSS.n2807 244.032
R6680 VSS.n2930 VSS.n2929 244.032
R6681 VSS.n3557 VSS.n3556 219.745
R6682 VSS.n32 VSS.t539 208.968
R6683 VSS.n6 VSS.t601 208.968
R6684 VSS.n1973 VSS.t567 208.968
R6685 VSS.n2204 VSS.t337 208.968
R6686 VSS.n2014 VSS.t381 208.968
R6687 VSS.n1955 VSS.t445 208.968
R6688 VSS.n2171 VSS.t439 208.968
R6689 VSS.n2130 VSS.t892 208.968
R6690 VSS.n2471 VSS.t1058 208.968
R6691 VSS.n1423 VSS.t1088 208.968
R6692 VSS.n2106 VSS.t924 208.968
R6693 VSS.n2370 VSS.t932 208.968
R6694 VSS.n2073 VSS.t904 208.968
R6695 VSS.n1436 VSS.t1026 208.968
R6696 VSS.n549 VSS.t575 208.968
R6697 VSS.n2672 VSS.n2671 208.868
R6698 VSS.n991 VSS.n967 182.584
R6699 VSS.n3347 VSS.t1175 174.847
R6700 VSS.t1175 VSS.n1147 174.847
R6701 VSS.t275 VSS.n1148 174.847
R6702 VSS.n1205 VSS.t275 174.847
R6703 VSS.n3314 VSS.t1722 174.847
R6704 VSS.t1722 VSS.n1110 174.847
R6705 VSS.t798 VSS.n1111 174.847
R6706 VSS.n3303 VSS.t798 174.847
R6707 VSS.t267 VSS.n1205 172.161
R6708 VSS.t792 VSS.n3303 172.161
R6709 VSS.n1078 VSS.n966 168.704
R6710 VSS.n510 VSS.n484 166.81
R6711 VSS.n2272 VSS.n2271 166.81
R6712 VSS.n3587 VSS.n3586 166.81
R6713 VSS.n1554 VSS.n1547 166.81
R6714 VSS.n3520 VSS.n3519 166.81
R6715 VSS.n3514 VSS.n3513 166.81
R6716 VSS.n2988 VSS.n1363 155.569
R6717 VSS.n862 VSS.t994 154.054
R6718 VSS.t994 VSS.n383 154.054
R6719 VSS.n383 VSS.t996 154.054
R6720 VSS.n864 VSS.t996 154.054
R6721 VSS.n865 VSS.t14 154.054
R6722 VSS.t14 VSS.n379 154.054
R6723 VSS.n379 VSS.t8 154.054
R6724 VSS.n867 VSS.t8 154.054
R6725 VSS.n868 VSS.t10 154.054
R6726 VSS.t10 VSS.n362 154.054
R6727 VSS.t16 VSS.n362 154.054
R6728 VSS.n377 VSS.t16 154.054
R6729 VSS.n3532 VSS.t519 154.054
R6730 VSS.t519 VSS.n937 154.054
R6731 VSS.n937 VSS.t523 154.054
R6732 VSS.n3534 VSS.t523 154.054
R6733 VSS.n3535 VSS.t58 154.054
R6734 VSS.t58 VSS.n934 154.054
R6735 VSS.n934 VSS.t52 154.054
R6736 VSS.n3537 VSS.t52 154.054
R6737 VSS.n3538 VSS.t62 154.054
R6738 VSS.t62 VSS.n931 154.054
R6739 VSS.t54 VSS.n931 154.054
R6740 VSS.n933 VSS.t54 154.054
R6741 VSS.t136 VSS.n984 124.263
R6742 VSS.n995 VSS.t138 124.263
R6743 VSS.n2916 VSS.t1790 124.263
R6744 VSS.t1321 VSS.n2673 124.263
R6745 VSS.n3513 VSS.n920 123.477
R6746 VSS.n861 VSS.n860 122.585
R6747 VSS.n3531 VSS.n942 122.585
R6748 VSS.n3224 VSS.n965 110.793
R6749 VSS.n3225 VSS.n3213 110.793
R6750 VSS.n2536 VSS.n2535 109.819
R6751 VSS.n2521 VSS.n2519 109.819
R6752 VSS.n2603 VSS.n2602 109.819
R6753 VSS.t144 VSS.n985 109.546
R6754 VSS.n985 VSS.t136 109.546
R6755 VSS.n1002 VSS.t138 109.546
R6756 VSS.t146 VSS.n1002 109.546
R6757 VSS.t1790 VSS.n2915 109.546
R6758 VSS.n2915 VSS.t1788 109.546
R6759 VSS.t1788 VSS.n2914 109.546
R6760 VSS.n2768 VSS.t1321 109.546
R6761 VSS.n2768 VSS.t1323 109.546
R6762 VSS.t1323 VSS.n2767 109.546
R6763 VSS.n2764 VSS.t1339 109.546
R6764 VSS.n2954 VSS.t1339 109.546
R6765 VSS.t1407 VSS.n484 108.831
R6766 VSS.n629 VSS.t1391 108.831
R6767 VSS.n628 VSS.t1409 108.831
R6768 VSS.t1401 VSS.n623 108.831
R6769 VSS.t1377 VSS.n466 108.831
R6770 VSS.n679 VSS.t1427 108.831
R6771 VSS.n678 VSS.t1431 108.831
R6772 VSS.t1387 VSS.n673 108.831
R6773 VSS.t1645 VSS.n448 108.831
R6774 VSS.n729 VSS.t1617 108.831
R6775 VSS.n728 VSS.t1609 108.831
R6776 VSS.t1639 VSS.n723 108.831
R6777 VSS.t1631 VSS.n430 108.831
R6778 VSS.n779 VSS.t1595 108.831
R6779 VSS.n778 VSS.t1625 108.831
R6780 VSS.t1653 VSS.n773 108.831
R6781 VSS.t88 VSS.n412 108.831
R6782 VSS.n826 VSS.t92 108.831
R6783 VSS.n825 VSS.t90 108.831
R6784 VSS.t1479 VSS.n2272 108.831
R6785 VSS.n3721 VSS.t1441 108.831
R6786 VSS.n3720 VSS.t1437 108.831
R6787 VSS.n94 VSS.t1499 108.831
R6788 VSS.t1463 VSS.n118 108.831
R6789 VSS.n3695 VSS.t1487 108.831
R6790 VSS.n3694 VSS.t1447 108.831
R6791 VSS.n136 VSS.t1459 108.831
R6792 VSS.t1237 VSS.n160 108.831
R6793 VSS.n3669 VSS.t1189 108.831
R6794 VSS.n3668 VSS.t1181 108.831
R6795 VSS.n178 VSS.t1195 108.831
R6796 VSS.t1229 VSS.n202 108.831
R6797 VSS.n3643 VSS.t1197 108.831
R6798 VSS.n3642 VSS.t1221 108.831
R6799 VSS.n220 VSS.t1225 108.831
R6800 VSS.t182 VSS.n244 108.831
R6801 VSS.n3617 VSS.t186 108.831
R6802 VSS.n3616 VSS.t184 108.831
R6803 VSS.n262 VSS.t188 108.831
R6804 VSS.t990 VSS.n282 108.831
R6805 VSS.n3587 VSS.t992 108.831
R6806 VSS.t1906 VSS.n1547 108.831
R6807 VSS.n1905 VSS.t1924 108.831
R6808 VSS.n1904 VSS.t1876 108.831
R6809 VSS.n1583 VSS.t1868 108.831
R6810 VSS.t1882 VSS.n1607 108.831
R6811 VSS.n1879 VSS.t1898 108.831
R6812 VSS.n1878 VSS.t1900 108.831
R6813 VSS.n1625 VSS.t1912 108.831
R6814 VSS.t1736 VSS.n1649 108.831
R6815 VSS.n1853 VSS.t1746 108.831
R6816 VSS.n1852 VSS.t1748 108.831
R6817 VSS.n1667 VSS.t1752 108.831
R6818 VSS.t1780 VSS.n1691 108.831
R6819 VSS.n1827 VSS.t1782 108.831
R6820 VSS.n1826 VSS.t1726 108.831
R6821 VSS.n1709 VSS.t1730 108.831
R6822 VSS.t28 VSS.n1782 108.831
R6823 VSS.n1801 VSS.t32 108.831
R6824 VSS.n1800 VSS.t30 108.831
R6825 VSS.n3519 VSS.t760 108.831
R6826 VSS.t762 VSS.n3514 108.831
R6827 VSS.t1681 VSS.n1075 104.523
R6828 VSS.n1078 VSS.t1681 104.523
R6829 VSS.n1186 VSS.t780 104.523
R6830 VSS.t780 VSS.n1184 104.523
R6831 VSS.n3376 VSS.n1184 99.0225
R6832 VSS.n488 VSS.t1407 94.4235
R6833 VSS.n488 VSS.t1405 94.4235
R6834 VSS.n615 VSS.t1405 94.4235
R6835 VSS.n616 VSS.t1389 94.4235
R6836 VSS.t1389 VSS.n483 94.4235
R6837 VSS.t1391 VSS.n483 94.4235
R6838 VSS.t1409 VSS.n627 94.4235
R6839 VSS.n627 VSS.t1411 94.4235
R6840 VSS.t1411 VSS.n626 94.4235
R6841 VSS.n625 VSS.t1403 94.4235
R6842 VSS.t1403 VSS.n624 94.4235
R6843 VSS.n624 VSS.t1401 94.4235
R6844 VSS.n470 VSS.t1377 94.4235
R6845 VSS.n470 VSS.t1379 94.4235
R6846 VSS.n665 VSS.t1379 94.4235
R6847 VSS.n666 VSS.t1425 94.4235
R6848 VSS.t1425 VSS.n465 94.4235
R6849 VSS.t1427 VSS.n465 94.4235
R6850 VSS.t1431 VSS.n677 94.4235
R6851 VSS.n677 VSS.t1429 94.4235
R6852 VSS.t1429 VSS.n676 94.4235
R6853 VSS.n675 VSS.t1385 94.4235
R6854 VSS.t1385 VSS.n674 94.4235
R6855 VSS.n674 VSS.t1387 94.4235
R6856 VSS.n452 VSS.t1645 94.4235
R6857 VSS.n452 VSS.t1647 94.4235
R6858 VSS.n715 VSS.t1647 94.4235
R6859 VSS.n716 VSS.t1619 94.4235
R6860 VSS.t1619 VSS.n447 94.4235
R6861 VSS.t1617 VSS.n447 94.4235
R6862 VSS.t1609 VSS.n727 94.4235
R6863 VSS.n727 VSS.t1611 94.4235
R6864 VSS.t1611 VSS.n726 94.4235
R6865 VSS.n725 VSS.t1637 94.4235
R6866 VSS.t1637 VSS.n724 94.4235
R6867 VSS.n724 VSS.t1639 94.4235
R6868 VSS.n434 VSS.t1631 94.4235
R6869 VSS.n434 VSS.t1629 94.4235
R6870 VSS.n765 VSS.t1629 94.4235
R6871 VSS.n766 VSS.t1593 94.4235
R6872 VSS.t1593 VSS.n429 94.4235
R6873 VSS.t1595 VSS.n429 94.4235
R6874 VSS.t1625 VSS.n777 94.4235
R6875 VSS.n777 VSS.t1627 94.4235
R6876 VSS.t1627 VSS.n776 94.4235
R6877 VSS.n775 VSS.t1655 94.4235
R6878 VSS.t1655 VSS.n774 94.4235
R6879 VSS.n774 VSS.t1653 94.4235
R6880 VSS.n416 VSS.t88 94.4235
R6881 VSS.n416 VSS.t96 94.4235
R6882 VSS.n815 VSS.t96 94.4235
R6883 VSS.n816 VSS.t84 94.4235
R6884 VSS.t84 VSS.n411 94.4235
R6885 VSS.t92 VSS.n411 94.4235
R6886 VSS.t90 VSS.n824 94.4235
R6887 VSS.n824 VSS.t98 94.4235
R6888 VSS.t98 VSS.n823 94.4235
R6889 VSS.n391 VSS.t86 94.4235
R6890 VSS.t86 VSS.n389 94.4235
R6891 VSS.n389 VSS.t94 94.4235
R6892 VSS.n860 VSS.t94 94.4235
R6893 VSS.n2277 VSS.t1479 94.4235
R6894 VSS.n2277 VSS.t1477 94.4235
R6895 VSS.t1477 VSS.n2276 94.4235
R6896 VSS.n85 VSS.t1443 94.4235
R6897 VSS.t1443 VSS.n84 94.4235
R6898 VSS.t1441 VSS.n84 94.4235
R6899 VSS.t1437 VSS.n3719 94.4235
R6900 VSS.n3719 VSS.t1439 94.4235
R6901 VSS.t1439 VSS.n3718 94.4235
R6902 VSS.n3717 VSS.t1497 94.4235
R6903 VSS.n87 VSS.t1497 94.4235
R6904 VSS.t1499 VSS.n87 94.4235
R6905 VSS.n122 VSS.t1463 94.4235
R6906 VSS.n122 VSS.t1461 94.4235
R6907 VSS.n126 VSS.t1461 94.4235
R6908 VSS.n127 VSS.t1485 94.4235
R6909 VSS.t1485 VSS.n117 94.4235
R6910 VSS.t1487 VSS.n117 94.4235
R6911 VSS.t1447 VSS.n3693 94.4235
R6912 VSS.n3693 VSS.t1445 94.4235
R6913 VSS.t1445 VSS.n3692 94.4235
R6914 VSS.n3691 VSS.t1457 94.4235
R6915 VSS.n129 VSS.t1457 94.4235
R6916 VSS.t1459 VSS.n129 94.4235
R6917 VSS.n164 VSS.t1237 94.4235
R6918 VSS.n164 VSS.t1239 94.4235
R6919 VSS.n168 VSS.t1239 94.4235
R6920 VSS.n169 VSS.t1191 94.4235
R6921 VSS.t1191 VSS.n159 94.4235
R6922 VSS.t1189 VSS.n159 94.4235
R6923 VSS.t1181 VSS.n3667 94.4235
R6924 VSS.n3667 VSS.t1183 94.4235
R6925 VSS.t1183 VSS.n3666 94.4235
R6926 VSS.n3665 VSS.t1193 94.4235
R6927 VSS.n171 VSS.t1193 94.4235
R6928 VSS.t1195 VSS.n171 94.4235
R6929 VSS.n206 VSS.t1229 94.4235
R6930 VSS.n206 VSS.t1231 94.4235
R6931 VSS.n210 VSS.t1231 94.4235
R6932 VSS.n211 VSS.t1199 94.4235
R6933 VSS.t1199 VSS.n201 94.4235
R6934 VSS.t1197 VSS.n201 94.4235
R6935 VSS.t1221 VSS.n3641 94.4235
R6936 VSS.n3641 VSS.t1223 94.4235
R6937 VSS.t1223 VSS.n3640 94.4235
R6938 VSS.n3639 VSS.t1227 94.4235
R6939 VSS.n213 VSS.t1227 94.4235
R6940 VSS.t1225 VSS.n213 94.4235
R6941 VSS.n248 VSS.t182 94.4235
R6942 VSS.n248 VSS.t190 94.4235
R6943 VSS.n252 VSS.t190 94.4235
R6944 VSS.n253 VSS.t178 94.4235
R6945 VSS.t178 VSS.n243 94.4235
R6946 VSS.t186 VSS.n243 94.4235
R6947 VSS.t184 VSS.n3615 94.4235
R6948 VSS.n3615 VSS.t176 94.4235
R6949 VSS.t176 VSS.n3614 94.4235
R6950 VSS.n3613 VSS.t180 94.4235
R6951 VSS.n255 VSS.t180 94.4235
R6952 VSS.t188 VSS.n255 94.4235
R6953 VSS.n286 VSS.t990 94.4235
R6954 VSS.n286 VSS.t998 94.4235
R6955 VSS.n290 VSS.t998 94.4235
R6956 VSS.n291 VSS.t1000 94.4235
R6957 VSS.t1000 VSS.n281 94.4235
R6958 VSS.t992 VSS.n281 94.4235
R6959 VSS.n1551 VSS.t1906 94.4235
R6960 VSS.n1551 VSS.t1894 94.4235
R6961 VSS.n1573 VSS.t1894 94.4235
R6962 VSS.n1574 VSS.t1910 94.4235
R6963 VSS.t1910 VSS.n1546 94.4235
R6964 VSS.t1924 VSS.n1546 94.4235
R6965 VSS.t1876 VSS.n1903 94.4235
R6966 VSS.n1903 VSS.t1888 94.4235
R6967 VSS.t1888 VSS.n1902 94.4235
R6968 VSS.n1901 VSS.t1918 94.4235
R6969 VSS.n1576 VSS.t1918 94.4235
R6970 VSS.t1868 VSS.n1576 94.4235
R6971 VSS.n1611 VSS.t1882 94.4235
R6972 VSS.n1611 VSS.t1922 94.4235
R6973 VSS.n1615 VSS.t1922 94.4235
R6974 VSS.n1616 VSS.t1870 94.4235
R6975 VSS.t1870 VSS.n1606 94.4235
R6976 VSS.t1898 VSS.n1606 94.4235
R6977 VSS.t1900 VSS.n1877 94.4235
R6978 VSS.n1877 VSS.t1866 94.4235
R6979 VSS.t1866 VSS.n1876 94.4235
R6980 VSS.n1875 VSS.t1880 94.4235
R6981 VSS.n1618 VSS.t1880 94.4235
R6982 VSS.t1912 VSS.n1618 94.4235
R6983 VSS.n1653 VSS.t1736 94.4235
R6984 VSS.n1653 VSS.t1756 94.4235
R6985 VSS.n1657 VSS.t1756 94.4235
R6986 VSS.n1658 VSS.t1770 94.4235
R6987 VSS.t1770 VSS.n1648 94.4235
R6988 VSS.t1746 VSS.n1648 94.4235
R6989 VSS.t1748 VSS.n1851 94.4235
R6990 VSS.n1851 VSS.t1776 94.4235
R6991 VSS.t1776 VSS.n1850 94.4235
R6992 VSS.n1849 VSS.t1740 94.4235
R6993 VSS.n1660 VSS.t1740 94.4235
R6994 VSS.t1752 VSS.n1660 94.4235
R6995 VSS.n1695 VSS.t1780 94.4235
R6996 VSS.n1695 VSS.t1734 94.4235
R6997 VSS.n1699 VSS.t1734 94.4235
R6998 VSS.n1700 VSS.t1768 94.4235
R6999 VSS.t1768 VSS.n1690 94.4235
R7000 VSS.t1782 VSS.n1690 94.4235
R7001 VSS.t1726 VSS.n1825 94.4235
R7002 VSS.n1825 VSS.t1744 94.4235
R7003 VSS.t1744 VSS.n1824 94.4235
R7004 VSS.n1823 VSS.t1760 94.4235
R7005 VSS.n1702 VSS.t1760 94.4235
R7006 VSS.t1730 VSS.n1702 94.4235
R7007 VSS.n1786 VSS.t28 94.4235
R7008 VSS.n1786 VSS.t36 94.4235
R7009 VSS.n1790 VSS.t36 94.4235
R7010 VSS.n1791 VSS.t24 94.4235
R7011 VSS.t24 VSS.n1781 94.4235
R7012 VSS.t32 VSS.n1781 94.4235
R7013 VSS.t30 VSS.n1799 94.4235
R7014 VSS.n1799 VSS.t38 94.4235
R7015 VSS.t38 VSS.n1798 94.4235
R7016 VSS.t26 VSS.n944 94.4235
R7017 VSS.n946 VSS.t26 94.4235
R7018 VSS.n946 VSS.t34 94.4235
R7019 VSS.t34 VSS.n942 94.4235
R7020 VSS.t760 VSS.n3518 94.4235
R7021 VSS.n3518 VSS.t764 94.4235
R7022 VSS.t764 VSS.n3517 94.4235
R7023 VSS.n3516 VSS.t766 94.4235
R7024 VSS.t766 VSS.n3515 94.4235
R7025 VSS.n3515 VSS.t762 94.4235
R7026 VSS.n2640 VSS.n2639 91.8088
R7027 VSS.n3498 VSS.n3497 89.6983
R7028 VSS.n3228 VSS.n3227 89.6983
R7029 VSS.n3242 VSS.n3212 89.6983
R7030 VSS.n2819 VSS.t1812 89.4768
R7031 VSS.t1818 VSS.n2872 89.4768
R7032 VSS.n2890 VSS.t1796 89.4768
R7033 VSS.n2889 VSS.t140 89.4768
R7034 VSS.n2766 VSS.t1337 89.4768
R7035 VSS.t1822 VSS.n2799 89.4768
R7036 VSS.n2933 VSS.t1794 89.4768
R7037 VSS.n2932 VSS.t1838 89.4768
R7038 VSS.n2965 VSS.t1325 89.4768
R7039 VSS.t150 VSS.n991 88.9962
R7040 VSS.n2510 VSS.n2509 88.8036
R7041 VSS.n2533 VSS.n2532 88.8036
R7042 VSS.n2525 VSS.n1401 88.8036
R7043 VSS.n2600 VSS.n2599 88.8036
R7044 VSS.n2955 VSS.n2954 84.5617
R7045 VSS.t1243 VSS.n920 81.6772
R7046 VSS.n3559 VSS.t1251 81.6772
R7047 VSS.n1087 VSS.n1075 80.6851
R7048 VSS.n993 VSS.t142 75.5973
R7049 VSS.t142 VSS.n992 75.5973
R7050 VSS.n992 VSS.t150 75.5973
R7051 VSS.n2912 VSS.t1814 75.5973
R7052 VSS.n2812 VSS.t1814 75.5973
R7053 VSS.t1812 VSS.n2812 75.5973
R7054 VSS.n2876 VSS.t1818 75.5973
R7055 VSS.n2876 VSS.t1816 75.5973
R7056 VSS.n2880 VSS.t1816 75.5973
R7057 VSS.n2881 VSS.t1798 75.5973
R7058 VSS.t1798 VSS.n2871 75.5973
R7059 VSS.t1796 VSS.n2871 75.5973
R7060 VSS.t140 VSS.n2888 75.5973
R7061 VSS.n2888 VSS.t148 75.5973
R7062 VSS.t148 VSS.n986 75.5973
R7063 VSS.n2803 VSS.t1822 75.5973
R7064 VSS.n2803 VSS.t1820 75.5973
R7065 VSS.n2807 VSS.t1820 75.5973
R7066 VSS.n2808 VSS.t1792 75.5973
R7067 VSS.t1792 VSS.n2798 75.5973
R7068 VSS.t1794 VSS.n2798 75.5973
R7069 VSS.t1838 VSS.n2931 75.5973
R7070 VSS.n2931 VSS.t1836 75.5973
R7071 VSS.t1836 VSS.n2930 75.5973
R7072 VSS.n2929 VSS.t1824 75.5973
R7073 VSS.n2927 VSS.t1824 75.5973
R7074 VSS.n2927 VSS.t1826 75.5973
R7075 VSS.n2672 VSS.t1327 75.5973
R7076 VSS.t1327 VSS.n2663 75.5973
R7077 VSS.t1325 VSS.n2663 75.5973
R7078 VSS.n2630 VSS.n2629 72.4605
R7079 VSS.n2637 VSS.n1367 72.4605
R7080 VSS.n2965 VSS.n2964 72.2354
R7081 VSS.n924 VSS.t1243 68.0737
R7082 VSS.n924 VSS.t1245 68.0737
R7083 VSS.n3556 VSS.t1245 68.0737
R7084 VSS.n3557 VSS.t1249 68.0737
R7085 VSS.t1249 VSS.n916 68.0737
R7086 VSS.n916 VSS.t1251 68.0737
R7087 VSS.n3460 VSS.t144 67.2651
R7088 VSS.n1003 VSS.t146 67.2651
R7089 VSS.t521 VSS.n967 61.1001
R7090 VSS.t1345 VSS.n1363 61.1001
R7091 VSS.n2926 VSS.n2917 60.8415
R7092 VSS.n2589 VSS.n2588 54.9096
R7093 VSS.n971 VSS.t521 48.5111
R7094 VSS.n971 VSS.t515 48.5111
R7095 VSS.n2667 VSS.t1345 48.5111
R7096 VSS.n2667 VSS.t1347 48.5111
R7097 VSS.n2671 VSS.t1347 48.5111
R7098 VSS.n2588 VSS.n1379 45.9047
R7099 VSS.t515 VSS.n966 45.1069
R7100 VSS.t1826 VSS.n2926 43.7671
R7101 VSS.n965 VSS.t517 38.335
R7102 VSS.t507 VSS.n3224 38.335
R7103 VSS.t505 VSS.n3225 38.335
R7104 VSS.t1858 VSS.n3213 38.335
R7105 VSS.t1852 VSS.n915 38.335
R7106 VSS.n2536 VSS.t1110 38.0177
R7107 VSS.n2535 VSS.t1064 38.0177
R7108 VSS.n2519 VSS.t1096 38.0177
R7109 VSS.t1080 VSS.n2521 38.0177
R7110 VSS.n2603 VSS.t1050 38.0177
R7111 VSS.n2602 VSS.t1038 38.0177
R7112 VSS.n2589 VSS.t1036 38.0177
R7113 VSS.n2504 VSS.t1034 32.9629
R7114 VSS.t1313 VSS.n1379 32.1215
R7115 VSS.n2640 VSS.t1343 32.1215
R7116 VSS.n2639 VSS.t1335 32.1215
R7117 VSS.n2987 VSS.t1305 32.1215
R7118 VSS.n2913 VSS.n2912 31.8307
R7119 VSS.n1003 VSS.n994 29.1782
R7120 VSS.n3461 VSS.n3460 29.1782
R7121 VSS.n3498 VSS.t513 27.7873
R7122 VSS.t513 VSS.n964 27.7873
R7123 VSS.t517 VSS.n964 27.7873
R7124 VSS.n3229 VSS.t507 27.7873
R7125 VSS.n3229 VSS.t503 27.7873
R7126 VSS.t503 VSS.n3228 27.7873
R7127 VSS.n3227 VSS.t501 27.7873
R7128 VSS.t501 VSS.n3226 27.7873
R7129 VSS.n3226 VSS.t505 27.7873
R7130 VSS.n3222 VSS.t1858 27.7873
R7131 VSS.n3222 VSS.t1856 27.7873
R7132 VSS.t1854 VSS.n3212 27.7873
R7133 VSS.n3215 VSS.t1854 27.7873
R7134 VSS.n3215 VSS.t1852 27.7873
R7135 VSS.n2509 VSS.t1034 27.5102
R7136 VSS.n2510 VSS.t1006 27.5102
R7137 VSS.t1006 VSS.n2503 27.5102
R7138 VSS.t1110 VSS.n2503 27.5102
R7139 VSS.t1064 VSS.n2534 27.5102
R7140 VSS.n2534 VSS.t1020 27.5102
R7141 VSS.t1020 VSS.n2533 27.5102
R7142 VSS.n2532 VSS.t1126 27.5102
R7143 VSS.n2512 VSS.t1126 27.5102
R7144 VSS.t1096 VSS.n2512 27.5102
R7145 VSS.n2526 VSS.t1080 27.5102
R7146 VSS.n2526 VSS.t1108 27.5102
R7147 VSS.t1108 VSS.n2525 27.5102
R7148 VSS.n1401 VSS.t1124 27.5102
R7149 VSS.t1124 VSS.n1400 27.5102
R7150 VSS.t1050 VSS.n1400 27.5102
R7151 VSS.t1038 VSS.n2601 27.5102
R7152 VSS.n2601 VSS.t1094 27.5102
R7153 VSS.t1094 VSS.n2600 27.5102
R7154 VSS.n2599 VSS.t1114 27.5102
R7155 VSS.n1403 VSS.t1114 27.5102
R7156 VSS.t1036 VSS.n1403 27.5102
R7157 VSS.n3726 VSS.n3725 27.4411
R7158 VSS.n3713 VSS.n3712 27.4411
R7159 VSS.n3700 VSS.n3699 27.4411
R7160 VSS.n3687 VSS.n3686 27.4411
R7161 VSS.n3674 VSS.n3673 27.4411
R7162 VSS.n3661 VSS.n3660 27.4411
R7163 VSS.n3648 VSS.n3647 27.4411
R7164 VSS.n3635 VSS.n3634 27.4411
R7165 VSS.n3622 VSS.n3621 27.4411
R7166 VSS.n3609 VSS.n3608 27.4411
R7167 VSS.n3592 VSS.n3591 27.4411
R7168 VSS.n2645 VSS.n2644 27.4411
R7169 VSS.n2983 VSS.n2982 27.4411
R7170 VSS.n2970 VSS.n2969 27.4411
R7171 VSS.n2951 VSS.n2950 27.4411
R7172 VSS.n2938 VSS.n2937 27.4411
R7173 VSS.n2908 VSS.n2907 27.4411
R7174 VSS.n2895 VSS.n2894 27.4411
R7175 VSS.n3466 VSS.n3465 27.4411
R7176 VSS.n3491 VSS.n3490 27.4411
R7177 VSS.n3503 VSS.n3502 27.4411
R7178 VSS.n1910 VSS.n1909 27.4411
R7179 VSS.n1897 VSS.n1896 27.4411
R7180 VSS.n1884 VSS.n1883 27.4411
R7181 VSS.n1871 VSS.n1870 27.4411
R7182 VSS.n1858 VSS.n1857 27.4411
R7183 VSS.n1845 VSS.n1844 27.4411
R7184 VSS.n1832 VSS.n1831 27.4411
R7185 VSS.n1819 VSS.n1818 27.4411
R7186 VSS.n1806 VSS.n1805 27.4411
R7187 VSS.n1771 VSS.n1770 27.4411
R7188 VSS.n634 VSS.n633 27.4411
R7189 VSS.n659 VSS.n658 27.4411
R7190 VSS.n684 VSS.n683 27.4411
R7191 VSS.n709 VSS.n708 27.4411
R7192 VSS.n734 VSS.n733 27.4411
R7193 VSS.n759 VSS.n758 27.4411
R7194 VSS.n784 VSS.n783 27.4411
R7195 VSS.n809 VSS.n808 27.4411
R7196 VSS.n831 VSS.n830 27.4411
R7197 VSS.n856 VSS.n855 27.4411
R7198 VSS.n898 VSS.n897 27.4411
R7199 VSS.n1383 VSS.t1313 22.4473
R7200 VSS.n1383 VSS.t1315 22.4473
R7201 VSS.n2629 VSS.t1315 22.4473
R7202 VSS.n2630 VSS.t1341 22.4473
R7203 VSS.t1341 VSS.n1378 22.4473
R7204 VSS.t1343 VSS.n1378 22.4473
R7205 VSS.t1335 VSS.n2638 22.4473
R7206 VSS.n2638 VSS.t1333 22.4473
R7207 VSS.t1333 VSS.n2637 22.4473
R7208 VSS.n1367 VSS.t1307 22.4473
R7209 VSS.t1307 VSS.n1365 22.4473
R7210 VSS.n1365 VSS.t1305 22.4473
R7211 VSS.n3243 VSS.n3242 18.525
R7212 VSS.n550 VSS.t576 17.5088
R7213 VSS.n1439 VSS.t1027 17.5088
R7214 VSS.n2076 VSS.t905 17.5088
R7215 VSS.n2376 VSS.t933 17.5088
R7216 VSS.n2109 VSS.t925 17.5088
R7217 VSS.n2507 VSS.t1113 17.5088
R7218 VSS.n1976 VSS.t568 17.5088
R7219 VSS.n38 VSS.t540 17.5088
R7220 VSS.n367 VSS.t1676 17.5088
R7221 VSS.n9 VSS.t602 17.5088
R7222 VSS.n2174 VSS.t440 17.5088
R7223 VSS.n2207 VSS.t338 17.5088
R7224 VSS.n3577 VSS.t131 17.5088
R7225 VSS.n3566 VSS.t1658 17.5088
R7226 VSS.n2017 VSS.t382 17.5088
R7227 VSS.n1967 VSS.t446 17.5088
R7228 VSS.n2133 VSS.t893 17.5088
R7229 VSS.n2474 VSS.t1059 17.5088
R7230 VSS.n1429 VSS.t1089 17.5088
R7231 VSS.n341 VSS.t1260 17.3786
R7232 VSS.n338 VSS.t1262 17.3786
R7233 VSS.n901 VSS.t1266 17.3786
R7234 VSS.n342 VSS.t1264 17.3786
R7235 VSS.n839 VSS.t1276 17.3786
R7236 VSS.n854 VSS.t1286 17.3786
R7237 VSS.n404 VSS.t1284 17.3786
R7238 VSS.n842 VSS.t1270 17.3786
R7239 VSS.n840 VSS.t1268 17.3786
R7240 VSS.n832 VSS.t1256 17.3786
R7241 VSS.n792 VSS.t1258 17.3786
R7242 VSS.n834 VSS.t1272 17.3786
R7243 VSS.n405 VSS.t1274 17.3786
R7244 VSS.n807 VSS.t1600 17.3786
R7245 VSS.n422 VSS.t1598 17.3786
R7246 VSS.n795 VSS.t1280 17.3786
R7247 VSS.n793 VSS.t1282 17.3786
R7248 VSS.n785 VSS.t1644 17.3786
R7249 VSS.n742 VSS.t1642 17.3786
R7250 VSS.n787 VSS.t1636 17.3786
R7251 VSS.n423 VSS.t1634 17.3786
R7252 VSS.n757 VSS.t1602 17.3786
R7253 VSS.n440 VSS.t1604 17.3786
R7254 VSS.n745 VSS.t1614 17.3786
R7255 VSS.n743 VSS.t1616 17.3786
R7256 VSS.n735 VSS.t1622 17.3786
R7257 VSS.n692 VSS.t1624 17.3786
R7258 VSS.n737 VSS.t1650 17.3786
R7259 VSS.n441 VSS.t1652 17.3786
R7260 VSS.n707 VSS.t1436 17.3786
R7261 VSS.n458 VSS.t1434 17.3786
R7262 VSS.n695 VSS.t1608 17.3786
R7263 VSS.n693 VSS.t1606 17.3786
R7264 VSS.n685 VSS.t1374 17.3786
R7265 VSS.n642 VSS.t1376 17.3786
R7266 VSS.n687 VSS.t1398 17.3786
R7267 VSS.n459 VSS.t1400 17.3786
R7268 VSS.n657 VSS.t1384 17.3786
R7269 VSS.n476 VSS.t1382 17.3786
R7270 VSS.n645 VSS.t1422 17.3786
R7271 VSS.n643 VSS.t1424 17.3786
R7272 VSS.n635 VSS.t1420 17.3786
R7273 VSS.n591 VSS.t1418 17.3786
R7274 VSS.n637 VSS.t1414 17.3786
R7275 VSS.n477 VSS.t1416 17.3786
R7276 VSS.n606 VSS.t582 17.3786
R7277 VSS.n541 VSS.t528 17.3786
R7278 VSS.n594 VSS.t1396 17.3786
R7279 VSS.n592 VSS.t1394 17.3786
R7280 VSS.n584 VSS.t562 17.3786
R7281 VSS.n581 VSS.t636 17.3786
R7282 VSS.n586 VSS.t564 17.3786
R7283 VSS.n542 VSS.t624 17.3786
R7284 VSS.n575 VSS.t626 17.3786
R7285 VSS.n557 VSS.t580 17.3786
R7286 VSS.n578 VSS.t630 17.3786
R7287 VSS.n580 VSS.t606 17.3786
R7288 VSS.n2 VSS.t610 17.3786
R7289 VSS.n3791 VSS.t554 17.3786
R7290 VSS.n562 VSS.t644 17.3786
R7291 VSS.n558 VSS.t542 17.3786
R7292 VSS.n0 VSS.t648 17.3786
R7293 VSS.n899 VSS.t1278 17.3786
R7294 VSS.n921 VSS.t1250 17.3786
R7295 VSS.n918 VSS.t1252 17.3786
R7296 VSS.n3553 VSS.t1244 17.3786
R7297 VSS.n922 VSS.t1246 17.3786
R7298 VSS.n957 VSS.t1520 17.3786
R7299 VSS.n954 VSS.t1518 17.3786
R7300 VSS.n3506 VSS.t1508 17.3786
R7301 VSS.n958 VSS.t1506 17.3786
R7302 VSS.n3474 VSS.t1524 17.3786
R7303 VSS.n3489 VSS.t1532 17.3786
R7304 VSS.n977 VSS.t1530 17.3786
R7305 VSS.n3477 VSS.t1504 17.3786
R7306 VSS.n3475 VSS.t1502 17.3786
R7307 VSS.n3467 VSS.t1528 17.3786
R7308 VSS.n2860 VSS.t1526 17.3786
R7309 VSS.n3469 VSS.t1514 17.3786
R7310 VSS.n978 VSS.t1516 17.3786
R7311 VSS.n2896 VSS.t1829 17.3786
R7312 VSS.n2855 VSS.t1831 17.3786
R7313 VSS.n2858 VSS.t1510 17.3786
R7314 VSS.n2861 VSS.t1512 17.3786
R7315 VSS.n2906 VSS.t1833 17.3786
R7316 VSS.n2823 VSS.t1835 17.3786
R7317 VSS.n2852 VSS.t1801 17.3786
R7318 VSS.n2854 VSS.t1803 17.3786
R7319 VSS.n2842 VSS.t1809 17.3786
R7320 VSS.n2839 VSS.t1811 17.3786
R7321 VSS.n2844 VSS.t1807 17.3786
R7322 VSS.n2824 VSS.t1805 17.3786
R7323 VSS.n2939 VSS.t1847 17.3786
R7324 VSS.n2794 VSS.t1845 17.3786
R7325 VSS.n2836 VSS.t1851 17.3786
R7326 VSS.n2838 VSS.t1849 17.3786
R7327 VSS.n2949 VSS.t1300 17.3786
R7328 VSS.n2779 VSS.t1298 17.3786
R7329 VSS.n2791 VSS.t1843 17.3786
R7330 VSS.n2793 VSS.t1841 17.3786
R7331 VSS.n2971 VSS.t1354 17.3786
R7332 VSS.n2659 VSS.t1356 17.3786
R7333 VSS.n2783 VSS.t1358 17.3786
R7334 VSS.n2780 VSS.t1360 17.3786
R7335 VSS.n2981 VSS.t1310 17.3786
R7336 VSS.n1371 VSS.t1312 17.3786
R7337 VSS.n2656 VSS.t1350 17.3786
R7338 VSS.n2658 VSS.t1352 17.3786
R7339 VSS.n2646 VSS.t1318 17.3786
R7340 VSS.n1470 VSS.t1320 17.3786
R7341 VSS.n2648 VSS.t1302 17.3786
R7342 VSS.n1372 VSS.t1304 17.3786
R7343 VSS.n1481 VSS.t1083 17.3786
R7344 VSS.n1465 VSS.t1031 17.3786
R7345 VSS.n1468 VSS.t1330 17.3786
R7346 VSS.n1471 VSS.t1332 17.3786
R7347 VSS.n2447 VSS.t1099 17.3786
R7348 VSS.n1457 VSS.t1043 17.3786
R7349 VSS.n1460 VSS.t1091 17.3786
R7350 VSS.n1464 VSS.t1011 17.3786
R7351 VSS.n2456 VSS.t1013 17.3786
R7352 VSS.n1449 VSS.t1047 17.3786
R7353 VSS.n1452 VSS.t1133 17.3786
R7354 VSS.n1456 VSS.t1023 17.3786
R7355 VSS.n2466 VSS.t1025 17.3786
R7356 VSS.n1437 VSS.t1053 17.3786
R7357 VSS.n1446 VSS.t1107 17.3786
R7358 VSS.n1448 VSS.t1067 17.3786
R7359 VSS.n1438 VSS.t1077 17.3786
R7360 VSS.n3504 VSS.t1522 17.3786
R7361 VSS.n3549 VSS.t767 17.3786
R7362 VSS.n3551 VSS.t763 17.3786
R7363 VSS.n3546 VSS.t761 17.3786
R7364 VSS.n3548 VSS.t765 17.3786
R7365 VSS.n949 VSS.t61 17.3786
R7366 VSS.n948 VSS.t65 17.3786
R7367 VSS.n950 VSS.t57 17.3786
R7368 VSS.n3543 VSS.t67 17.3786
R7369 VSS.n947 VSS.t35 17.3786
R7370 VSS.n1792 VSS.t27 17.3786
R7371 VSS.n1804 VSS.t33 17.3786
R7372 VSS.n1783 VSS.t25 17.3786
R7373 VSS.n1795 VSS.t31 17.3786
R7374 VSS.n1793 VSS.t39 17.3786
R7375 VSS.n1820 VSS.t1731 17.3786
R7376 VSS.n1707 VSS.t1761 17.3786
R7377 VSS.n1787 VSS.t29 17.3786
R7378 VSS.n1784 VSS.t37 17.3786
R7379 VSS.n1830 VSS.t1783 17.3786
R7380 VSS.n1692 VSS.t1769 17.3786
R7381 VSS.n1704 VSS.t1727 17.3786
R7382 VSS.n1706 VSS.t1745 17.3786
R7383 VSS.n1846 VSS.t1753 17.3786
R7384 VSS.n1665 VSS.t1741 17.3786
R7385 VSS.n1696 VSS.t1781 17.3786
R7386 VSS.n1693 VSS.t1735 17.3786
R7387 VSS.n1856 VSS.t1747 17.3786
R7388 VSS.n1650 VSS.t1771 17.3786
R7389 VSS.n1662 VSS.t1749 17.3786
R7390 VSS.n1664 VSS.t1777 17.3786
R7391 VSS.n1872 VSS.t1913 17.3786
R7392 VSS.n1623 VSS.t1881 17.3786
R7393 VSS.n1654 VSS.t1737 17.3786
R7394 VSS.n1651 VSS.t1757 17.3786
R7395 VSS.n1882 VSS.t1899 17.3786
R7396 VSS.n1608 VSS.t1871 17.3786
R7397 VSS.n1620 VSS.t1901 17.3786
R7398 VSS.n1622 VSS.t1867 17.3786
R7399 VSS.n1898 VSS.t1869 17.3786
R7400 VSS.n1581 VSS.t1919 17.3786
R7401 VSS.n1612 VSS.t1883 17.3786
R7402 VSS.n1609 VSS.t1923 17.3786
R7403 VSS.n1908 VSS.t1925 17.3786
R7404 VSS.n1548 VSS.t1911 17.3786
R7405 VSS.n1578 VSS.t1877 17.3786
R7406 VSS.n1580 VSS.t1889 17.3786
R7407 VSS.n1570 VSS.t1907 17.3786
R7408 VSS.n1549 VSS.t1895 17.3786
R7409 VSS.n1503 VSS.t909 17.3786
R7410 VSS.n2414 VSS.t851 17.3786
R7411 VSS.n2411 VSS.t919 17.3786
R7412 VSS.n2416 VSS.t969 17.3786
R7413 VSS.n1504 VSS.t889 17.3786
R7414 VSS.n2405 VSS.t891 17.3786
R7415 VSS.n2080 VSS.t921 17.3786
R7416 VSS.n2408 VSS.t879 17.3786
R7417 VSS.n2410 VSS.t901 17.3786
R7418 VSS.n2101 VSS.t903 17.3786
R7419 VSS.n2074 VSS.t939 17.3786
R7420 VSS.n2083 VSS.t865 17.3786
R7421 VSS.n2081 VSS.t949 17.3786
R7422 VSS.n2075 VSS.t965 17.3786
R7423 VSS.n2423 VSS.t967 17.3786
R7424 VSS.n2432 VSS.t935 17.3786
R7425 VSS.n2442 VSS.t875 17.3786
R7426 VSS.n2388 VSS.t943 17.3786
R7427 VSS.n2429 VSS.t863 17.3786
R7428 VSS.n2431 VSS.t913 17.3786
R7429 VSS.n2400 VSS.t915 17.3786
R7430 VSS.n2365 VSS.t945 17.3786
R7431 VSS.n2391 VSS.t899 17.3786
R7432 VSS.n2389 VSS.t929 17.3786
R7433 VSS.n2381 VSS.t931 17.3786
R7434 VSS.n2378 VSS.t959 17.3786
R7435 VSS.n2383 VSS.t881 17.3786
R7436 VSS.n2366 VSS.t973 17.3786
R7437 VSS.n2377 VSS.t859 17.3786
R7438 VSS.n1497 VSS.t861 17.3786
R7439 VSS.n1568 VSS.t941 17.3786
R7440 VSS.n1565 VSS.t877 17.3786
R7441 VSS.n2349 VSS.t911 17.3786
R7442 VSS.n1521 VSS.t857 17.3786
R7443 VSS.n1562 VSS.t917 17.3786
R7444 VSS.n1564 VSS.t849 17.3786
R7445 VSS.n2359 VSS.t853 17.3786
R7446 VSS.n2113 VSS.t937 17.3786
R7447 VSS.n1518 VSS.t855 17.3786
R7448 VSS.n1520 VSS.t957 17.3786
R7449 VSS.n2125 VSS.t961 17.3786
R7450 VSS.n2107 VSS.t895 17.3786
R7451 VSS.n2116 VSS.t869 17.3786
R7452 VSS.n2114 VSS.t887 17.3786
R7453 VSS.n2108 VSS.t871 17.3786
R7454 VSS.n2596 VSS.t1115 17.3786
R7455 VSS.n2606 VSS.t1051 17.3786
R7456 VSS.n2522 VSS.t1125 17.3786
R7457 VSS.n2593 VSS.t1039 17.3786
R7458 VSS.n2595 VSS.t1095 17.3786
R7459 VSS.n2529 VSS.t1097 17.3786
R7460 VSS.n2517 VSS.t1127 17.3786
R7461 VSS.n2520 VSS.t1081 17.3786
R7462 VSS.n2523 VSS.t1109 17.3786
R7463 VSS.n2539 VSS.t1111 17.3786
R7464 VSS.n2505 VSS.t1007 17.3786
R7465 VSS.n2514 VSS.t1065 17.3786
R7466 VSS.n2516 VSS.t1021 17.3786
R7467 VSS.n2506 VSS.t1035 17.3786
R7468 VSS.n2590 VSS.t1037 17.3786
R7469 VSS.n2984 VSS.t1306 17.3786
R7470 VSS.n2631 VSS.t1308 17.3786
R7471 VSS.n2643 VSS.t1344 17.3786
R7472 VSS.n1380 VSS.t1342 17.3786
R7473 VSS.n2634 VSS.t1336 17.3786
R7474 VSS.n2632 VSS.t1334 17.3786
R7475 VSS.n2626 VSS.t1314 17.3786
R7476 VSS.n1381 VSS.t1316 17.3786
R7477 VSS.n2668 VSS.t1346 17.3786
R7478 VSS.n2665 VSS.t1348 17.3786
R7479 VSS.n2968 VSS.t1326 17.3786
R7480 VSS.n2664 VSS.t1328 17.3786
R7481 VSS.n2774 VSS.t1340 17.3786
R7482 VSS.n2771 VSS.t1322 17.3786
R7483 VSS.n2773 VSS.t1324 17.3786
R7484 VSS.n2922 VSS.t1825 17.3786
R7485 VSS.n2936 VSS.t1795 17.3786
R7486 VSS.n2800 VSS.t1793 17.3786
R7487 VSS.n2919 VSS.t1839 17.3786
R7488 VSS.n2921 VSS.t1837 17.3786
R7489 VSS.n2775 VSS.t1338 17.3786
R7490 VSS.n2804 VSS.t1823 17.3786
R7491 VSS.n2801 VSS.t1821 17.3786
R7492 VSS.n2923 VSS.t1827 17.3786
R7493 VSS.n2814 VSS.t1791 17.3786
R7494 VSS.n2816 VSS.t1789 17.3786
R7495 VSS.n2882 VSS.t145 17.3786
R7496 VSS.n2893 VSS.t1797 17.3786
R7497 VSS.n2873 VSS.t1799 17.3786
R7498 VSS.n2885 VSS.t141 17.3786
R7499 VSS.n2883 VSS.t149 17.3786
R7500 VSS.n2909 VSS.t1813 17.3786
R7501 VSS.n2817 VSS.t1815 17.3786
R7502 VSS.n2877 VSS.t1819 17.3786
R7503 VSS.n2874 VSS.t1817 17.3786
R7504 VSS.n3464 VSS.t137 17.3786
R7505 VSS.n999 VSS.t139 17.3786
R7506 VSS.n3492 VSS.t151 17.3786
R7507 VSS.n996 VSS.t143 17.3786
R7508 VSS.n997 VSS.t147 17.3786
R7509 VSS.n3494 VSS.t522 17.3786
R7510 VSS.n3219 VSS.t1855 17.3786
R7511 VSS.n3214 VSS.t1853 17.3786
R7512 VSS.n3239 VSS.t1859 17.3786
R7513 VSS.n3220 VSS.t1857 17.3786
R7514 VSS.n3235 VSS.t502 17.3786
R7515 VSS.n3237 VSS.t506 17.3786
R7516 VSS.n3232 VSS.t508 17.3786
R7517 VSS.n3234 VSS.t504 17.3786
R7518 VSS.n968 VSS.t514 17.3786
R7519 VSS.n969 VSS.t516 17.3786
R7520 VSS.n3501 VSS.t518 17.3786
R7521 VSS.n1392 VSS.t1093 17.3786
R7522 VSS.n2610 VSS.t1029 17.3786
R7523 VSS.n2550 VSS.t1103 17.3786
R7524 VSS.n2612 VSS.t1019 17.3786
R7525 VSS.n1393 VSS.t1071 17.3786
R7526 VSS.n2624 VSS.t1121 17.3786
R7527 VSS.n1405 VSS.t1061 17.3786
R7528 VSS.n3746 VSS.t646 17.3786
R7529 VSS.n3756 VSS.t556 17.3786
R7530 VSS.n1991 VSS.t622 17.3786
R7531 VSS.n3743 VSS.t558 17.3786
R7532 VSS.n3745 VSS.t618 17.3786
R7533 VSS.n1999 VSS.t590 17.3786
R7534 VSS.n1986 VSS.t574 17.3786
R7535 VSS.n1989 VSS.t620 17.3786
R7536 VSS.n1992 VSS.t598 17.3786
R7537 VSS.n2009 VSS.t600 17.3786
R7538 VSS.n1974 VSS.t544 17.3786
R7539 VSS.n1983 VSS.t638 17.3786
R7540 VSS.n1985 VSS.t536 17.3786
R7541 VSS.n1975 VSS.t640 17.3786
R7542 VSS.n68 VSS.t578 17.3786
R7543 VSS.n499 VSS.t616 17.3786
R7544 VSS.n3761 VSS.t530 17.3786
R7545 VSS.n56 VSS.t596 17.3786
R7546 VSS.n503 VSS.t534 17.3786
R7547 VSS.n500 VSS.t586 17.3786
R7548 VSS.n3771 VSS.t592 17.3786
R7549 VSS.n27 VSS.t548 17.3786
R7550 VSS.n53 VSS.t594 17.3786
R7551 VSS.n55 VSS.t566 17.3786
R7552 VSS.n43 VSS.t570 17.3786
R7553 VSS.n40 VSS.t642 17.3786
R7554 VSS.n45 VSS.t604 17.3786
R7555 VSS.n28 VSS.t634 17.3786
R7556 VSS.n39 VSS.t614 17.3786
R7557 VSS.n495 VSS.t550 17.3786
R7558 VSS.n857 VSS.t95 17.3786
R7559 VSS.n817 VSS.t87 17.3786
R7560 VSS.n829 VSS.t93 17.3786
R7561 VSS.n413 VSS.t85 17.3786
R7562 VSS.n820 VSS.t91 17.3786
R7563 VSS.n818 VSS.t99 17.3786
R7564 VSS.n810 VSS.t1654 17.3786
R7565 VSS.n767 VSS.t1656 17.3786
R7566 VSS.n812 VSS.t89 17.3786
R7567 VSS.n414 VSS.t97 17.3786
R7568 VSS.n782 VSS.t1596 17.3786
R7569 VSS.n431 VSS.t1594 17.3786
R7570 VSS.n770 VSS.t1626 17.3786
R7571 VSS.n768 VSS.t1628 17.3786
R7572 VSS.n760 VSS.t1640 17.3786
R7573 VSS.n717 VSS.t1638 17.3786
R7574 VSS.n762 VSS.t1632 17.3786
R7575 VSS.n432 VSS.t1630 17.3786
R7576 VSS.n732 VSS.t1618 17.3786
R7577 VSS.n449 VSS.t1620 17.3786
R7578 VSS.n720 VSS.t1610 17.3786
R7579 VSS.n718 VSS.t1612 17.3786
R7580 VSS.n710 VSS.t1388 17.3786
R7581 VSS.n667 VSS.t1386 17.3786
R7582 VSS.n712 VSS.t1646 17.3786
R7583 VSS.n450 VSS.t1648 17.3786
R7584 VSS.n682 VSS.t1428 17.3786
R7585 VSS.n467 VSS.t1426 17.3786
R7586 VSS.n670 VSS.t1432 17.3786
R7587 VSS.n668 VSS.t1430 17.3786
R7588 VSS.n660 VSS.t1402 17.3786
R7589 VSS.n617 VSS.t1404 17.3786
R7590 VSS.n662 VSS.t1378 17.3786
R7591 VSS.n468 VSS.t1380 17.3786
R7592 VSS.n632 VSS.t1392 17.3786
R7593 VSS.n485 VSS.t1390 17.3786
R7594 VSS.n620 VSS.t1410 17.3786
R7595 VSS.n618 VSS.t1412 17.3786
R7596 VSS.n612 VSS.t1408 17.3786
R7597 VSS.n486 VSS.t1406 17.3786
R7598 VSS.n886 VSS.t1368 17.3786
R7599 VSS.n896 VSS.t23 17.3786
R7600 VSS.n394 VSS.t19 17.3786
R7601 VSS.n883 VSS.t1362 17.3786
R7602 VSS.n885 VSS.t1364 17.3786
R7603 VSS.n392 VSS.t21 17.3786
R7604 VSS.n395 VSS.t13 17.3786
R7605 VSS.n353 VSS.t1366 17.3786
R7606 VSS.n358 VSS.t169 17.3786
R7607 VSS.n871 VSS.t171 17.3786
R7608 VSS.n359 VSS.t175 17.3786
R7609 VSS.n878 VSS.t173 17.3786
R7610 VSS.n369 VSS.t1670 17.3786
R7611 VSS.n368 VSS.t1674 17.3786
R7612 VSS.n365 VSS.t1672 17.3786
R7613 VSS.n610 VSS.t612 17.3786
R7614 VSS.n536 VSS.t552 17.3786
R7615 VSS.n530 VSS.t584 17.3786
R7616 VSS.n527 VSS.t532 17.3786
R7617 VSS.n533 VSS.t588 17.3786
R7618 VSS.n535 VSS.t650 17.3786
R7619 VSS.n3776 VSS.t652 17.3786
R7620 VSS.n19 VSS.t608 17.3786
R7621 VSS.n524 VSS.t526 17.3786
R7622 VSS.n526 VSS.t628 17.3786
R7623 VSS.n3786 VSS.t632 17.3786
R7624 VSS.n7 VSS.t572 17.3786
R7625 VSS.n16 VSS.t538 17.3786
R7626 VSS.n18 VSS.t560 17.3786
R7627 VSS.n8 VSS.t546 17.3786
R7628 VSS.n1924 VSS.t406 17.3786
R7629 VSS.n2320 VSS.t448 17.3786
R7630 VSS.n2317 VSS.t450 17.3786
R7631 VSS.n2322 VSS.t368 17.3786
R7632 VSS.n1925 VSS.t370 17.3786
R7633 VSS.n2311 VSS.t358 17.3786
R7634 VSS.n2178 VSS.t356 17.3786
R7635 VSS.n2314 VSS.t354 17.3786
R7636 VSS.n2316 VSS.t352 17.3786
R7637 VSS.n2199 VSS.t426 17.3786
R7638 VSS.n2172 VSS.t424 17.3786
R7639 VSS.n2181 VSS.t376 17.3786
R7640 VSS.n2179 VSS.t378 17.3786
R7641 VSS.n2173 VSS.t442 17.3786
R7642 VSS.n2329 VSS.t404 17.3786
R7643 VSS.n2260 VSS.t342 17.3786
R7644 VSS.n2296 VSS.t390 17.3786
R7645 VSS.n1942 VSS.t388 17.3786
R7646 VSS.n2264 VSS.t386 17.3786
R7647 VSS.n2261 VSS.t384 17.3786
R7648 VSS.n2306 VSS.t434 17.3786
R7649 VSS.n2211 VSS.t432 17.3786
R7650 VSS.n1939 VSS.t430 17.3786
R7651 VSS.n1941 VSS.t428 17.3786
R7652 VSS.n2223 VSS.t436 17.3786
R7653 VSS.n2205 VSS.t438 17.3786
R7654 VSS.n2214 VSS.t392 17.3786
R7655 VSS.n2212 VSS.t394 17.3786
R7656 VSS.n2206 VSS.t336 17.3786
R7657 VSS.n2256 VSS.t340 17.3786
R7658 VSS.n3590 VSS.t993 17.3786
R7659 VSS.n283 VSS.t1001 17.3786
R7660 VSS.n3610 VSS.t189 17.3786
R7661 VSS.n260 VSS.t181 17.3786
R7662 VSS.n287 VSS.t991 17.3786
R7663 VSS.n284 VSS.t999 17.3786
R7664 VSS.n3620 VSS.t187 17.3786
R7665 VSS.n245 VSS.t179 17.3786
R7666 VSS.n257 VSS.t185 17.3786
R7667 VSS.n259 VSS.t177 17.3786
R7668 VSS.n3636 VSS.t1226 17.3786
R7669 VSS.n218 VSS.t1228 17.3786
R7670 VSS.n249 VSS.t183 17.3786
R7671 VSS.n246 VSS.t191 17.3786
R7672 VSS.n3646 VSS.t1198 17.3786
R7673 VSS.n203 VSS.t1200 17.3786
R7674 VSS.n215 VSS.t1222 17.3786
R7675 VSS.n217 VSS.t1224 17.3786
R7676 VSS.n3662 VSS.t1196 17.3786
R7677 VSS.n176 VSS.t1194 17.3786
R7678 VSS.n207 VSS.t1230 17.3786
R7679 VSS.n204 VSS.t1232 17.3786
R7680 VSS.n3672 VSS.t1190 17.3786
R7681 VSS.n161 VSS.t1192 17.3786
R7682 VSS.n173 VSS.t1182 17.3786
R7683 VSS.n175 VSS.t1184 17.3786
R7684 VSS.n3688 VSS.t1460 17.3786
R7685 VSS.n134 VSS.t1458 17.3786
R7686 VSS.n165 VSS.t1238 17.3786
R7687 VSS.n162 VSS.t1240 17.3786
R7688 VSS.n3698 VSS.t1488 17.3786
R7689 VSS.n119 VSS.t1486 17.3786
R7690 VSS.n131 VSS.t1448 17.3786
R7691 VSS.n133 VSS.t1446 17.3786
R7692 VSS.n3714 VSS.t1500 17.3786
R7693 VSS.n92 VSS.t1498 17.3786
R7694 VSS.n123 VSS.t1464 17.3786
R7695 VSS.n120 VSS.t1462 17.3786
R7696 VSS.n3724 VSS.t1442 17.3786
R7697 VSS.n2273 VSS.t1444 17.3786
R7698 VSS.n89 VSS.t1438 17.3786
R7699 VSS.n91 VSS.t1440 17.3786
R7700 VSS.n2253 VSS.t1480 17.3786
R7701 VSS.n2274 VSS.t1478 17.3786
R7702 VSS.n3579 VSS.t129 17.3786
R7703 VSS.n3578 VSS.t135 17.3786
R7704 VSS.n298 VSS.t133 17.3786
R7705 VSS.n3564 VSS.t1662 17.3786
R7706 VSS.n3565 VSS.t1660 17.3786
R7707 VSS.n3573 VSS.t1664 17.3786
R7708 VSS.n306 VSS.t1574 17.3786
R7709 VSS.n310 VSS.t1566 17.3786
R7710 VSS.n307 VSS.t1568 17.3786
R7711 VSS.n303 VSS.t1576 17.3786
R7712 VSS.n322 VSS.t1552 17.3786
R7713 VSS.n319 VSS.t1550 17.3786
R7714 VSS.n326 VSS.t1534 17.3786
R7715 VSS.n323 VSS.t1536 17.3786
R7716 VSS.n3597 VSS.t1538 17.3786
R7717 VSS.n3607 VSS.t1564 17.3786
R7718 VSS.n266 VSS.t1562 17.3786
R7719 VSS.n3594 VSS.t1544 17.3786
R7720 VSS.n3596 VSS.t1542 17.3786
R7721 VSS.n3623 VSS.t1556 17.3786
R7722 VSS.n239 VSS.t1554 17.3786
R7723 VSS.n270 VSS.t1546 17.3786
R7724 VSS.n267 VSS.t1548 17.3786
R7725 VSS.n3633 VSS.t1202 17.3786
R7726 VSS.n224 VSS.t1204 17.3786
R7727 VSS.n236 VSS.t1558 17.3786
R7728 VSS.n238 VSS.t1560 17.3786
R7729 VSS.n3649 VSS.t1188 17.3786
R7730 VSS.n197 VSS.t1186 17.3786
R7731 VSS.n228 VSS.t1178 17.3786
R7732 VSS.n225 VSS.t1180 17.3786
R7733 VSS.n3659 VSS.t1236 17.3786
R7734 VSS.n182 VSS.t1234 17.3786
R7735 VSS.n194 VSS.t1212 17.3786
R7736 VSS.n196 VSS.t1210 17.3786
R7737 VSS.n3675 VSS.t1214 17.3786
R7738 VSS.n155 VSS.t1216 17.3786
R7739 VSS.n186 VSS.t1218 17.3786
R7740 VSS.n183 VSS.t1220 17.3786
R7741 VSS.n3685 VSS.t1492 17.3786
R7742 VSS.n140 VSS.t1490 17.3786
R7743 VSS.n152 VSS.t1206 17.3786
R7744 VSS.n154 VSS.t1208 17.3786
R7745 VSS.n3701 VSS.t1456 17.3786
R7746 VSS.n113 VSS.t1454 17.3786
R7747 VSS.n144 VSS.t1452 17.3786
R7748 VSS.n141 VSS.t1450 17.3786
R7749 VSS.n3711 VSS.t1474 17.3786
R7750 VSS.n98 VSS.t1476 17.3786
R7751 VSS.n110 VSS.t1470 17.3786
R7752 VSS.n112 VSS.t1472 17.3786
R7753 VSS.n3727 VSS.t1468 17.3786
R7754 VSS.n80 VSS.t1466 17.3786
R7755 VSS.n102 VSS.t1494 17.3786
R7756 VSS.n99 VSS.t1496 17.3786
R7757 VSS.n3737 VSS.t458 17.3786
R7758 VSS.n2040 VSS.t456 17.3786
R7759 VSS.n77 VSS.t1484 17.3786
R7760 VSS.n79 VSS.t1482 17.3786
R7761 VSS.n2048 VSS.t410 17.3786
R7762 VSS.n2035 VSS.t408 17.3786
R7763 VSS.n2038 VSS.t360 17.3786
R7764 VSS.n2041 VSS.t362 17.3786
R7765 VSS.n2058 VSS.t350 17.3786
R7766 VSS.n2027 VSS.t348 17.3786
R7767 VSS.n2030 VSS.t334 17.3786
R7768 VSS.n2034 VSS.t332 17.3786
R7769 VSS.n2068 VSS.t418 17.3786
R7770 VSS.n2015 VSS.t416 17.3786
R7771 VSS.n2024 VSS.t364 17.3786
R7772 VSS.n2026 VSS.t366 17.3786
R7773 VSS.n2016 VSS.t380 17.3786
R7774 VSS.n279 VSS.t1540 17.3786
R7775 VSS.n2281 VSS.t414 17.3786
R7776 VSS.n2250 VSS.t412 17.3786
R7777 VSS.n2291 VSS.t454 17.3786
R7778 VSS.n1948 VSS.t452 17.3786
R7779 VSS.n2247 VSS.t402 17.3786
R7780 VSS.n2249 VSS.t400 17.3786
R7781 VSS.n2237 VSS.t420 17.3786
R7782 VSS.n2234 VSS.t422 17.3786
R7783 VSS.n2239 VSS.t344 17.3786
R7784 VSS.n1949 VSS.t346 17.3786
R7785 VSS.n2228 VSS.t372 17.3786
R7786 VSS.n1969 VSS.t374 17.3786
R7787 VSS.n2231 VSS.t396 17.3786
R7788 VSS.n2233 VSS.t398 17.3786
R7789 VSS.n1968 VSS.t444 17.3786
R7790 VSS.n1751 VSS.t312 17.3786
R7791 VSS.n1749 VSS.t314 17.3786
R7792 VSS.n1744 VSS.t318 17.3786
R7793 VSS.n1750 VSS.t316 17.3786
R7794 VSS.n1762 VSS.t308 17.3786
R7795 VSS.n1772 VSS.t322 17.3786
R7796 VSS.n1736 VSS.t320 17.3786
R7797 VSS.n1739 VSS.t326 17.3786
R7798 VSS.n1761 VSS.t324 17.3786
R7799 VSS.n1807 VSS.t300 17.3786
R7800 VSS.n1728 VSS.t302 17.3786
R7801 VSS.n1731 VSS.t328 17.3786
R7802 VSS.n1735 VSS.t330 17.3786
R7803 VSS.n1817 VSS.t1775 17.3786
R7804 VSS.n1713 VSS.t1751 17.3786
R7805 VSS.n1725 VSS.t304 17.3786
R7806 VSS.n1727 VSS.t306 17.3786
R7807 VSS.n1833 VSS.t1767 17.3786
R7808 VSS.n1686 VSS.t1755 17.3786
R7809 VSS.n1717 VSS.t1773 17.3786
R7810 VSS.n1714 VSS.t1725 17.3786
R7811 VSS.n1843 VSS.t1739 17.3786
R7812 VSS.n1671 VSS.t1787 17.3786
R7813 VSS.n1683 VSS.t1765 17.3786
R7814 VSS.n1685 VSS.t1779 17.3786
R7815 VSS.n1859 VSS.t1729 17.3786
R7816 VSS.n1644 VSS.t1759 17.3786
R7817 VSS.n1675 VSS.t1733 17.3786
R7818 VSS.n1672 VSS.t1763 17.3786
R7819 VSS.n1869 VSS.t1897 17.3786
R7820 VSS.n1629 VSS.t1865 17.3786
R7821 VSS.n1641 VSS.t1785 17.3786
R7822 VSS.n1643 VSS.t1743 17.3786
R7823 VSS.n1885 VSS.t1885 17.3786
R7824 VSS.n1602 VSS.t1921 17.3786
R7825 VSS.n1633 VSS.t1887 17.3786
R7826 VSS.n1630 VSS.t1915 17.3786
R7827 VSS.n1895 VSS.t1917 17.3786
R7828 VSS.n1587 VSS.t1903 17.3786
R7829 VSS.n1599 VSS.t1873 17.3786
R7830 VSS.n1601 VSS.t1905 17.3786
R7831 VSS.n1911 VSS.t1909 17.3786
R7832 VSS.n1542 VSS.t1893 17.3786
R7833 VSS.n1591 VSS.t1927 17.3786
R7834 VSS.n1588 VSS.t1875 17.3786
R7835 VSS.n2334 VSS.t907 17.3786
R7836 VSS.n1534 VSS.t847 17.3786
R7837 VSS.n1537 VSS.t1891 17.3786
R7838 VSS.n1541 VSS.t1879 17.3786
R7839 VSS.n2344 VSS.t883 17.3786
R7840 VSS.n2148 VSS.t955 17.3786
R7841 VSS.n1531 VSS.t885 17.3786
R7842 VSS.n1533 VSS.t947 17.3786
R7843 VSS.n2156 VSS.t951 17.3786
R7844 VSS.n2143 VSS.t897 17.3786
R7845 VSS.n2146 VSS.t953 17.3786
R7846 VSS.n2149 VSS.t923 17.3786
R7847 VSS.n2166 VSS.t927 17.3786
R7848 VSS.n2131 VSS.t873 17.3786
R7849 VSS.n2140 VSS.t963 17.3786
R7850 VSS.n2142 VSS.t867 17.3786
R7851 VSS.n2132 VSS.t971 17.3786
R7852 VSS.n1759 VSS.t310 17.3786
R7853 VSS.n2579 VSS.t1129 17.3786
R7854 VSS.n2576 VSS.t1069 17.3786
R7855 VSS.n2581 VSS.t1123 17.3786
R7856 VSS.n1406 VSS.t1045 17.3786
R7857 VSS.n2570 VSS.t1049 17.3786
R7858 VSS.n2478 VSS.t1073 17.3786
R7859 VSS.n2573 VSS.t1033 17.3786
R7860 VSS.n2575 VSS.t1055 17.3786
R7861 VSS.n2499 VSS.t1057 17.3786
R7862 VSS.n2472 VSS.t1079 17.3786
R7863 VSS.n2481 VSS.t1009 17.3786
R7864 VSS.n2479 VSS.t1101 17.3786
R7865 VSS.n2473 VSS.t1117 17.3786
R7866 VSS.n2565 VSS.t1075 17.3786
R7867 VSS.n1418 VSS.t1105 17.3786
R7868 VSS.n2553 VSS.t1063 17.3786
R7869 VSS.n2551 VSS.t1085 17.3786
R7870 VSS.n2543 VSS.t1087 17.3786
R7871 VSS.n1431 VSS.t1119 17.3786
R7872 VSS.n2545 VSS.t1041 17.3786
R7873 VSS.n1419 VSS.t1131 17.3786
R7874 VSS.n1430 VSS.t1015 17.3786
R7875 VSS.n2619 VSS.t1017 17.3786
R7876 VSS.n1181 VSS.t820 17.3511
R7877 VSS.n1353 VSS.t836 17.3511
R7878 VSS.n1174 VSS.t816 17.3511
R7879 VSS.n1176 VSS.t837 17.3511
R7880 VSS.n1339 VSS.t814 17.3511
R7881 VSS.n1153 VSS.t823 17.3511
R7882 VSS.n1168 VSS.t1948 17.3511
R7883 VSS.n1325 VSS.t1931 17.3511
R7884 VSS.n1161 VSS.t1937 17.3511
R7885 VSS.n1163 VSS.t1933 17.3511
R7886 VSS.n1107 VSS.t713 17.3511
R7887 VSS.n1103 VSS.t701 17.3511
R7888 VSS.n1096 VSS.t698 17.3511
R7889 VSS.n1098 VSS.t716 17.3511
R7890 VSS.n3188 VSS.t709 17.3511
R7891 VSS.n1067 VSS.t718 17.3511
R7892 VSS.n1090 VSS.t1702 17.3511
R7893 VSS.n1055 VSS.t1697 17.3511
R7894 VSS.n1058 VSS.t1704 17.3511
R7895 VSS.n1060 VSS.t1695 17.3511
R7896 VSS.n1072 VSS.t1719 17.3511
R7897 VSS.n1144 VSS.t209 17.3511
R7898 VSS.n1305 VSS.t229 17.3511
R7899 VSS.n1137 VSS.t223 17.3511
R7900 VSS.n1139 VSS.t215 17.3511
R7901 VSS.n1291 VSS.t225 17.3511
R7902 VSS.n1116 VSS.t239 17.3511
R7903 VSS.n1131 VSS.t1139 17.3511
R7904 VSS.n3293 VSS.t1135 17.3511
R7905 VSS.n1124 VSS.t1141 17.3511
R7906 VSS.n1126 VSS.t1149 17.3511
R7907 VSS.n1121 VSS.t1146 17.3511
R7908 VSS.n1158 VSS.t1958 17.3511
R7909 VSS.n930 VSS.t63 17.3133
R7910 VSS.n940 VSS.t520 17.3133
R7911 VSS.n939 VSS.t524 17.3133
R7912 VSS.n938 VSS.t59 17.3133
R7913 VSS.n935 VSS.t53 17.3133
R7914 VSS.n932 VSS.t55 17.3133
R7915 VSS.n3164 VSS.t75 17.3133
R7916 VSS.n3162 VSS.t71 17.3133
R7917 VSS.n3169 VSS.t83 17.3133
R7918 VSS.n3160 VSS.t77 17.3133
R7919 VSS.n3173 VSS.t79 17.3133
R7920 VSS.n3183 VSS.t735 17.3133
R7921 VSS.n3152 VSS.t739 17.3133
R7922 VSS.n3178 VSS.t73 17.3133
R7923 VSS.n3156 VSS.t81 17.3133
R7924 VSS.n3415 VSS.t737 17.3133
R7925 VSS.n1036 VSS.t733 17.3133
R7926 VSS.n1034 VSS.t510 17.3133
R7927 VSS.n3421 VSS.t512 17.3133
R7928 VSS.n1026 VSS.t672 17.3133
R7929 VSS.n1024 VSS.t682 17.3133
R7930 VSS.n3432 VSS.t676 17.3133
R7931 VSS.n1028 VSS.t680 17.3133
R7932 VSS.n3427 VSS.t684 17.3133
R7933 VSS.n1030 VSS.t674 17.3133
R7934 VSS.n3422 VSS.t1143 17.3133
R7935 VSS.n3444 VSS.t117 17.3133
R7936 VSS.n2721 VSS.t115 17.3133
R7937 VSS.n3439 VSS.t678 17.3133
R7938 VSS.n1022 VSS.t670 17.3133
R7939 VSS.n2727 VSS.t119 17.3133
R7940 VSS.n2722 VSS.t113 17.3133
R7941 VSS.n2719 VSS.t167 17.3133
R7942 VSS.n2733 VSS.t165 17.3133
R7943 VSS.n2711 VSS.t666 17.3133
R7944 VSS.n2706 VSS.t660 17.3133
R7945 VSS.n2744 VSS.t664 17.3133
R7946 VSS.n2713 VSS.t654 17.3133
R7947 VSS.n2739 VSS.t662 17.3133
R7948 VSS.n2715 VSS.t668 17.3133
R7949 VSS.n2734 VSS.t1955 17.3133
R7950 VSS.n2756 VSS.t121 17.3133
R7951 VSS.n2682 VSS.t123 17.3133
R7952 VSS.n2751 VSS.t656 17.3133
R7953 VSS.n2704 VSS.t658 17.3133
R7954 VSS.n2684 VSS.t127 17.3133
R7955 VSS.n2683 VSS.t125 17.3133
R7956 VSS.n2696 VSS.t1005 17.3133
R7957 VSS.n2687 VSS.t1003 17.3133
R7958 VSS.n2688 VSS.t1721 17.3133
R7959 VSS.n3158 VSS.t69 17.3133
R7960 VSS.n2760 VSS.t1668 17.3133
R7961 VSS.n2675 VSS.t1666 17.3133
R7962 VSS.n2957 VSS.t1678 17.3133
R7963 VSS.n2763 VSS.t1680 17.3133
R7964 VSS.n3450 VSS.t1372 17.3133
R7965 VSS.n2762 VSS.t1370 17.3133
R7966 VSS.n3449 VSS.t1570 17.3133
R7967 VSS.n3455 VSS.t1572 17.3133
R7968 VSS.n1005 VSS.t1242 17.3133
R7969 VSS.n990 VSS.t1248 17.3133
R7970 VSS.n3456 VSS.t1861 17.3133
R7971 VSS.n988 VSS.t1863 17.3133
R7972 VSS.n1250 VSS.t231 17.3133
R7973 VSS.n1256 VSS.t789 17.3133
R7974 VSS.n1253 VSS.t791 17.3133
R7975 VSS.n1261 VSS.t690 17.3133
R7976 VSS.n3197 VSS.t753 17.3133
R7977 VSS.n1267 VSS.t749 17.3133
R7978 VSS.n3196 VSS.t686 17.3133
R7979 VSS.n1262 VSS.t688 17.3133
R7980 VSS.n3143 VSS.t745 17.3133
R7981 VSS.n1273 VSS.t747 17.3133
R7982 VSS.n3142 VSS.t755 17.3133
R7983 VSS.n1268 VSS.t759 17.3133
R7984 VSS.n3126 VSS.t288 17.3133
R7985 VSS.n1285 VSS.t286 17.3133
R7986 VSS.n3125 VSS.t109 17.3133
R7987 VSS.n1280 VSS.t111 17.3133
R7988 VSS.n1277 VSS.t835 17.3133
R7989 VSS.n1276 VSS.t751 17.3133
R7990 VSS.n1274 VSS.t757 17.3133
R7991 VSS.n3118 VSS.t262 17.3133
R7992 VSS.n3084 VSS.t260 17.3133
R7993 VSS.n3117 VSS.t290 17.3133
R7994 VSS.n1286 VSS.t292 17.3133
R7995 VSS.n3093 VSS.t256 17.3133
R7996 VSS.n1313 VSS.t258 17.3133
R7997 VSS.n3087 VSS.t250 17.3133
R7998 VSS.n3085 VSS.t254 17.3133
R7999 VSS.n3070 VSS.t470 17.3133
R8000 VSS.n3024 VSS.t468 17.3133
R8001 VSS.n3069 VSS.t741 17.3133
R8002 VSS.n1320 VSS.t743 17.3133
R8003 VSS.n1317 VSS.t703 17.3133
R8004 VSS.n1316 VSS.t264 17.3133
R8005 VSS.n1314 VSS.t252 17.3133
R8006 VSS.n3033 VSS.t480 17.3133
R8007 VSS.n1347 VSS.t476 17.3133
R8008 VSS.n3027 VSS.t472 17.3133
R8009 VSS.n3025 VSS.t474 17.3133
R8010 VSS.n3016 VSS.t490 17.3133
R8011 VSS.n2990 VSS.t488 17.3133
R8012 VSS.n3015 VSS.t484 17.3133
R8013 VSS.n1348 VSS.t486 17.3133
R8014 VSS.n2993 VSS.t478 17.3133
R8015 VSS.n2991 VSS.t482 17.3133
R8016 VSS.n1257 VSS.t692 17.3133
R8017 VSS.n3246 VSS.t201 17.3133
R8018 VSS.n1249 VSS.t195 17.3133
R8019 VSS.n3251 VSS.t207 17.3133
R8020 VSS.n1247 VSS.t203 17.3133
R8021 VSS.n3256 VSS.t199 17.3133
R8022 VSS.n1241 VSS.t153 17.3133
R8023 VSS.n1239 VSS.t157 17.3133
R8024 VSS.n3261 VSS.t197 17.3133
R8025 VSS.n1243 VSS.t205 17.3133
R8026 VSS.n3268 VSS.t155 17.3133
R8027 VSS.n1237 VSS.t159 17.3133
R8028 VSS.n1235 VSS.t282 17.3133
R8029 VSS.n3274 VSS.t284 17.3133
R8030 VSS.n3290 VSS.t979 17.3133
R8031 VSS.n3105 VSS.t987 17.3133
R8032 VSS.n3285 VSS.t977 17.3133
R8033 VSS.n1229 VSS.t983 17.3133
R8034 VSS.n3280 VSS.t989 17.3133
R8035 VSS.n1231 VSS.t981 17.3133
R8036 VSS.n3275 VSS.t298 17.3133
R8037 VSS.n3113 VSS.t105 17.3133
R8038 VSS.n1299 VSS.t103 17.3133
R8039 VSS.n3108 VSS.t985 17.3133
R8040 VSS.n3106 VSS.t975 17.3133
R8041 VSS.n1301 VSS.t107 17.3133
R8042 VSS.n1300 VSS.t101 17.3133
R8043 VSS.n3097 VSS.t163 17.3133
R8044 VSS.n3049 VSS.t161 17.3133
R8045 VSS.n3065 VSS.t1592 17.3133
R8046 VSS.n1333 VSS.t1580 17.3133
R8047 VSS.n3060 VSS.t1586 17.3133
R8048 VSS.n3045 VSS.t1578 17.3133
R8049 VSS.n3055 VSS.t1582 17.3133
R8050 VSS.n3047 VSS.t1588 17.3133
R8051 VSS.n3050 VSS.t1254 17.3133
R8052 VSS.n3037 VSS.t1294 17.3133
R8053 VSS.n3003 VSS.t1290 17.3133
R8054 VSS.n1335 VSS.t1590 17.3133
R8055 VSS.n1334 VSS.t1584 17.3133
R8056 VSS.n3006 VSS.t1296 17.3133
R8057 VSS.n3004 VSS.t1292 17.3133
R8058 VSS.n3011 VSS.t49 17.3133
R8059 VSS.n1360 VSS.t51 17.3133
R8060 VSS.n1361 VSS.t1288 17.3133
R8061 VSS.n1245 VSS.t193 17.3133
R8062 VSS.n3311 VSS.t1723 17.3133
R8063 VSS.n3309 VSS.t799 17.3133
R8064 VSS.n3300 VSS.t1 17.3133
R8065 VSS.n1221 VSS.t5 17.3133
R8066 VSS.n3316 VSS.t787 17.3133
R8067 VSS.n3302 VSS.t785 17.3133
R8068 VSS.n1217 VSS.t270 17.3133
R8069 VSS.n1214 VSS.t280 17.3133
R8070 VSS.n3324 VSS.t3 17.3133
R8071 VSS.n1219 VSS.t7 17.3133
R8072 VSS.n1210 VSS.t274 17.3133
R8073 VSS.n1208 VSS.t266 17.3133
R8074 VSS.n3332 VSS.t272 17.3133
R8075 VSS.n1212 VSS.t278 17.3133
R8076 VSS.n1206 VSS.t268 17.3133
R8077 VSS.n3344 VSS.t1176 17.3133
R8078 VSS.n3342 VSS.t276 17.3133
R8079 VSS.n1202 VSS.t464 17.3133
R8080 VSS.n1200 VSS.t462 17.3133
R8081 VSS.n3349 VSS.t294 17.3133
R8082 VSS.n1204 VSS.t296 17.3133
R8083 VSS.n1196 VSS.t779 17.3133
R8084 VSS.n1194 VSS.t773 17.3133
R8085 VSS.n3357 VSS.t466 17.3133
R8086 VSS.n1198 VSS.t460 17.3133
R8087 VSS.n1190 VSS.t771 17.3133
R8088 VSS.n3372 VSS.t769 17.3133
R8089 VSS.n3365 VSS.t783 17.3133
R8090 VSS.n1192 VSS.t777 17.3133
R8091 VSS.n3373 VSS.t775 17.3133
R8092 VSS.n1187 VSS.t781 17.3133
R8093 VSS.n1077 VSS.t1682 17.3133
R8094 VSS.n1082 VSS.t1174 17.3133
R8095 VSS.n1081 VSS.t1172 17.3133
R8096 VSS.n3392 VSS.t45 17.3133
R8097 VSS.n1047 VSS.t797 17.3133
R8098 VSS.n1045 VSS.t807 17.3133
R8099 VSS.n3397 VSS.t43 17.3133
R8100 VSS.n1049 VSS.t47 17.3133
R8101 VSS.n3411 VSS.t805 17.3133
R8102 VSS.n3304 VSS.t803 17.3133
R8103 VSS.n3405 VSS.t801 17.3133
R8104 VSS.n1043 VSS.t795 17.3133
R8105 VSS.n3305 VSS.t793 17.3133
R8106 VSS.n386 VSS.t995 17.3133
R8107 VSS.n385 VSS.t997 17.3133
R8108 VSS.n384 VSS.t15 17.3133
R8109 VSS.n381 VSS.t9 17.3133
R8110 VSS.n380 VSS.t11 17.3133
R8111 VSS.n870 VSS.t17 17.3133
R8112 VSS.n1051 VSS.t41 17.3133
R8113 VSS.n2955 VSS.t1337 17.2419
R8114 VSS.n1182 VSS.t824 17.0005
R8115 VSS.n1181 VSS.t831 17.0005
R8116 VSS.n1354 VSS.t838 17.0005
R8117 VSS.n1353 VSS.t811 17.0005
R8118 VSS.n1175 VSS.t818 17.0005
R8119 VSS.n1174 VSS.t829 17.0005
R8120 VSS.n1177 VSS.t809 17.0005
R8121 VSS.n1176 VSS.t813 17.0005
R8122 VSS.n1340 VSS.t817 17.0005
R8123 VSS.n1339 VSS.t821 17.0005
R8124 VSS.n1154 VSS.t826 17.0005
R8125 VSS.n1153 VSS.t833 17.0005
R8126 VSS.n1169 VSS.t1950 17.0005
R8127 VSS.n1168 VSS.t1942 17.0005
R8128 VSS.n1326 VSS.t1934 17.0005
R8129 VSS.n1325 VSS.t1929 17.0005
R8130 VSS.n1162 VSS.t1941 17.0005
R8131 VSS.n1161 VSS.t1951 17.0005
R8132 VSS.n1164 VSS.t1935 17.0005
R8133 VSS.n1163 VSS.t1946 17.0005
R8134 VSS.n1108 VSS.t719 17.0005
R8135 VSS.n1107 VSS.t726 17.0005
R8136 VSS.n1104 VSS.t694 17.0005
R8137 VSS.n1103 VSS.t706 17.0005
R8138 VSS.n1097 VSS.t699 17.0005
R8139 VSS.n1096 VSS.t714 17.0005
R8140 VSS.n1099 VSS.t696 17.0005
R8141 VSS.n1098 VSS.t707 17.0005
R8142 VSS.n3189 VSS.t711 17.0005
R8143 VSS.n3188 VSS.t704 17.0005
R8144 VSS.n1068 VSS.t722 17.0005
R8145 VSS.n1067 VSS.t729 17.0005
R8146 VSS.n1091 VSS.t1684 17.0005
R8147 VSS.n1090 VSS.t1700 17.0005
R8148 VSS.n1056 VSS.t1699 17.0005
R8149 VSS.n1055 VSS.t1690 17.0005
R8150 VSS.n1059 VSS.t1706 17.0005
R8151 VSS.n1058 VSS.t1688 17.0005
R8152 VSS.n1061 VSS.t1692 17.0005
R8153 VSS.n1060 VSS.t1694 17.0005
R8154 VSS.n1073 VSS.t1686 17.0005
R8155 VSS.n1072 VSS.t1701 17.0005
R8156 VSS.n1145 VSS.t216 17.0005
R8157 VSS.n1144 VSS.t233 17.0005
R8158 VSS.n1306 VSS.t232 17.0005
R8159 VSS.n1305 VSS.t243 17.0005
R8160 VSS.n1138 VSS.t226 17.0005
R8161 VSS.n1137 VSS.t219 17.0005
R8162 VSS.n1140 VSS.t217 17.0005
R8163 VSS.n1139 VSS.t213 17.0005
R8164 VSS.n1292 VSS.t227 17.0005
R8165 VSS.n1291 VSS.t221 17.0005
R8166 VSS.n1117 VSS.t241 17.0005
R8167 VSS.n1116 VSS.t211 17.0005
R8168 VSS.n1132 VSS.t1144 17.0005
R8169 VSS.n1131 VSS.t1157 17.0005
R8170 VSS.n3294 VSS.t1136 17.0005
R8171 VSS.n3293 VSS.t1153 17.0005
R8172 VSS.n1125 VSS.t1147 17.0005
R8173 VSS.n1124 VSS.t1158 17.0005
R8174 VSS.n1127 VSS.t1151 17.0005
R8175 VSS.n1126 VSS.t1138 17.0005
R8176 VSS.n1122 VSS.t1150 17.0005
R8177 VSS.n1121 VSS.t1161 17.0005
R8178 VSS.n37 VSS.n36 17.0005
R8179 VSS.n48 VSS.n47 17.0005
R8180 VSS.n47 VSS.n30 17.0005
R8181 VSS.n47 VSS.n46 17.0005
R8182 VSS.n35 VSS.n31 17.0005
R8183 VSS.n34 VSS.n31 17.0005
R8184 VSS.n3765 VSS.n50 17.0005
R8185 VSS.n3766 VSS.n50 17.0005
R8186 VSS.n52 VSS.n50 17.0005
R8187 VSS.n3769 VSS.n49 17.0005
R8188 VSS.n3769 VSS.n25 17.0005
R8189 VSS.n506 VSS.n505 17.0005
R8190 VSS.n505 VSS.n502 17.0005
R8191 VSS.n505 VSS.n504 17.0005
R8192 VSS.n3764 VSS.n3763 17.0005
R8193 VSS.n3763 VSS.n51 17.0005
R8194 VSS.n508 VSS.n493 17.0005
R8195 VSS.n508 VSS.n507 17.0005
R8196 VSS.n874 VSS.n873 17.0005
R8197 VSS.n873 VSS.n361 17.0005
R8198 VSS.n873 VSS.n872 17.0005
R8199 VSS.n876 VSS.n356 17.0005
R8200 VSS.n876 VSS.n875 17.0005
R8201 VSS.n373 VSS.n363 17.0005
R8202 VSS.n374 VSS.n363 17.0005
R8203 VSS.n371 VSS.n364 17.0005
R8204 VSS.n372 VSS.n371 17.0005
R8205 VSS.n11 VSS.n10 17.0005
R8206 VSS.n3780 VSS.n13 17.0005
R8207 VSS.n3781 VSS.n13 17.0005
R8208 VSS.n15 VSS.n13 17.0005
R8209 VSS.n3784 VSS.n12 17.0005
R8210 VSS.n3784 VSS.n5 17.0005
R8211 VSS.n522 VSS.n520 17.0005
R8212 VSS.n522 VSS.n521 17.0005
R8213 VSS.n523 VSS.n522 17.0005
R8214 VSS.n3779 VSS.n3778 17.0005
R8215 VSS.n3778 VSS.n14 17.0005
R8216 VSS.n514 VSS.n490 17.0005
R8217 VSS.n515 VSS.n490 17.0005
R8218 VSS.n532 VSS.n490 17.0005
R8219 VSS.n519 VSS.n491 17.0005
R8220 VSS.n518 VSS.n491 17.0005
R8221 VSS.n513 VSS.n489 17.0005
R8222 VSS.n512 VSS.n489 17.0005
R8223 VSS.n399 VSS.n397 17.0005
R8224 VSS.n399 VSS.n398 17.0005
R8225 VSS.n400 VSS.n399 17.0005
R8226 VSS.n859 VSS.n388 17.0005
R8227 VSS.n890 VSS.n350 17.0005
R8228 VSS.n891 VSS.n350 17.0005
R8229 VSS.n882 VSS.n350 17.0005
R8230 VSS.n894 VSS.n349 17.0005
R8231 VSS.n894 VSS.n348 17.0005
R8232 VSS.n888 VSS.n351 17.0005
R8233 VSS.n889 VSS.n888 17.0005
R8234 VSS.n870 VSS.n869 17.0005
R8235 VSS.n869 VSS.n377 17.0005
R8236 VSS.n869 VSS.n362 17.0005
R8237 VSS.n869 VSS.n868 17.0005
R8238 VSS.n866 VSS.n381 17.0005
R8239 VSS.n867 VSS.n866 17.0005
R8240 VSS.n866 VSS.n379 17.0005
R8241 VSS.n866 VSS.n865 17.0005
R8242 VSS.n863 VSS.n385 17.0005
R8243 VSS.n864 VSS.n863 17.0005
R8244 VSS.n863 VSS.n383 17.0005
R8245 VSS.n863 VSS.n862 17.0005
R8246 VSS.n615 VSS.n614 17.0005
R8247 VSS.n614 VSS.n488 17.0005
R8248 VSS.n614 VSS.n613 17.0005
R8249 VSS.n626 VSS.n622 17.0005
R8250 VSS.n627 VSS.n622 17.0005
R8251 VSS.n622 VSS.n621 17.0005
R8252 VSS.n630 VSS.n616 17.0005
R8253 VSS.n630 VSS.n483 17.0005
R8254 VSS.n665 VSS.n664 17.0005
R8255 VSS.n664 VSS.n470 17.0005
R8256 VSS.n664 VSS.n663 17.0005
R8257 VSS.n625 VSS.n471 17.0005
R8258 VSS.n624 VSS.n471 17.0005
R8259 VSS.n676 VSS.n672 17.0005
R8260 VSS.n677 VSS.n672 17.0005
R8261 VSS.n672 VSS.n671 17.0005
R8262 VSS.n680 VSS.n666 17.0005
R8263 VSS.n680 VSS.n465 17.0005
R8264 VSS.n715 VSS.n714 17.0005
R8265 VSS.n714 VSS.n452 17.0005
R8266 VSS.n714 VSS.n713 17.0005
R8267 VSS.n675 VSS.n453 17.0005
R8268 VSS.n674 VSS.n453 17.0005
R8269 VSS.n726 VSS.n722 17.0005
R8270 VSS.n727 VSS.n722 17.0005
R8271 VSS.n722 VSS.n721 17.0005
R8272 VSS.n730 VSS.n716 17.0005
R8273 VSS.n730 VSS.n447 17.0005
R8274 VSS.n765 VSS.n764 17.0005
R8275 VSS.n764 VSS.n434 17.0005
R8276 VSS.n764 VSS.n763 17.0005
R8277 VSS.n725 VSS.n435 17.0005
R8278 VSS.n724 VSS.n435 17.0005
R8279 VSS.n776 VSS.n772 17.0005
R8280 VSS.n777 VSS.n772 17.0005
R8281 VSS.n772 VSS.n771 17.0005
R8282 VSS.n780 VSS.n766 17.0005
R8283 VSS.n780 VSS.n429 17.0005
R8284 VSS.n815 VSS.n814 17.0005
R8285 VSS.n814 VSS.n416 17.0005
R8286 VSS.n814 VSS.n813 17.0005
R8287 VSS.n775 VSS.n417 17.0005
R8288 VSS.n774 VSS.n417 17.0005
R8289 VSS.n823 VSS.n822 17.0005
R8290 VSS.n824 VSS.n822 17.0005
R8291 VSS.n822 VSS.n821 17.0005
R8292 VSS.n827 VSS.n816 17.0005
R8293 VSS.n827 VSS.n411 17.0005
R8294 VSS.n859 VSS.n391 17.0005
R8295 VSS.n859 VSS.n389 17.0005
R8296 VSS.n860 VSS.n859 17.0005
R8297 VSS.n1978 VSS.n1977 17.0005
R8298 VSS.n2003 VSS.n1980 17.0005
R8299 VSS.n2004 VSS.n1980 17.0005
R8300 VSS.n1982 VSS.n1980 17.0005
R8301 VSS.n2007 VSS.n1979 17.0005
R8302 VSS.n2007 VSS.n1972 17.0005
R8303 VSS.n1996 VSS.n1994 17.0005
R8304 VSS.n1996 VSS.n1995 17.0005
R8305 VSS.n1997 VSS.n1996 17.0005
R8306 VSS.n2002 VSS.n2001 17.0005
R8307 VSS.n2001 VSS.n1981 17.0005
R8308 VSS.n3750 VSS.n64 17.0005
R8309 VSS.n3751 VSS.n64 17.0005
R8310 VSS.n3742 VSS.n64 17.0005
R8311 VSS.n3754 VSS.n63 17.0005
R8312 VSS.n3754 VSS.n62 17.0005
R8313 VSS.n3748 VSS.n65 17.0005
R8314 VSS.n3749 VSS.n3748 17.0005
R8315 VSS.n2209 VSS.n2208 17.0005
R8316 VSS.n2217 VSS.n2216 17.0005
R8317 VSS.n2218 VSS.n2216 17.0005
R8318 VSS.n2216 VSS.n2215 17.0005
R8319 VSS.n2221 VSS.n2210 17.0005
R8320 VSS.n2221 VSS.n2203 17.0005
R8321 VSS.n2300 VSS.n1936 17.0005
R8322 VSS.n2301 VSS.n1936 17.0005
R8323 VSS.n1938 VSS.n1936 17.0005
R8324 VSS.n2304 VSS.n1935 17.0005
R8325 VSS.n2304 VSS.n1934 17.0005
R8326 VSS.n2267 VSS.n2266 17.0005
R8327 VSS.n2266 VSS.n2263 17.0005
R8328 VSS.n2266 VSS.n2265 17.0005
R8329 VSS.n2299 VSS.n2298 17.0005
R8330 VSS.n2298 VSS.n1937 17.0005
R8331 VSS.n2269 VSS.n2254 17.0005
R8332 VSS.n2269 VSS.n2268 17.0005
R8333 VSS.n2019 VSS.n2018 17.0005
R8334 VSS.n2062 VSS.n2021 17.0005
R8335 VSS.n2063 VSS.n2021 17.0005
R8336 VSS.n2023 VSS.n2021 17.0005
R8337 VSS.n2066 VSS.n2020 17.0005
R8338 VSS.n2066 VSS.n2013 17.0005
R8339 VSS.n2054 VSS.n2052 17.0005
R8340 VSS.n2054 VSS.n2053 17.0005
R8341 VSS.n2055 VSS.n2054 17.0005
R8342 VSS.n2061 VSS.n2060 17.0005
R8343 VSS.n2060 VSS.n2022 17.0005
R8344 VSS.n2045 VSS.n2043 17.0005
R8345 VSS.n2045 VSS.n2044 17.0005
R8346 VSS.n2046 VSS.n2045 17.0005
R8347 VSS.n2051 VSS.n2050 17.0005
R8348 VSS.n2050 VSS.n2033 17.0005
R8349 VSS.n3731 VSS.n74 17.0005
R8350 VSS.n3732 VSS.n74 17.0005
R8351 VSS.n76 VSS.n74 17.0005
R8352 VSS.n3735 VSS.n73 17.0005
R8353 VSS.n3735 VSS.n72 17.0005
R8354 VSS.n105 VSS.n104 17.0005
R8355 VSS.n104 VSS.n101 17.0005
R8356 VSS.n104 VSS.n103 17.0005
R8357 VSS.n3730 VSS.n3729 17.0005
R8358 VSS.n3729 VSS.n75 17.0005
R8359 VSS.n3705 VSS.n107 17.0005
R8360 VSS.n3706 VSS.n107 17.0005
R8361 VSS.n109 VSS.n107 17.0005
R8362 VSS.n3709 VSS.n106 17.0005
R8363 VSS.n3709 VSS.n96 17.0005
R8364 VSS.n147 VSS.n146 17.0005
R8365 VSS.n146 VSS.n143 17.0005
R8366 VSS.n146 VSS.n145 17.0005
R8367 VSS.n3704 VSS.n3703 17.0005
R8368 VSS.n3703 VSS.n108 17.0005
R8369 VSS.n3679 VSS.n149 17.0005
R8370 VSS.n3680 VSS.n149 17.0005
R8371 VSS.n151 VSS.n149 17.0005
R8372 VSS.n3683 VSS.n148 17.0005
R8373 VSS.n3683 VSS.n138 17.0005
R8374 VSS.n189 VSS.n188 17.0005
R8375 VSS.n188 VSS.n185 17.0005
R8376 VSS.n188 VSS.n187 17.0005
R8377 VSS.n3678 VSS.n3677 17.0005
R8378 VSS.n3677 VSS.n150 17.0005
R8379 VSS.n3653 VSS.n191 17.0005
R8380 VSS.n3654 VSS.n191 17.0005
R8381 VSS.n193 VSS.n191 17.0005
R8382 VSS.n3657 VSS.n190 17.0005
R8383 VSS.n3657 VSS.n180 17.0005
R8384 VSS.n231 VSS.n230 17.0005
R8385 VSS.n230 VSS.n227 17.0005
R8386 VSS.n230 VSS.n229 17.0005
R8387 VSS.n3652 VSS.n3651 17.0005
R8388 VSS.n3651 VSS.n192 17.0005
R8389 VSS.n3627 VSS.n233 17.0005
R8390 VSS.n3628 VSS.n233 17.0005
R8391 VSS.n235 VSS.n233 17.0005
R8392 VSS.n3631 VSS.n232 17.0005
R8393 VSS.n3631 VSS.n222 17.0005
R8394 VSS.n273 VSS.n272 17.0005
R8395 VSS.n272 VSS.n269 17.0005
R8396 VSS.n272 VSS.n271 17.0005
R8397 VSS.n3626 VSS.n3625 17.0005
R8398 VSS.n3625 VSS.n234 17.0005
R8399 VSS.n3601 VSS.n275 17.0005
R8400 VSS.n3602 VSS.n275 17.0005
R8401 VSS.n3593 VSS.n275 17.0005
R8402 VSS.n3605 VSS.n274 17.0005
R8403 VSS.n3605 VSS.n264 17.0005
R8404 VSS.n3599 VSS.n276 17.0005
R8405 VSS.n3600 VSS.n3599 17.0005
R8406 VSS.n329 VSS.n328 17.0005
R8407 VSS.n328 VSS.n325 17.0005
R8408 VSS.n328 VSS.n327 17.0005
R8409 VSS.n331 VSS.n317 17.0005
R8410 VSS.n331 VSS.n330 17.0005
R8411 VSS.n1966 VSS.n1965 17.0005
R8412 VSS.n1959 VSS.n1953 17.0005
R8413 VSS.n1960 VSS.n1953 17.0005
R8414 VSS.n2230 VSS.n1953 17.0005
R8415 VSS.n1964 VSS.n1954 17.0005
R8416 VSS.n1963 VSS.n1954 17.0005
R8417 VSS.n2242 VSS.n2241 17.0005
R8418 VSS.n2241 VSS.n1951 17.0005
R8419 VSS.n2241 VSS.n2240 17.0005
R8420 VSS.n1958 VSS.n1952 17.0005
R8421 VSS.n1957 VSS.n1952 17.0005
R8422 VSS.n2285 VSS.n2244 17.0005
R8423 VSS.n2286 VSS.n2244 17.0005
R8424 VSS.n2246 VSS.n2244 17.0005
R8425 VSS.n2289 VSS.n2243 17.0005
R8426 VSS.n2289 VSS.n1946 17.0005
R8427 VSS.n2284 VSS.n2283 17.0005
R8428 VSS.n2283 VSS.n2245 17.0005
R8429 VSS.n313 VSS.n312 17.0005
R8430 VSS.n312 VSS.n309 17.0005
R8431 VSS.n312 VSS.n311 17.0005
R8432 VSS.n315 VSS.n302 17.0005
R8433 VSS.n315 VSS.n314 17.0005
R8434 VSS.n3569 VSS.n3568 17.0005
R8435 VSS.n3568 VSS.n3567 17.0005
R8436 VSS.n3571 VSS.n301 17.0005
R8437 VSS.n3571 VSS.n3570 17.0005
R8438 VSS.n3583 VSS.n294 17.0005
R8439 VSS.n3584 VSS.n294 17.0005
R8440 VSS.n3581 VSS.n295 17.0005
R8441 VSS.n3582 VSS.n3581 17.0005
R8442 VSS.n2278 VSS.n2276 17.0005
R8443 VSS.n2278 VSS.n2277 17.0005
R8444 VSS.n2279 VSS.n2278 17.0005
R8445 VSS.n3718 VSS.n86 17.0005
R8446 VSS.n3719 VSS.n86 17.0005
R8447 VSS.n88 VSS.n86 17.0005
R8448 VSS.n3722 VSS.n85 17.0005
R8449 VSS.n3722 VSS.n84 17.0005
R8450 VSS.n126 VSS.n125 17.0005
R8451 VSS.n125 VSS.n122 17.0005
R8452 VSS.n125 VSS.n124 17.0005
R8453 VSS.n3717 VSS.n3716 17.0005
R8454 VSS.n3716 VSS.n87 17.0005
R8455 VSS.n3692 VSS.n128 17.0005
R8456 VSS.n3693 VSS.n128 17.0005
R8457 VSS.n130 VSS.n128 17.0005
R8458 VSS.n3696 VSS.n127 17.0005
R8459 VSS.n3696 VSS.n117 17.0005
R8460 VSS.n168 VSS.n167 17.0005
R8461 VSS.n167 VSS.n164 17.0005
R8462 VSS.n167 VSS.n166 17.0005
R8463 VSS.n3691 VSS.n3690 17.0005
R8464 VSS.n3690 VSS.n129 17.0005
R8465 VSS.n3666 VSS.n170 17.0005
R8466 VSS.n3667 VSS.n170 17.0005
R8467 VSS.n172 VSS.n170 17.0005
R8468 VSS.n3670 VSS.n169 17.0005
R8469 VSS.n3670 VSS.n159 17.0005
R8470 VSS.n210 VSS.n209 17.0005
R8471 VSS.n209 VSS.n206 17.0005
R8472 VSS.n209 VSS.n208 17.0005
R8473 VSS.n3665 VSS.n3664 17.0005
R8474 VSS.n3664 VSS.n171 17.0005
R8475 VSS.n3640 VSS.n212 17.0005
R8476 VSS.n3641 VSS.n212 17.0005
R8477 VSS.n214 VSS.n212 17.0005
R8478 VSS.n3644 VSS.n211 17.0005
R8479 VSS.n3644 VSS.n201 17.0005
R8480 VSS.n252 VSS.n251 17.0005
R8481 VSS.n251 VSS.n248 17.0005
R8482 VSS.n251 VSS.n250 17.0005
R8483 VSS.n3639 VSS.n3638 17.0005
R8484 VSS.n3638 VSS.n213 17.0005
R8485 VSS.n3614 VSS.n254 17.0005
R8486 VSS.n3615 VSS.n254 17.0005
R8487 VSS.n256 VSS.n254 17.0005
R8488 VSS.n3618 VSS.n253 17.0005
R8489 VSS.n3618 VSS.n243 17.0005
R8490 VSS.n290 VSS.n289 17.0005
R8491 VSS.n289 VSS.n286 17.0005
R8492 VSS.n289 VSS.n288 17.0005
R8493 VSS.n3613 VSS.n3612 17.0005
R8494 VSS.n3612 VSS.n255 17.0005
R8495 VSS.n3588 VSS.n291 17.0005
R8496 VSS.n3588 VSS.n281 17.0005
R8497 VSS.n2176 VSS.n2175 17.0005
R8498 VSS.n2193 VSS.n2183 17.0005
R8499 VSS.n2194 VSS.n2183 17.0005
R8500 VSS.n2183 VSS.n2182 17.0005
R8501 VSS.n2197 VSS.n2177 17.0005
R8502 VSS.n2197 VSS.n2170 17.0005
R8503 VSS.n2187 VSS.n1929 17.0005
R8504 VSS.n2188 VSS.n1929 17.0005
R8505 VSS.n2313 VSS.n1929 17.0005
R8506 VSS.n2192 VSS.n1930 17.0005
R8507 VSS.n2191 VSS.n1930 17.0005
R8508 VSS.n2325 VSS.n2324 17.0005
R8509 VSS.n2324 VSS.n1927 17.0005
R8510 VSS.n2324 VSS.n2323 17.0005
R8511 VSS.n2186 VSS.n1928 17.0005
R8512 VSS.n2185 VSS.n1928 17.0005
R8513 VSS.n2327 VSS.n1921 17.0005
R8514 VSS.n2327 VSS.n2326 17.0005
R8515 VSS.n2135 VSS.n2134 17.0005
R8516 VSS.n2160 VSS.n2137 17.0005
R8517 VSS.n2161 VSS.n2137 17.0005
R8518 VSS.n2139 VSS.n2137 17.0005
R8519 VSS.n2164 VSS.n2136 17.0005
R8520 VSS.n2164 VSS.n2129 17.0005
R8521 VSS.n2153 VSS.n2151 17.0005
R8522 VSS.n2153 VSS.n2152 17.0005
R8523 VSS.n2154 VSS.n2153 17.0005
R8524 VSS.n2159 VSS.n2158 17.0005
R8525 VSS.n2158 VSS.n2138 17.0005
R8526 VSS.n2338 VSS.n1528 17.0005
R8527 VSS.n2339 VSS.n1528 17.0005
R8528 VSS.n1530 VSS.n1528 17.0005
R8529 VSS.n2342 VSS.n1527 17.0005
R8530 VSS.n2342 VSS.n1526 17.0005
R8531 VSS.n1917 VSS.n1915 17.0005
R8532 VSS.n1917 VSS.n1916 17.0005
R8533 VSS.n1918 VSS.n1917 17.0005
R8534 VSS.n2337 VSS.n2336 17.0005
R8535 VSS.n2336 VSS.n1529 17.0005
R8536 VSS.n1594 VSS.n1593 17.0005
R8537 VSS.n1593 VSS.n1590 17.0005
R8538 VSS.n1593 VSS.n1592 17.0005
R8539 VSS.n1914 VSS.n1913 17.0005
R8540 VSS.n1913 VSS.n1540 17.0005
R8541 VSS.n1889 VSS.n1596 17.0005
R8542 VSS.n1890 VSS.n1596 17.0005
R8543 VSS.n1598 VSS.n1596 17.0005
R8544 VSS.n1893 VSS.n1595 17.0005
R8545 VSS.n1893 VSS.n1585 17.0005
R8546 VSS.n1636 VSS.n1635 17.0005
R8547 VSS.n1635 VSS.n1632 17.0005
R8548 VSS.n1635 VSS.n1634 17.0005
R8549 VSS.n1888 VSS.n1887 17.0005
R8550 VSS.n1887 VSS.n1597 17.0005
R8551 VSS.n1863 VSS.n1638 17.0005
R8552 VSS.n1864 VSS.n1638 17.0005
R8553 VSS.n1640 VSS.n1638 17.0005
R8554 VSS.n1867 VSS.n1637 17.0005
R8555 VSS.n1867 VSS.n1627 17.0005
R8556 VSS.n1678 VSS.n1677 17.0005
R8557 VSS.n1677 VSS.n1674 17.0005
R8558 VSS.n1677 VSS.n1676 17.0005
R8559 VSS.n1862 VSS.n1861 17.0005
R8560 VSS.n1861 VSS.n1639 17.0005
R8561 VSS.n1837 VSS.n1680 17.0005
R8562 VSS.n1838 VSS.n1680 17.0005
R8563 VSS.n1682 VSS.n1680 17.0005
R8564 VSS.n1841 VSS.n1679 17.0005
R8565 VSS.n1841 VSS.n1669 17.0005
R8566 VSS.n1720 VSS.n1719 17.0005
R8567 VSS.n1719 VSS.n1716 17.0005
R8568 VSS.n1719 VSS.n1718 17.0005
R8569 VSS.n1836 VSS.n1835 17.0005
R8570 VSS.n1835 VSS.n1681 17.0005
R8571 VSS.n1811 VSS.n1722 17.0005
R8572 VSS.n1812 VSS.n1722 17.0005
R8573 VSS.n1724 VSS.n1722 17.0005
R8574 VSS.n1815 VSS.n1721 17.0005
R8575 VSS.n1815 VSS.n1711 17.0005
R8576 VSS.n1778 VSS.n1776 17.0005
R8577 VSS.n1778 VSS.n1777 17.0005
R8578 VSS.n1779 VSS.n1778 17.0005
R8579 VSS.n1810 VSS.n1809 17.0005
R8580 VSS.n1809 VSS.n1723 17.0005
R8581 VSS.n1768 VSS.n1766 17.0005
R8582 VSS.n1768 VSS.n1767 17.0005
R8583 VSS.n1769 VSS.n1768 17.0005
R8584 VSS.n1775 VSS.n1774 17.0005
R8585 VSS.n1774 VSS.n1734 17.0005
R8586 VSS.n1764 VSS.n1742 17.0005
R8587 VSS.n1765 VSS.n1764 17.0005
R8588 VSS.n1757 VSS.n1755 17.0005
R8589 VSS.n1757 VSS.n1756 17.0005
R8590 VSS.n1758 VSS.n1757 17.0005
R8591 VSS.n1753 VSS.n1747 17.0005
R8592 VSS.n1754 VSS.n1753 17.0005
R8593 VSS.n2476 VSS.n2475 17.0005
R8594 VSS.n2493 VSS.n2483 17.0005
R8595 VSS.n2494 VSS.n2483 17.0005
R8596 VSS.n2483 VSS.n2482 17.0005
R8597 VSS.n2497 VSS.n2477 17.0005
R8598 VSS.n2497 VSS.n2470 17.0005
R8599 VSS.n2487 VSS.n1410 17.0005
R8600 VSS.n2488 VSS.n1410 17.0005
R8601 VSS.n2572 VSS.n1410 17.0005
R8602 VSS.n2492 VSS.n1411 17.0005
R8603 VSS.n2491 VSS.n1411 17.0005
R8604 VSS.n2584 VSS.n2583 17.0005
R8605 VSS.n2583 VSS.n1408 17.0005
R8606 VSS.n2583 VSS.n2582 17.0005
R8607 VSS.n2486 VSS.n1409 17.0005
R8608 VSS.n2485 VSS.n1409 17.0005
R8609 VSS.n2585 VSS.n1384 17.0005
R8610 VSS.n2586 VSS.n1384 17.0005
R8611 VSS.n1428 VSS.n1427 17.0005
R8612 VSS.n2548 VSS.n2547 17.0005
R8613 VSS.n2547 VSS.n1421 17.0005
R8614 VSS.n2547 VSS.n2546 17.0005
R8615 VSS.n1426 VSS.n1422 17.0005
R8616 VSS.n1425 VSS.n1422 17.0005
R8617 VSS.n2559 VSS.n2555 17.0005
R8618 VSS.n2560 VSS.n2555 17.0005
R8619 VSS.n2555 VSS.n2554 17.0005
R8620 VSS.n2563 VSS.n2549 17.0005
R8621 VSS.n2563 VSS.n1416 17.0005
R8622 VSS.n2615 VSS.n2614 17.0005
R8623 VSS.n2614 VSS.n1395 17.0005
R8624 VSS.n2614 VSS.n2613 17.0005
R8625 VSS.n2558 VSS.n1396 17.0005
R8626 VSS.n2557 VSS.n1396 17.0005
R8627 VSS.n2617 VSS.n1389 17.0005
R8628 VSS.n2617 VSS.n2616 17.0005
R8629 VSS.n3394 VSS.n1051 17.0005
R8630 VSS.n3394 VSS.n1052 17.0005
R8631 VSS.n3307 VSS.n3305 17.0005
R8632 VSS.n3307 VSS.n3306 17.0005
R8633 VSS.n3407 VSS.n1043 17.0005
R8634 VSS.n3407 VSS.n3404 17.0005
R8635 VSS.n3407 VSS.n1042 17.0005
R8636 VSS.n3408 VSS.n3407 17.0005
R8637 VSS.n3410 VSS.n1041 17.0005
R8638 VSS.n3410 VSS.n1039 17.0005
R8639 VSS.n3411 VSS.n3410 17.0005
R8640 VSS.n3410 VSS.n3409 17.0005
R8641 VSS.n3399 VSS.n1049 17.0005
R8642 VSS.n3399 VSS.n3396 17.0005
R8643 VSS.n3399 VSS.n1048 17.0005
R8644 VSS.n3400 VSS.n3399 17.0005
R8645 VSS.n3403 VSS.n3402 17.0005
R8646 VSS.n3402 VSS.n1044 17.0005
R8647 VSS.n3402 VSS.n1047 17.0005
R8648 VSS.n3402 VSS.n3401 17.0005
R8649 VSS.n3394 VSS.n1050 17.0005
R8650 VSS.n3395 VSS.n3394 17.0005
R8651 VSS.n1085 VSS.n1081 17.0005
R8652 VSS.n1086 VSS.n1085 17.0005
R8653 VSS.n1085 VSS.n1076 17.0005
R8654 VSS.n1085 VSS.n1084 17.0005
R8655 VSS.n1079 VSS.n1078 17.0005
R8656 VSS.n1079 VSS.n1075 17.0005
R8657 VSS.n3374 VSS.n1184 17.0005
R8658 VSS.n3374 VSS.n1186 17.0005
R8659 VSS.n3374 VSS.n3373 17.0005
R8660 VSS.n3375 VSS.n3374 17.0005
R8661 VSS.n3367 VSS.n1192 17.0005
R8662 VSS.n3367 VSS.n3364 17.0005
R8663 VSS.n3367 VSS.n1191 17.0005
R8664 VSS.n3368 VSS.n3367 17.0005
R8665 VSS.n3370 VSS.n1185 17.0005
R8666 VSS.n3370 VSS.n1189 17.0005
R8667 VSS.n3370 VSS.n1190 17.0005
R8668 VSS.n3370 VSS.n3369 17.0005
R8669 VSS.n3359 VSS.n1198 17.0005
R8670 VSS.n3359 VSS.n3356 17.0005
R8671 VSS.n3359 VSS.n1197 17.0005
R8672 VSS.n3360 VSS.n3359 17.0005
R8673 VSS.n3363 VSS.n3362 17.0005
R8674 VSS.n3362 VSS.n1193 17.0005
R8675 VSS.n3362 VSS.n1196 17.0005
R8676 VSS.n3362 VSS.n3361 17.0005
R8677 VSS.n3351 VSS.n1204 17.0005
R8678 VSS.n3351 VSS.n3348 17.0005
R8679 VSS.n3351 VSS.n1203 17.0005
R8680 VSS.n3352 VSS.n3351 17.0005
R8681 VSS.n3355 VSS.n3354 17.0005
R8682 VSS.n3354 VSS.n1199 17.0005
R8683 VSS.n3354 VSS.n1202 17.0005
R8684 VSS.n3354 VSS.n3353 17.0005
R8685 VSS.n3340 VSS.n1205 17.0005
R8686 VSS.n3340 VSS.n1148 17.0005
R8687 VSS.n3346 VSS.n1147 17.0005
R8688 VSS.n3347 VSS.n3346 17.0005
R8689 VSS.n3340 VSS.n1206 17.0005
R8690 VSS.n3340 VSS.n3339 17.0005
R8691 VSS.n3334 VSS.n1212 17.0005
R8692 VSS.n3334 VSS.n3331 17.0005
R8693 VSS.n3334 VSS.n1211 17.0005
R8694 VSS.n3335 VSS.n3334 17.0005
R8695 VSS.n3338 VSS.n3337 17.0005
R8696 VSS.n3337 VSS.n1207 17.0005
R8697 VSS.n3337 VSS.n1210 17.0005
R8698 VSS.n3337 VSS.n3336 17.0005
R8699 VSS.n3326 VSS.n1219 17.0005
R8700 VSS.n3326 VSS.n3323 17.0005
R8701 VSS.n3326 VSS.n1218 17.0005
R8702 VSS.n3327 VSS.n3326 17.0005
R8703 VSS.n3330 VSS.n3329 17.0005
R8704 VSS.n3329 VSS.n1213 17.0005
R8705 VSS.n3329 VSS.n1217 17.0005
R8706 VSS.n3329 VSS.n3328 17.0005
R8707 VSS.n3318 VSS.n3302 17.0005
R8708 VSS.n3318 VSS.n3315 17.0005
R8709 VSS.n3318 VSS.n3301 17.0005
R8710 VSS.n3319 VSS.n3318 17.0005
R8711 VSS.n3322 VSS.n3321 17.0005
R8712 VSS.n3321 VSS.n1220 17.0005
R8713 VSS.n3321 VSS.n3300 17.0005
R8714 VSS.n3321 VSS.n3320 17.0005
R8715 VSS.n3307 VSS.n3303 17.0005
R8716 VSS.n3307 VSS.n1111 17.0005
R8717 VSS.n3313 VSS.n1110 17.0005
R8718 VSS.n3314 VSS.n3313 17.0005
R8719 VSS.n3383 VSS.n3382 17.0005
R8720 VSS.n3382 VSS.n1120 17.0005
R8721 VSS.n3382 VSS.n1129 17.0005
R8722 VSS.n3382 VSS.n1130 17.0005
R8723 VSS.n3382 VSS.n1119 17.0005
R8724 VSS.n3382 VSS.n1135 17.0005
R8725 VSS.n3382 VSS.n1118 17.0005
R8726 VSS.n3382 VSS.n1115 17.0005
R8727 VSS.n3382 VSS.n1136 17.0005
R8728 VSS.n3382 VSS.n1113 17.0005
R8729 VSS.n3382 VSS.n1142 17.0005
R8730 VSS.n3382 VSS.n1143 17.0005
R8731 VSS.n3382 VSS.n1112 17.0005
R8732 VSS.n3382 VSS.n3381 17.0005
R8733 VSS.n3386 VSS.n1088 17.0005
R8734 VSS.n3386 VSS.n1071 17.0005
R8735 VSS.n3387 VSS.n3386 17.0005
R8736 VSS.n3386 VSS.n1089 17.0005
R8737 VSS.n3386 VSS.n1070 17.0005
R8738 VSS.n3386 VSS.n1094 17.0005
R8739 VSS.n3386 VSS.n1069 17.0005
R8740 VSS.n3386 VSS.n1066 17.0005
R8741 VSS.n3386 VSS.n1095 17.0005
R8742 VSS.n3386 VSS.n1064 17.0005
R8743 VSS.n3386 VSS.n1101 17.0005
R8744 VSS.n3386 VSS.n1102 17.0005
R8745 VSS.n3386 VSS.n1063 17.0005
R8746 VSS.n3386 VSS.n3385 17.0005
R8747 VSS.n1159 VSS.t1962 17.0005
R8748 VSS.n1158 VSS.t1940 17.0005
R8749 VSS.n3379 VSS.n3378 17.0005
R8750 VSS.n3378 VSS.n1157 17.0005
R8751 VSS.n3378 VSS.n1166 17.0005
R8752 VSS.n3378 VSS.n1167 17.0005
R8753 VSS.n3378 VSS.n1156 17.0005
R8754 VSS.n3378 VSS.n1172 17.0005
R8755 VSS.n3378 VSS.n1155 17.0005
R8756 VSS.n3378 VSS.n1152 17.0005
R8757 VSS.n3378 VSS.n1173 17.0005
R8758 VSS.n3378 VSS.n1150 17.0005
R8759 VSS.n3378 VSS.n1179 17.0005
R8760 VSS.n3378 VSS.n1180 17.0005
R8761 VSS.n3378 VSS.n1149 17.0005
R8762 VSS.n3378 VSS.n3377 17.0005
R8763 VSS.n3258 VSS.n1245 17.0005
R8764 VSS.n3258 VSS.n3254 17.0005
R8765 VSS.n3000 VSS.n2999 17.0005
R8766 VSS.n2999 VSS.n2998 17.0005
R8767 VSS.n3010 VSS.n3001 17.0005
R8768 VSS.n3010 VSS.n1358 17.0005
R8769 VSS.n3011 VSS.n3010 17.0005
R8770 VSS.n3010 VSS.n3009 17.0005
R8771 VSS.n3007 VSS.n3004 17.0005
R8772 VSS.n3007 VSS.n3005 17.0005
R8773 VSS.n3007 VSS 17.0005
R8774 VSS.n3007 VSS.n3002 17.0005
R8775 VSS.n3007 VSS.n3006 17.0005
R8776 VSS.n3008 VSS.n3007 17.0005
R8777 VSS.n3041 VSS.n1334 17.0005
R8778 VSS.n3042 VSS.n3041 17.0005
R8779 VSS.n3041 VSS 17.0005
R8780 VSS.n3041 VSS.n1332 17.0005
R8781 VSS.n3041 VSS.n1335 17.0005
R8782 VSS.n3041 VSS.n3040 17.0005
R8783 VSS.n3038 VSS.n1338 17.0005
R8784 VSS.n3038 VSS.n1336 17.0005
R8785 VSS.n3038 VSS.n3037 17.0005
R8786 VSS.n3039 VSS.n3038 17.0005
R8787 VSS.n3052 VSS.n3048 17.0005
R8788 VSS.n3053 VSS.n3052 17.0005
R8789 VSS.n3057 VSS.n3047 17.0005
R8790 VSS.n3057 VSS.n3054 17.0005
R8791 VSS.n3057 VSS.n3046 17.0005
R8792 VSS.n3058 VSS.n3057 17.0005
R8793 VSS.n3061 VSS.n3045 17.0005
R8794 VSS.n3061 VSS.n3059 17.0005
R8795 VSS.n3061 VSS 17.0005
R8796 VSS.n3061 VSS.n3044 17.0005
R8797 VSS.n3061 VSS.n3060 17.0005
R8798 VSS.n3062 VSS.n3061 17.0005
R8799 VSS.n3064 VSS.n3043 17.0005
R8800 VSS.n3064 VSS.n1330 17.0005
R8801 VSS.n3065 VSS.n3064 17.0005
R8802 VSS.n3064 VSS.n3063 17.0005
R8803 VSS.n3098 VSS.n1304 17.0005
R8804 VSS.n3098 VSS.n1302 17.0005
R8805 VSS.n3098 VSS.n3097 17.0005
R8806 VSS.n3099 VSS.n3098 17.0005
R8807 VSS.n3101 VSS.n1300 17.0005
R8808 VSS.n3102 VSS.n3101 17.0005
R8809 VSS.n3101 VSS 17.0005
R8810 VSS.n3101 VSS.n1298 17.0005
R8811 VSS.n3101 VSS.n1301 17.0005
R8812 VSS.n3101 VSS.n3100 17.0005
R8813 VSS.n3109 VSS.n3106 17.0005
R8814 VSS.n3109 VSS.n3107 17.0005
R8815 VSS.n3109 VSS 17.0005
R8816 VSS.n3109 VSS.n3104 17.0005
R8817 VSS.n3109 VSS.n3108 17.0005
R8818 VSS.n3110 VSS.n3109 17.0005
R8819 VSS.n3112 VSS.n3103 17.0005
R8820 VSS.n3112 VSS.n1296 17.0005
R8821 VSS.n3113 VSS.n3112 17.0005
R8822 VSS.n3112 VSS.n3111 17.0005
R8823 VSS.n3277 VSS.n1232 17.0005
R8824 VSS.n3278 VSS.n3277 17.0005
R8825 VSS.n3282 VSS.n1231 17.0005
R8826 VSS.n3282 VSS.n3279 17.0005
R8827 VSS.n3282 VSS.n1230 17.0005
R8828 VSS.n3283 VSS.n3282 17.0005
R8829 VSS.n3286 VSS.n1229 17.0005
R8830 VSS.n3286 VSS.n3284 17.0005
R8831 VSS.n3286 VSS 17.0005
R8832 VSS.n3286 VSS.n1228 17.0005
R8833 VSS.n3286 VSS.n3285 17.0005
R8834 VSS.n3287 VSS.n3286 17.0005
R8835 VSS.n3289 VSS.n1227 17.0005
R8836 VSS.n3289 VSS.n1225 17.0005
R8837 VSS.n3290 VSS.n3289 17.0005
R8838 VSS.n3289 VSS.n3288 17.0005
R8839 VSS.n3272 VSS.n1234 17.0005
R8840 VSS.n3272 VSS.n1233 17.0005
R8841 VSS.n3272 VSS.n1235 17.0005
R8842 VSS.n3272 VSS.n3271 17.0005
R8843 VSS.n3269 VSS.n1237 17.0005
R8844 VSS.n3269 VSS.n3267 17.0005
R8845 VSS.n3269 VSS 17.0005
R8846 VSS.n3269 VSS.n1236 17.0005
R8847 VSS.n3269 VSS.n3268 17.0005
R8848 VSS.n3270 VSS.n3269 17.0005
R8849 VSS.n3262 VSS.n1243 17.0005
R8850 VSS.n3262 VSS.n3260 17.0005
R8851 VSS.n3262 VSS 17.0005
R8852 VSS.n3262 VSS.n1242 17.0005
R8853 VSS.n3262 VSS.n3261 17.0005
R8854 VSS.n3263 VSS.n3262 17.0005
R8855 VSS.n3266 VSS.n3265 17.0005
R8856 VSS.n3265 VSS.n1238 17.0005
R8857 VSS.n3265 VSS.n1241 17.0005
R8858 VSS.n3265 VSS.n3264 17.0005
R8859 VSS.n3258 VSS.n1244 17.0005
R8860 VSS.n3259 VSS.n3258 17.0005
R8861 VSS.n3252 VSS.n1247 17.0005
R8862 VSS.n3252 VSS.n3250 17.0005
R8863 VSS.n3252 VSS 17.0005
R8864 VSS.n3252 VSS.n1246 17.0005
R8865 VSS.n3252 VSS.n3251 17.0005
R8866 VSS.n3253 VSS.n3252 17.0005
R8867 VSS.n3248 VSS.n1249 17.0005
R8868 VSS.n3248 VSS.n3245 17.0005
R8869 VSS.n3248 VSS.n1248 17.0005
R8870 VSS.n3249 VSS.n3248 17.0005
R8871 VSS.n3204 VSS.n1257 17.0005
R8872 VSS.n3205 VSS.n3204 17.0005
R8873 VSS.n2995 VSS.n2991 17.0005
R8874 VSS.n2995 VSS.n2992 17.0005
R8875 VSS.n2995 VSS.n2989 17.0005
R8876 VSS.n2996 VSS.n2995 17.0005
R8877 VSS.n3020 VSS.n1348 17.0005
R8878 VSS.n3021 VSS.n3020 17.0005
R8879 VSS.n3020 VSS.n1346 17.0005
R8880 VSS.n3020 VSS.n3019 17.0005
R8881 VSS.n3017 VSS.n1352 17.0005
R8882 VSS.n3017 VSS.n1350 17.0005
R8883 VSS.n3017 VSS.n3016 17.0005
R8884 VSS.n3018 VSS.n3017 17.0005
R8885 VSS.n3029 VSS.n3025 17.0005
R8886 VSS.n3029 VSS.n3026 17.0005
R8887 VSS.n3029 VSS.n3023 17.0005
R8888 VSS.n3030 VSS.n3029 17.0005
R8889 VSS.n3032 VSS.n3022 17.0005
R8890 VSS.n3032 VSS.n1344 17.0005
R8891 VSS.n3033 VSS.n3032 17.0005
R8892 VSS.n3032 VSS.n3031 17.0005
R8893 VSS.n3080 VSS.n1314 17.0005
R8894 VSS.n3081 VSS.n3080 17.0005
R8895 VSS.n3080 VSS.n1312 17.0005
R8896 VSS.n3080 VSS.n3079 17.0005
R8897 VSS.n3078 VSS.n3077 17.0005
R8898 VSS.n3077 VSS.n3076 17.0005
R8899 VSS.n3074 VSS.n1320 17.0005
R8900 VSS.n3075 VSS.n3074 17.0005
R8901 VSS.n3074 VSS.n1319 17.0005
R8902 VSS.n3074 VSS.n3073 17.0005
R8903 VSS.n3071 VSS.n1324 17.0005
R8904 VSS.n3071 VSS.n1322 17.0005
R8905 VSS.n3071 VSS.n3070 17.0005
R8906 VSS.n3072 VSS.n3071 17.0005
R8907 VSS.n3089 VSS.n3085 17.0005
R8908 VSS.n3089 VSS.n3086 17.0005
R8909 VSS.n3089 VSS.n3083 17.0005
R8910 VSS.n3090 VSS.n3089 17.0005
R8911 VSS.n3092 VSS.n3082 17.0005
R8912 VSS.n3092 VSS.n1310 17.0005
R8913 VSS.n3093 VSS.n3092 17.0005
R8914 VSS.n3092 VSS.n3091 17.0005
R8915 VSS.n3122 VSS.n1286 17.0005
R8916 VSS.n3123 VSS.n3122 17.0005
R8917 VSS.n3122 VSS.n1284 17.0005
R8918 VSS.n3122 VSS.n3121 17.0005
R8919 VSS.n3119 VSS.n1290 17.0005
R8920 VSS.n3119 VSS.n1288 17.0005
R8921 VSS.n3119 VSS.n3118 17.0005
R8922 VSS.n3120 VSS.n3119 17.0005
R8923 VSS.n3136 VSS.n1274 17.0005
R8924 VSS.n3137 VSS.n3136 17.0005
R8925 VSS.n3136 VSS.n1272 17.0005
R8926 VSS.n3136 VSS.n3135 17.0005
R8927 VSS.n3134 VSS.n3133 17.0005
R8928 VSS.n3133 VSS.n3132 17.0005
R8929 VSS.n3130 VSS.n1280 17.0005
R8930 VSS.n3131 VSS.n3130 17.0005
R8931 VSS.n3130 VSS.n1279 17.0005
R8932 VSS.n3130 VSS.n3129 17.0005
R8933 VSS.n3127 VSS.n3124 17.0005
R8934 VSS.n3127 VSS.n1282 17.0005
R8935 VSS.n3127 VSS.n3126 17.0005
R8936 VSS.n3128 VSS.n3127 17.0005
R8937 VSS.n3147 VSS.n1268 17.0005
R8938 VSS.n3148 VSS.n3147 17.0005
R8939 VSS.n3147 VSS.n1266 17.0005
R8940 VSS.n3147 VSS.n3146 17.0005
R8941 VSS.n3144 VSS.n3138 17.0005
R8942 VSS.n3144 VSS.n1270 17.0005
R8943 VSS.n3144 VSS.n3143 17.0005
R8944 VSS.n3145 VSS.n3144 17.0005
R8945 VSS.n3201 VSS.n1262 17.0005
R8946 VSS.n3202 VSS.n3201 17.0005
R8947 VSS.n3201 VSS.n1260 17.0005
R8948 VSS.n3201 VSS.n3200 17.0005
R8949 VSS.n3198 VSS.n3149 17.0005
R8950 VSS.n3198 VSS.n1264 17.0005
R8951 VSS.n3198 VSS.n3197 17.0005
R8952 VSS.n3199 VSS.n3198 17.0005
R8953 VSS.n3204 VSS.n1255 17.0005
R8954 VSS.n3204 VSS.n3203 17.0005
R8955 VSS.n3207 VSS.n1253 17.0005
R8956 VSS.n3208 VSS.n3207 17.0005
R8957 VSS.n3207 VSS.n1252 17.0005
R8958 VSS.n3207 VSS.n3206 17.0005
R8959 VSS.n3211 VSS.n3210 17.0005
R8960 VSS.n3210 VSS.n3209 17.0005
R8961 VSS.n3497 VSS.n3496 17.0005
R8962 VSS.n3499 VSS.n964 17.0005
R8963 VSS.n3499 VSS.n3498 17.0005
R8964 VSS.n3230 VSS.n3228 17.0005
R8965 VSS.n3230 VSS.n3229 17.0005
R8966 VSS.n3231 VSS.n3230 17.0005
R8967 VSS.n3226 VSS.n3223 17.0005
R8968 VSS.n3227 VSS.n3223 17.0005
R8969 VSS.n3242 VSS.n3241 17.0005
R8970 VSS.n3241 VSS.n3222 17.0005
R8971 VSS.n3241 VSS.n3240 17.0005
R8972 VSS.n3217 VSS.n3215 17.0005
R8973 VSS.n3217 VSS.n3212 17.0005
R8974 VSS.n3496 VSS.n971 17.0005
R8975 VSS.n3496 VSS.n3495 17.0005
R8976 VSS.n1001 VSS.n994 17.0005
R8977 VSS.n993 VSS.n972 17.0005
R8978 VSS.n992 VSS.n972 17.0005
R8979 VSS.n1002 VSS.n1001 17.0005
R8980 VSS.n1001 VSS.n1000 17.0005
R8981 VSS.n3462 VSS.n985 17.0005
R8982 VSS.n3458 VSS.n988 17.0005
R8983 VSS.n3458 VSS.n1009 17.0005
R8984 VSS.n3458 VSS.n987 17.0005
R8985 VSS.n3459 VSS.n3458 17.0005
R8986 VSS.n1007 VSS.n990 17.0005
R8987 VSS.n1007 VSS.n1004 17.0005
R8988 VSS.n1007 VSS.n989 17.0005
R8989 VSS.n1008 VSS.n1007 17.0005
R8990 VSS.n2880 VSS.n2879 17.0005
R8991 VSS.n2879 VSS.n2876 17.0005
R8992 VSS.n2879 VSS.n2878 17.0005
R8993 VSS.n2912 VSS.n2911 17.0005
R8994 VSS.n2911 VSS.n2812 17.0005
R8995 VSS.n2887 VSS.n986 17.0005
R8996 VSS.n2888 VSS.n2887 17.0005
R8997 VSS.n2887 VSS.n2886 17.0005
R8998 VSS.n2891 VSS.n2881 17.0005
R8999 VSS.n2891 VSS.n2871 17.0005
R9000 VSS.n3462 VSS.n3461 17.0005
R9001 VSS.n2914 VSS.n2811 17.0005
R9002 VSS.n2915 VSS.n2811 17.0005
R9003 VSS.n2813 VSS.n2811 17.0005
R9004 VSS.n3455 VSS.n3454 17.0005
R9005 VSS.n3454 VSS.n1011 17.0005
R9006 VSS.n3454 VSS.n1010 17.0005
R9007 VSS.n3454 VSS.n3453 17.0005
R9008 VSS.n3451 VSS.n1015 17.0005
R9009 VSS.n3451 VSS.n1013 17.0005
R9010 VSS.n3451 VSS.n3450 17.0005
R9011 VSS.n3452 VSS.n3451 17.0005
R9012 VSS.n2807 VSS.n2806 17.0005
R9013 VSS.n2806 VSS.n2803 17.0005
R9014 VSS.n2806 VSS.n2805 17.0005
R9015 VSS.n2930 VSS.n2809 17.0005
R9016 VSS.n2931 VSS.n2809 17.0005
R9017 VSS.n2918 VSS.n2809 17.0005
R9018 VSS.n2934 VSS.n2808 17.0005
R9019 VSS.n2934 VSS.n2798 17.0005
R9020 VSS.n2929 VSS.n2928 17.0005
R9021 VSS.n2928 VSS.n2927 17.0005
R9022 VSS.n2769 VSS.n2767 17.0005
R9023 VSS.n2769 VSS.n2768 17.0005
R9024 VSS.n2770 VSS.n2769 17.0005
R9025 VSS.n2953 VSS.n2764 17.0005
R9026 VSS.n2954 VSS.n2953 17.0005
R9027 VSS.n2959 VSS.n2763 17.0005
R9028 VSS.n2959 VSS.n2956 17.0005
R9029 VSS.n2959 VSS.n2761 17.0005
R9030 VSS.n2960 VSS.n2959 17.0005
R9031 VSS.n2963 VSS.n2962 17.0005
R9032 VSS.n2962 VSS.n2674 17.0005
R9033 VSS.n2962 VSS.n2760 17.0005
R9034 VSS.n2962 VSS.n2961 17.0005
R9035 VSS.n2966 VSS.n2672 17.0005
R9036 VSS.n2966 VSS.n2663 17.0005
R9037 VSS.n2671 VSS.n2670 17.0005
R9038 VSS.n2670 VSS.n2667 17.0005
R9039 VSS.n2670 VSS.n2669 17.0005
R9040 VSS.n3175 VSS.n3158 17.0005
R9041 VSS.n3175 VSS.n3172 17.0005
R9042 VSS.n2691 VSS.n2690 17.0005
R9043 VSS.n2690 VSS.n1364 17.0005
R9044 VSS.n2697 VSS.n2692 17.0005
R9045 VSS.n2697 VSS.n2685 17.0005
R9046 VSS.n2697 VSS.n2696 17.0005
R9047 VSS.n2698 VSS.n2697 17.0005
R9048 VSS.n2700 VSS.n2683 17.0005
R9049 VSS.n2701 VSS.n2700 17.0005
R9050 VSS.n2700 VSS 17.0005
R9051 VSS.n2700 VSS.n2681 17.0005
R9052 VSS.n2700 VSS.n2684 17.0005
R9053 VSS.n2700 VSS.n2699 17.0005
R9054 VSS.n2752 VSS.n2704 17.0005
R9055 VSS.n2752 VSS.n2750 17.0005
R9056 VSS.n2752 VSS 17.0005
R9057 VSS.n2752 VSS.n2703 17.0005
R9058 VSS.n2752 VSS.n2751 17.0005
R9059 VSS.n2753 VSS.n2752 17.0005
R9060 VSS.n2755 VSS.n2702 17.0005
R9061 VSS.n2755 VSS.n2679 17.0005
R9062 VSS.n2756 VSS.n2755 17.0005
R9063 VSS.n2755 VSS.n2754 17.0005
R9064 VSS.n2736 VSS.n2716 17.0005
R9065 VSS.n2737 VSS.n2736 17.0005
R9066 VSS.n2741 VSS.n2715 17.0005
R9067 VSS.n2741 VSS.n2738 17.0005
R9068 VSS.n2741 VSS.n2714 17.0005
R9069 VSS.n2742 VSS.n2741 17.0005
R9070 VSS.n2745 VSS.n2713 17.0005
R9071 VSS.n2745 VSS.n2743 17.0005
R9072 VSS.n2745 VSS 17.0005
R9073 VSS.n2745 VSS.n2712 17.0005
R9074 VSS.n2745 VSS.n2744 17.0005
R9075 VSS.n2746 VSS.n2745 17.0005
R9076 VSS.n2749 VSS.n2748 17.0005
R9077 VSS.n2748 VSS.n2705 17.0005
R9078 VSS.n2748 VSS.n2711 17.0005
R9079 VSS.n2748 VSS.n2747 17.0005
R9080 VSS.n2731 VSS.n2718 17.0005
R9081 VSS.n2731 VSS.n2717 17.0005
R9082 VSS.n2731 VSS.n2719 17.0005
R9083 VSS.n2731 VSS.n2730 17.0005
R9084 VSS.n2728 VSS.n2722 17.0005
R9085 VSS.n2728 VSS.n2723 17.0005
R9086 VSS.n2728 VSS 17.0005
R9087 VSS.n2728 VSS.n2720 17.0005
R9088 VSS.n2728 VSS.n2727 17.0005
R9089 VSS.n2729 VSS.n2728 17.0005
R9090 VSS.n3440 VSS.n1022 17.0005
R9091 VSS.n3440 VSS.n3438 17.0005
R9092 VSS.n3440 VSS 17.0005
R9093 VSS.n3440 VSS.n1021 17.0005
R9094 VSS.n3440 VSS.n3439 17.0005
R9095 VSS.n3441 VSS.n3440 17.0005
R9096 VSS.n3443 VSS.n1020 17.0005
R9097 VSS.n3443 VSS.n1018 17.0005
R9098 VSS.n3444 VSS.n3443 17.0005
R9099 VSS.n3443 VSS.n3442 17.0005
R9100 VSS.n3424 VSS.n1031 17.0005
R9101 VSS.n3425 VSS.n3424 17.0005
R9102 VSS.n3429 VSS.n1030 17.0005
R9103 VSS.n3429 VSS.n3426 17.0005
R9104 VSS.n3429 VSS.n1029 17.0005
R9105 VSS.n3430 VSS.n3429 17.0005
R9106 VSS.n3433 VSS.n1028 17.0005
R9107 VSS.n3433 VSS.n3431 17.0005
R9108 VSS.n3433 VSS 17.0005
R9109 VSS.n3433 VSS.n1027 17.0005
R9110 VSS.n3433 VSS.n3432 17.0005
R9111 VSS.n3434 VSS.n3433 17.0005
R9112 VSS.n3437 VSS.n3436 17.0005
R9113 VSS.n3436 VSS.n1023 17.0005
R9114 VSS.n3436 VSS.n1026 17.0005
R9115 VSS.n3436 VSS.n3435 17.0005
R9116 VSS.n3419 VSS.n1033 17.0005
R9117 VSS.n3419 VSS.n1032 17.0005
R9118 VSS.n3419 VSS.n1034 17.0005
R9119 VSS.n3419 VSS.n3418 17.0005
R9120 VSS.n3416 VSS.n1036 17.0005
R9121 VSS.n3416 VSS.n1037 17.0005
R9122 VSS.n3416 VSS 17.0005
R9123 VSS.n3416 VSS.n1035 17.0005
R9124 VSS.n3416 VSS.n3415 17.0005
R9125 VSS.n3417 VSS.n3416 17.0005
R9126 VSS.n3179 VSS.n3156 17.0005
R9127 VSS.n3179 VSS.n3177 17.0005
R9128 VSS.n3179 VSS 17.0005
R9129 VSS.n3179 VSS.n3155 17.0005
R9130 VSS.n3179 VSS.n3178 17.0005
R9131 VSS.n3180 VSS.n3179 17.0005
R9132 VSS.n3182 VSS.n3154 17.0005
R9133 VSS.n3182 VSS.n3151 17.0005
R9134 VSS.n3183 VSS.n3182 17.0005
R9135 VSS.n3182 VSS.n3181 17.0005
R9136 VSS.n3175 VSS.n3157 17.0005
R9137 VSS.n3176 VSS.n3175 17.0005
R9138 VSS.n3170 VSS.n3160 17.0005
R9139 VSS.n3170 VSS.n3168 17.0005
R9140 VSS.n3170 VSS 17.0005
R9141 VSS.n3170 VSS.n3159 17.0005
R9142 VSS.n3170 VSS.n3169 17.0005
R9143 VSS.n3171 VSS.n3170 17.0005
R9144 VSS.n3166 VSS.n3162 17.0005
R9145 VSS.n3166 VSS.n3163 17.0005
R9146 VSS.n3166 VSS.n3161 17.0005
R9147 VSS.n3167 VSS.n3166 17.0005
R9148 VSS.n2629 VSS.n2628 17.0005
R9149 VSS.n2628 VSS.n1383 17.0005
R9150 VSS.n2628 VSS.n2627 17.0005
R9151 VSS.n2637 VSS.n2636 17.0005
R9152 VSS.n2638 VSS.n2636 17.0005
R9153 VSS.n2636 VSS.n2635 17.0005
R9154 VSS.n2641 VSS.n2630 17.0005
R9155 VSS.n2641 VSS.n1378 17.0005
R9156 VSS.n2986 VSS.n1367 17.0005
R9157 VSS.n2986 VSS.n1365 17.0005
R9158 VSS.n2509 VSS.n2508 17.0005
R9159 VSS.n2533 VSS.n2511 17.0005
R9160 VSS.n2534 VSS.n2511 17.0005
R9161 VSS.n2513 VSS.n2511 17.0005
R9162 VSS.n2537 VSS.n2510 17.0005
R9163 VSS.n2537 VSS.n2503 17.0005
R9164 VSS.n2527 VSS.n2525 17.0005
R9165 VSS.n2527 VSS.n2526 17.0005
R9166 VSS.n2528 VSS.n2527 17.0005
R9167 VSS.n2532 VSS.n2531 17.0005
R9168 VSS.n2531 VSS.n2512 17.0005
R9169 VSS.n2600 VSS.n1402 17.0005
R9170 VSS.n2601 VSS.n1402 17.0005
R9171 VSS.n2592 VSS.n1402 17.0005
R9172 VSS.n2604 VSS.n1401 17.0005
R9173 VSS.n2604 VSS.n1400 17.0005
R9174 VSS.n2598 VSS.n1403 17.0005
R9175 VSS.n2599 VSS.n2598 17.0005
R9176 VSS.n2111 VSS.n2110 17.0005
R9177 VSS.n2119 VSS.n2118 17.0005
R9178 VSS.n2120 VSS.n2118 17.0005
R9179 VSS.n2118 VSS.n2117 17.0005
R9180 VSS.n2123 VSS.n2112 17.0005
R9181 VSS.n2123 VSS.n2105 17.0005
R9182 VSS.n2353 VSS.n1515 17.0005
R9183 VSS.n2354 VSS.n1515 17.0005
R9184 VSS.n1517 VSS.n1515 17.0005
R9185 VSS.n2357 VSS.n1514 17.0005
R9186 VSS.n2357 VSS.n1513 17.0005
R9187 VSS.n1560 VSS.n1558 17.0005
R9188 VSS.n1560 VSS.n1559 17.0005
R9189 VSS.n1561 VSS.n1560 17.0005
R9190 VSS.n2352 VSS.n2351 17.0005
R9191 VSS.n2351 VSS.n1516 17.0005
R9192 VSS.n1557 VSS.n1552 17.0005
R9193 VSS.n1556 VSS.n1552 17.0005
R9194 VSS.n2375 VSS.n2374 17.0005
R9195 VSS.n2386 VSS.n2385 17.0005
R9196 VSS.n2385 VSS.n2368 17.0005
R9197 VSS.n2385 VSS.n2384 17.0005
R9198 VSS.n2373 VSS.n2369 17.0005
R9199 VSS.n2372 VSS.n2369 17.0005
R9200 VSS.n2394 VSS.n2393 17.0005
R9201 VSS.n2395 VSS.n2393 17.0005
R9202 VSS.n2393 VSS.n2392 17.0005
R9203 VSS.n2398 VSS.n2387 17.0005
R9204 VSS.n2398 VSS.n2363 17.0005
R9205 VSS.n2436 VSS.n1493 17.0005
R9206 VSS.n2437 VSS.n1493 17.0005
R9207 VSS.n2428 VSS.n1493 17.0005
R9208 VSS.n2440 VSS.n1492 17.0005
R9209 VSS.n2440 VSS.n1491 17.0005
R9210 VSS.n2434 VSS.n1494 17.0005
R9211 VSS.n2435 VSS.n2434 17.0005
R9212 VSS.n2078 VSS.n2077 17.0005
R9213 VSS.n2095 VSS.n2085 17.0005
R9214 VSS.n2096 VSS.n2085 17.0005
R9215 VSS.n2085 VSS.n2084 17.0005
R9216 VSS.n2099 VSS.n2079 17.0005
R9217 VSS.n2099 VSS.n2072 17.0005
R9218 VSS.n2089 VSS.n1508 17.0005
R9219 VSS.n2090 VSS.n1508 17.0005
R9220 VSS.n2407 VSS.n1508 17.0005
R9221 VSS.n2094 VSS.n1509 17.0005
R9222 VSS.n2093 VSS.n1509 17.0005
R9223 VSS.n2419 VSS.n2418 17.0005
R9224 VSS.n2418 VSS.n1506 17.0005
R9225 VSS.n2418 VSS.n2417 17.0005
R9226 VSS.n2088 VSS.n1507 17.0005
R9227 VSS.n2087 VSS.n1507 17.0005
R9228 VSS.n2421 VSS.n1500 17.0005
R9229 VSS.n2421 VSS.n2420 17.0005
R9230 VSS.n1573 VSS.n1572 17.0005
R9231 VSS.n1572 VSS.n1551 17.0005
R9232 VSS.n1572 VSS.n1571 17.0005
R9233 VSS.n1902 VSS.n1575 17.0005
R9234 VSS.n1903 VSS.n1575 17.0005
R9235 VSS.n1577 VSS.n1575 17.0005
R9236 VSS.n1906 VSS.n1574 17.0005
R9237 VSS.n1906 VSS.n1546 17.0005
R9238 VSS.n1615 VSS.n1614 17.0005
R9239 VSS.n1614 VSS.n1611 17.0005
R9240 VSS.n1614 VSS.n1613 17.0005
R9241 VSS.n1901 VSS.n1900 17.0005
R9242 VSS.n1900 VSS.n1576 17.0005
R9243 VSS.n1876 VSS.n1617 17.0005
R9244 VSS.n1877 VSS.n1617 17.0005
R9245 VSS.n1619 VSS.n1617 17.0005
R9246 VSS.n1880 VSS.n1616 17.0005
R9247 VSS.n1880 VSS.n1606 17.0005
R9248 VSS.n1657 VSS.n1656 17.0005
R9249 VSS.n1656 VSS.n1653 17.0005
R9250 VSS.n1656 VSS.n1655 17.0005
R9251 VSS.n1875 VSS.n1874 17.0005
R9252 VSS.n1874 VSS.n1618 17.0005
R9253 VSS.n1850 VSS.n1659 17.0005
R9254 VSS.n1851 VSS.n1659 17.0005
R9255 VSS.n1661 VSS.n1659 17.0005
R9256 VSS.n1854 VSS.n1658 17.0005
R9257 VSS.n1854 VSS.n1648 17.0005
R9258 VSS.n1699 VSS.n1698 17.0005
R9259 VSS.n1698 VSS.n1695 17.0005
R9260 VSS.n1698 VSS.n1697 17.0005
R9261 VSS.n1849 VSS.n1848 17.0005
R9262 VSS.n1848 VSS.n1660 17.0005
R9263 VSS.n1824 VSS.n1701 17.0005
R9264 VSS.n1825 VSS.n1701 17.0005
R9265 VSS.n1703 VSS.n1701 17.0005
R9266 VSS.n1828 VSS.n1700 17.0005
R9267 VSS.n1828 VSS.n1690 17.0005
R9268 VSS.n1790 VSS.n1789 17.0005
R9269 VSS.n1789 VSS.n1786 17.0005
R9270 VSS.n1789 VSS.n1788 17.0005
R9271 VSS.n1823 VSS.n1822 17.0005
R9272 VSS.n1822 VSS.n1702 17.0005
R9273 VSS.n1798 VSS.n1797 17.0005
R9274 VSS.n1799 VSS.n1797 17.0005
R9275 VSS.n1797 VSS.n1796 17.0005
R9276 VSS.n1802 VSS.n1791 17.0005
R9277 VSS.n1802 VSS.n1781 17.0005
R9278 VSS.n3529 VSS.n944 17.0005
R9279 VSS.n3529 VSS.n946 17.0005
R9280 VSS.n3529 VSS.n942 17.0005
R9281 VSS.n3526 VSS.n3524 17.0005
R9282 VSS.n3526 VSS.n3525 17.0005
R9283 VSS.n3527 VSS.n3526 17.0005
R9284 VSS.n3530 VSS.n3529 17.0005
R9285 VSS.n3522 VSS.n927 17.0005
R9286 VSS.n3523 VSS.n927 17.0005
R9287 VSS.n3539 VSS.n932 17.0005
R9288 VSS.n3539 VSS.n933 17.0005
R9289 VSS VSS.n3539 17.0005
R9290 VSS.n3539 VSS.n931 17.0005
R9291 VSS.n3536 VSS.n935 17.0005
R9292 VSS.n3537 VSS.n3536 17.0005
R9293 VSS.n3536 VSS.n934 17.0005
R9294 VSS.n3536 VSS.n3535 17.0005
R9295 VSS.n3533 VSS.n939 17.0005
R9296 VSS.n3534 VSS.n3533 17.0005
R9297 VSS.n3533 VSS.n937 17.0005
R9298 VSS.n3533 VSS.n3532 17.0005
R9299 VSS.n3539 VSS.n930 17.0005
R9300 VSS.n3539 VSS.n3538 17.0005
R9301 VSS.n3517 VSS.n926 17.0005
R9302 VSS.n3518 VSS.n926 17.0005
R9303 VSS.n3545 VSS.n926 17.0005
R9304 VSS.n3515 VSS.n925 17.0005
R9305 VSS.n3516 VSS.n925 17.0005
R9306 VSS.n1441 VSS.n1440 17.0005
R9307 VSS.n2460 VSS.n1443 17.0005
R9308 VSS.n2461 VSS.n1443 17.0005
R9309 VSS.n1445 VSS.n1443 17.0005
R9310 VSS.n2464 VSS.n1442 17.0005
R9311 VSS.n2464 VSS.n1435 17.0005
R9312 VSS.n2453 VSS.n2451 17.0005
R9313 VSS.n2453 VSS.n2452 17.0005
R9314 VSS.n2454 VSS.n2453 17.0005
R9315 VSS.n2459 VSS.n2458 17.0005
R9316 VSS.n2458 VSS.n1444 17.0005
R9317 VSS.n1487 VSS.n1485 17.0005
R9318 VSS.n1487 VSS.n1486 17.0005
R9319 VSS.n1488 VSS.n1487 17.0005
R9320 VSS.n2450 VSS.n2449 17.0005
R9321 VSS.n2449 VSS.n1455 17.0005
R9322 VSS.n1478 VSS.n1476 17.0005
R9323 VSS.n1478 VSS.n1477 17.0005
R9324 VSS.n1479 VSS.n1478 17.0005
R9325 VSS.n1484 VSS.n1483 17.0005
R9326 VSS.n1483 VSS.n1463 17.0005
R9327 VSS.n2651 VSS.n2650 17.0005
R9328 VSS.n2650 VSS.n1374 17.0005
R9329 VSS.n2650 VSS.n2649 17.0005
R9330 VSS.n1475 VSS.n1375 17.0005
R9331 VSS.n1474 VSS.n1375 17.0005
R9332 VSS.n2975 VSS.n2653 17.0005
R9333 VSS.n2976 VSS.n2653 17.0005
R9334 VSS.n2655 VSS.n2653 17.0005
R9335 VSS.n2979 VSS.n2652 17.0005
R9336 VSS.n2979 VSS.n1369 17.0005
R9337 VSS.n2786 VSS.n2785 17.0005
R9338 VSS.n2785 VSS.n2782 17.0005
R9339 VSS.n2785 VSS.n2784 17.0005
R9340 VSS.n2974 VSS.n2973 17.0005
R9341 VSS.n2973 VSS.n2654 17.0005
R9342 VSS.n2943 VSS.n2788 17.0005
R9343 VSS.n2944 VSS.n2788 17.0005
R9344 VSS.n2790 VSS.n2788 17.0005
R9345 VSS.n2947 VSS.n2787 17.0005
R9346 VSS.n2947 VSS.n2777 17.0005
R9347 VSS.n2834 VSS.n2832 17.0005
R9348 VSS.n2834 VSS.n2833 17.0005
R9349 VSS.n2835 VSS.n2834 17.0005
R9350 VSS.n2942 VSS.n2941 17.0005
R9351 VSS.n2941 VSS.n2789 17.0005
R9352 VSS.n2847 VSS.n2846 17.0005
R9353 VSS.n2846 VSS.n2826 17.0005
R9354 VSS.n2846 VSS.n2845 17.0005
R9355 VSS.n2831 VSS.n2827 17.0005
R9356 VSS.n2830 VSS.n2827 17.0005
R9357 VSS.n2900 VSS.n2849 17.0005
R9358 VSS.n2901 VSS.n2849 17.0005
R9359 VSS.n2851 VSS.n2849 17.0005
R9360 VSS.n2904 VSS.n2848 17.0005
R9361 VSS.n2904 VSS.n2821 17.0005
R9362 VSS.n2868 VSS.n2866 17.0005
R9363 VSS.n2868 VSS.n2867 17.0005
R9364 VSS.n2869 VSS.n2868 17.0005
R9365 VSS.n2899 VSS.n2898 17.0005
R9366 VSS.n2898 VSS.n2850 17.0005
R9367 VSS.n3472 VSS.n3471 17.0005
R9368 VSS.n3471 VSS.n980 17.0005
R9369 VSS.n3471 VSS.n3470 17.0005
R9370 VSS.n2865 VSS.n981 17.0005
R9371 VSS.n2864 VSS.n981 17.0005
R9372 VSS.n3483 VSS.n3479 17.0005
R9373 VSS.n3484 VSS.n3479 17.0005
R9374 VSS.n3479 VSS.n3478 17.0005
R9375 VSS.n3487 VSS.n3473 17.0005
R9376 VSS.n3487 VSS.n975 17.0005
R9377 VSS.n3481 VSS.n961 17.0005
R9378 VSS.n3482 VSS.n961 17.0005
R9379 VSS.n3509 VSS.n3508 17.0005
R9380 VSS.n3508 VSS.n960 17.0005
R9381 VSS.n3508 VSS.n3507 17.0005
R9382 VSS.n3511 VSS.n952 17.0005
R9383 VSS.n3511 VSS.n3510 17.0005
R9384 VSS.n3556 VSS.n3555 17.0005
R9385 VSS.n3555 VSS.n924 17.0005
R9386 VSS.n3555 VSS.n3554 17.0005
R9387 VSS.n3558 VSS.n916 17.0005
R9388 VSS.n3558 VSS.n3557 17.0005
R9389 VSS.n552 VSS.n551 17.0005
R9390 VSS.n565 VSS.n564 17.0005
R9391 VSS.n564 VSS.n560 17.0005
R9392 VSS.n564 VSS.n563 17.0005
R9393 VSS.n553 VSS.n1 17.0005
R9394 VSS.n554 VSS.n1 17.0005
R9395 VSS.n570 VSS.n546 17.0005
R9396 VSS.n571 VSS.n546 17.0005
R9397 VSS.n577 VSS.n546 17.0005
R9398 VSS.n574 VSS.n566 17.0005
R9399 VSS.n574 VSS.n547 17.0005
R9400 VSS.n589 VSS.n588 17.0005
R9401 VSS.n588 VSS.n544 17.0005
R9402 VSS.n588 VSS.n587 17.0005
R9403 VSS.n569 VSS.n545 17.0005
R9404 VSS.n568 VSS.n545 17.0005
R9405 VSS.n600 VSS.n596 17.0005
R9406 VSS.n601 VSS.n596 17.0005
R9407 VSS.n596 VSS.n595 17.0005
R9408 VSS.n604 VSS.n590 17.0005
R9409 VSS.n604 VSS.n539 17.0005
R9410 VSS.n640 VSS.n639 17.0005
R9411 VSS.n639 VSS.n479 17.0005
R9412 VSS.n639 VSS.n638 17.0005
R9413 VSS.n599 VSS.n480 17.0005
R9414 VSS.n598 VSS.n480 17.0005
R9415 VSS.n651 VSS.n647 17.0005
R9416 VSS.n652 VSS.n647 17.0005
R9417 VSS.n647 VSS.n646 17.0005
R9418 VSS.n655 VSS.n641 17.0005
R9419 VSS.n655 VSS.n474 17.0005
R9420 VSS.n690 VSS.n689 17.0005
R9421 VSS.n689 VSS.n461 17.0005
R9422 VSS.n689 VSS.n688 17.0005
R9423 VSS.n650 VSS.n462 17.0005
R9424 VSS.n649 VSS.n462 17.0005
R9425 VSS.n701 VSS.n697 17.0005
R9426 VSS.n702 VSS.n697 17.0005
R9427 VSS.n697 VSS.n696 17.0005
R9428 VSS.n705 VSS.n691 17.0005
R9429 VSS.n705 VSS.n456 17.0005
R9430 VSS.n740 VSS.n739 17.0005
R9431 VSS.n739 VSS.n443 17.0005
R9432 VSS.n739 VSS.n738 17.0005
R9433 VSS.n700 VSS.n444 17.0005
R9434 VSS.n699 VSS.n444 17.0005
R9435 VSS.n751 VSS.n747 17.0005
R9436 VSS.n752 VSS.n747 17.0005
R9437 VSS.n747 VSS.n746 17.0005
R9438 VSS.n755 VSS.n741 17.0005
R9439 VSS.n755 VSS.n438 17.0005
R9440 VSS.n790 VSS.n789 17.0005
R9441 VSS.n789 VSS.n425 17.0005
R9442 VSS.n789 VSS.n788 17.0005
R9443 VSS.n750 VSS.n426 17.0005
R9444 VSS.n749 VSS.n426 17.0005
R9445 VSS.n801 VSS.n797 17.0005
R9446 VSS.n802 VSS.n797 17.0005
R9447 VSS.n797 VSS.n796 17.0005
R9448 VSS.n805 VSS.n791 17.0005
R9449 VSS.n805 VSS.n420 17.0005
R9450 VSS.n837 VSS.n836 17.0005
R9451 VSS.n836 VSS.n407 17.0005
R9452 VSS.n836 VSS.n835 17.0005
R9453 VSS.n800 VSS.n408 17.0005
R9454 VSS.n799 VSS.n408 17.0005
R9455 VSS.n848 VSS.n844 17.0005
R9456 VSS.n849 VSS.n844 17.0005
R9457 VSS.n844 VSS.n843 17.0005
R9458 VSS.n852 VSS.n838 17.0005
R9459 VSS.n852 VSS.n402 17.0005
R9460 VSS.n846 VSS.n345 17.0005
R9461 VSS.n847 VSS.n345 17.0005
R9462 VSS.n904 VSS.n903 17.0005
R9463 VSS.n903 VSS.n344 17.0005
R9464 VSS.n903 VSS.n902 17.0005
R9465 VSS.n906 VSS.n336 17.0005
R9466 VSS.n906 VSS.n905 17.0005
R9467 VSS VSS.t1965 16.0687
R9468 VSS.n3310 VSS.t1966 15.9923
R9469 VSS.n3343 VSS.t1967 15.9923
R9470 VSS.n2988 VSS.n2987 15.9755
R9471 VSS.n2759 VSS.n2758 14.735
R9472 VSS.n3185 VSS.n3150 14.735
R9473 VSS.n3541 VSS.n3540 13.9411
R9474 VSS.n3541 VSS.n929 13.9411
R9475 VSS.n2726 VSS.n2725 13.9411
R9476 VSS.n3298 VSS.n1223 13.9411
R9477 VSS.n3414 VSS.n3413 13.9411
R9478 VSS.n3390 VSS.n1053 13.9411
R9479 VSS.n2710 VSS.n2709 13.9411
R9480 VSS.n3035 VSS.n3034 13.9411
R9481 VSS.n3068 VSS.n3067 13.9411
R9482 VSS.n3095 VSS.n3094 13.9411
R9483 VSS.n3116 VSS.n3115 13.9411
R9484 VSS.n3292 VSS.n1224 13.9411
R9485 VSS.n3141 VSS.n3140 13.9411
R9486 VSS.n3195 VSS.n3194 13.9411
R9487 VSS.n1258 VSS.n1054 13.9411
R9488 VSS.n3014 VSS.n3013 13.9411
R9489 VSS.n2695 VSS.n2694 13.9411
R9490 VSS.n2567 VSS.n1414 13.9411
R9491 VSS.n2608 VSS.n2607 13.9411
R9492 VSS.n2621 VSS.n1387 13.9411
R9493 VSS.n2541 VSS.n2540 13.9411
R9494 VSS.n3789 VSS.n3788 13.9411
R9495 VSS.n3774 VSS.n22 13.9411
R9496 VSS.n583 VSS.n59 13.9411
R9497 VSS.n608 VSS.n607 13.9411
R9498 VSS.n2841 VSS.n1016 13.767
R9499 VSS.n2924 VSS.n1016 13.5866
R9500 VSS.n3297 VSS.n3296 13.5005
R9501 VSS.n1105 VSS.n1038 13.5005
R9502 VSS.n3389 VSS.n3388 13.5005
R9503 VSS.n3192 VSS.n3191 13.5005
R9504 VSS.n3448 VSS.n3447 13.5005
R9505 VSS.n3741 VSS.n3740 13.5005
R9506 VSS.n2331 VSS.n2330 13.5005
R9507 VSS.n2333 VSS.n2332 13.5005
R9508 VSS.n2425 VSS.n2424 13.5005
R9509 VSS.n2427 VSS.n2426 13.5005
R9510 VSS.n2257 VSS.n1919 13.5005
R9511 VSS.n2280 VSS.n70 13.5005
R9512 VSS.n3739 VSS.n3738 13.5005
R9513 VSS.n496 VSS.n69 13.5005
R9514 VSS.n609 VSS.n608 13.5005
R9515 VSS.n2623 VSS.n2622 13.5005
R9516 VSS.n2578 VSS.n1398 13.5005
R9517 VSS.n2444 VSS.n2443 13.5005
R9518 VSS.n2413 VSS.n1489 13.5005
R9519 VSS.n2346 VSS.n2345 13.5005
R9520 VSS.n2319 VSS.n1524 13.5005
R9521 VSS.n2295 VSS.n2294 13.5005
R9522 VSS.n2293 VSS.n2292 13.5005
R9523 VSS.n2047 VSS.n60 13.5005
R9524 VSS.n3758 VSS.n3757 13.5005
R9525 VSS.n3760 VSS.n3759 13.5005
R9526 VSS.n529 VSS.n59 13.5005
R9527 VSS.n2609 VSS.n2608 13.5005
R9528 VSS.n2621 VSS.n2620 13.5005
R9529 VSS.n2567 VSS.n2566 13.5005
R9530 VSS.n2569 VSS.n2568 13.5005
R9531 VSS.n2402 VSS.n2401 13.5005
R9532 VSS.n2404 VSS.n2403 13.5005
R9533 VSS.n2155 VSS.n1511 13.5005
R9534 VSS.n2310 VSS.n2309 13.5005
R9535 VSS.n2308 VSS.n2307 13.5005
R9536 VSS.n2236 VSS.n1932 13.5005
R9537 VSS.n2057 VSS.n2056 13.5005
R9538 VSS.n1998 VSS.n23 13.5005
R9539 VSS.n3773 VSS.n3772 13.5005
R9540 VSS.n3775 VSS.n3774 13.5005
R9541 VSS.n2455 VSS.n1413 13.5005
R9542 VSS.n2446 VSS.n2445 13.5005
R9543 VSS.n1480 VSS.n1386 13.5005
R9544 VSS.n1295 VSS.n1294 13.5005
R9545 VSS.n1309 VSS.n1308 13.5005
R9546 VSS.n3446 VSS.n3445 13.5005
R9547 VSS.n3185 VSS.n3184 13.5005
R9548 VSS.n2709 VSS.n2708 13.5005
R9549 VSS.n2725 VSS.n2724 13.5005
R9550 VSS.n1216 VSS.n1017 13.5005
R9551 VSS.n3299 VSS.n3298 13.5005
R9552 VSS.n3413 VSS.n3412 13.5005
R9553 VSS.n3187 VSS.n3186 13.5005
R9554 VSS.n3391 VSS.n3390 13.5005
R9555 VSS.n1329 VSS.n1328 13.5005
R9556 VSS.n1343 VSS.n1342 13.5005
R9557 VSS.n2678 VSS.n2677 13.5005
R9558 VSS.n2758 VSS.n2757 13.5005
R9559 VSS.n1357 VSS.n1356 13.5005
R9560 VSS.n2694 VSS.n2693 13.5005
R9561 VSS.n3013 VSS.n3012 13.5005
R9562 VSS.n3036 VSS.n3035 13.5005
R9563 VSS.n3067 VSS.n3066 13.5005
R9564 VSS.n3096 VSS.n3095 13.5005
R9565 VSS.n3115 VSS.n3114 13.5005
R9566 VSS.n3292 VSS.n3291 13.5005
R9567 VSS.n3140 VSS.n3139 13.5005
R9568 VSS.n3194 VSS.n3193 13.5005
R9569 VSS.n3255 VSS.n1054 13.5005
R9570 VSS.n2542 VSS.n2541 13.5005
R9571 VSS.n2501 VSS.n2500 13.5005
R9572 VSS.n2468 VSS.n2467 13.5005
R9573 VSS.n2380 VSS.n1433 13.5005
R9574 VSS.n2103 VSS.n2102 13.5005
R9575 VSS.n2168 VSS.n2167 13.5005
R9576 VSS.n2201 VSS.n2200 13.5005
R9577 VSS.n2225 VSS.n2224 13.5005
R9578 VSS.n2227 VSS.n2226 13.5005
R9579 VSS.n2070 VSS.n2069 13.5005
R9580 VSS.n2011 VSS.n2010 13.5005
R9581 VSS.n42 VSS.n3 13.5005
R9582 VSS.n3788 VSS.n3787 13.5005
R9583 VSS.n2127 VSS.n2126 13.5005
R9584 VSS.n2361 VSS.n2360 13.5005
R9585 VSS.n2348 VSS.n2347 13.5005
R9586 VSS.n1567 VSS.n1498 13.5005
R9587 VSS.n3542 VSS.n3541 13.5005
R9588 VSS.n2504 VSS.t1112 13.2354
R9589 VSS.n880 VSS.n354 9.44113
R9590 VSS.n881 VSS.n880 9.44113
R9591 VSS.n3575 VSS.n3574 9.44113
R9592 VSS.n3575 VSS.n299 9.44113
R9593 VSS.n3243 VSS.t1856 9.26277
R9594 VSS.n880 VSS.n879 9.0005
R9595 VSS.n3576 VSS.n3575 9.0005
R9596 VSS.n37 VSS.n32 8.49776
R9597 VSS.n10 VSS.n6 8.49776
R9598 VSS.n1977 VSS.n1973 8.49776
R9599 VSS.n2208 VSS.n2204 8.49776
R9600 VSS.n2018 VSS.n2014 8.49776
R9601 VSS.n1966 VSS.n1955 8.49776
R9602 VSS.n2175 VSS.n2171 8.49776
R9603 VSS.n2134 VSS.n2130 8.49776
R9604 VSS.n2475 VSS.n2471 8.49776
R9605 VSS.n1428 VSS.n1423 8.49776
R9606 VSS.n2110 VSS.n2106 8.49776
R9607 VSS.n2375 VSS.n2370 8.49776
R9608 VSS.n2077 VSS.n2073 8.49776
R9609 VSS.n1440 VSS.n1436 8.49776
R9610 VSS.n551 VSS.n549 8.49776
R9611 VSS.n508 VSS.n494 8.45768
R9612 VSS.n41 VSS.n31 8.45768
R9613 VSS.n44 VSS.n31 8.45768
R9614 VSS.n3769 VSS.n24 8.45768
R9615 VSS.n3770 VSS.n3769 8.45768
R9616 VSS.n3763 VSS.n57 8.45768
R9617 VSS.n3763 VSS.n3762 8.45768
R9618 VSS.n508 VSS.n497 8.45768
R9619 VSS.n877 VSS.n876 8.45768
R9620 VSS.n876 VSS.n355 8.45768
R9621 VSS.n371 VSS.n366 8.45768
R9622 VSS.n371 VSS.n370 8.45768
R9623 VSS.n3784 VSS.n4 8.45768
R9624 VSS.n3785 VSS.n3784 8.45768
R9625 VSS.n3778 VSS.n20 8.45768
R9626 VSS.n3778 VSS.n3777 8.45768
R9627 VSS.n528 VSS.n491 8.45768
R9628 VSS.n531 VSS.n491 8.45768
R9629 VSS.n537 VSS.n489 8.45768
R9630 VSS.n611 VSS.n489 8.45768
R9631 VSS.n888 VSS.n352 8.45768
R9632 VSS.n894 VSS.n347 8.45768
R9633 VSS.n895 VSS.n894 8.45768
R9634 VSS.n888 VSS.n887 8.45768
R9635 VSS.n869 VSS.n378 8.45768
R9636 VSS.n866 VSS.n382 8.45768
R9637 VSS.n863 VSS.n387 8.45768
R9638 VSS.n630 VSS.n482 8.45768
R9639 VSS.n631 VSS.n630 8.45768
R9640 VSS.n472 VSS.n471 8.45768
R9641 VSS.n661 VSS.n471 8.45768
R9642 VSS.n680 VSS.n464 8.45768
R9643 VSS.n681 VSS.n680 8.45768
R9644 VSS.n454 VSS.n453 8.45768
R9645 VSS.n711 VSS.n453 8.45768
R9646 VSS.n730 VSS.n446 8.45768
R9647 VSS.n731 VSS.n730 8.45768
R9648 VSS.n436 VSS.n435 8.45768
R9649 VSS.n761 VSS.n435 8.45768
R9650 VSS.n780 VSS.n428 8.45768
R9651 VSS.n781 VSS.n780 8.45768
R9652 VSS.n418 VSS.n417 8.45768
R9653 VSS.n811 VSS.n417 8.45768
R9654 VSS.n827 VSS.n410 8.45768
R9655 VSS.n828 VSS.n827 8.45768
R9656 VSS.n859 VSS.n390 8.45768
R9657 VSS.n859 VSS.n858 8.45768
R9658 VSS.n3748 VSS.n67 8.45768
R9659 VSS.n2007 VSS.n1971 8.45768
R9660 VSS.n2008 VSS.n2007 8.45768
R9661 VSS.n2001 VSS.n1987 8.45768
R9662 VSS.n2001 VSS.n2000 8.45768
R9663 VSS.n3754 VSS.n61 8.45768
R9664 VSS.n3755 VSS.n3754 8.45768
R9665 VSS.n3748 VSS.n3747 8.45768
R9666 VSS.n2269 VSS.n2255 8.45768
R9667 VSS.n2221 VSS.n2202 8.45768
R9668 VSS.n2222 VSS.n2221 8.45768
R9669 VSS.n2304 VSS.n1933 8.45768
R9670 VSS.n2305 VSS.n2304 8.45768
R9671 VSS.n2298 VSS.n1943 8.45768
R9672 VSS.n2298 VSS.n2297 8.45768
R9673 VSS.n2269 VSS.n2258 8.45768
R9674 VSS.n3599 VSS.n278 8.45768
R9675 VSS.n2066 VSS.n2012 8.45768
R9676 VSS.n2067 VSS.n2066 8.45768
R9677 VSS.n2060 VSS.n2028 8.45768
R9678 VSS.n2060 VSS.n2059 8.45768
R9679 VSS.n2050 VSS.n2036 8.45768
R9680 VSS.n2050 VSS.n2049 8.45768
R9681 VSS.n3735 VSS.n71 8.45768
R9682 VSS.n3736 VSS.n3735 8.45768
R9683 VSS.n3729 VSS.n81 8.45768
R9684 VSS.n3729 VSS.n3728 8.45768
R9685 VSS.n3709 VSS.n95 8.45768
R9686 VSS.n3710 VSS.n3709 8.45768
R9687 VSS.n3703 VSS.n114 8.45768
R9688 VSS.n3703 VSS.n3702 8.45768
R9689 VSS.n3683 VSS.n137 8.45768
R9690 VSS.n3684 VSS.n3683 8.45768
R9691 VSS.n3677 VSS.n156 8.45768
R9692 VSS.n3677 VSS.n3676 8.45768
R9693 VSS.n3657 VSS.n179 8.45768
R9694 VSS.n3658 VSS.n3657 8.45768
R9695 VSS.n3651 VSS.n198 8.45768
R9696 VSS.n3651 VSS.n3650 8.45768
R9697 VSS.n3631 VSS.n221 8.45768
R9698 VSS.n3632 VSS.n3631 8.45768
R9699 VSS.n3625 VSS.n240 8.45768
R9700 VSS.n3625 VSS.n3624 8.45768
R9701 VSS.n3605 VSS.n263 8.45768
R9702 VSS.n3606 VSS.n3605 8.45768
R9703 VSS.n3599 VSS.n3598 8.45768
R9704 VSS.n331 VSS.n318 8.45768
R9705 VSS.n331 VSS.n320 8.45768
R9706 VSS.n1970 VSS.n1954 8.45768
R9707 VSS.n2229 VSS.n1954 8.45768
R9708 VSS.n2235 VSS.n1952 8.45768
R9709 VSS.n2238 VSS.n1952 8.45768
R9710 VSS.n2289 VSS.n1945 8.45768
R9711 VSS.n2290 VSS.n2289 8.45768
R9712 VSS.n2283 VSS.n2251 8.45768
R9713 VSS.n2283 VSS.n2282 8.45768
R9714 VSS.n315 VSS.n304 8.45768
R9715 VSS.n315 VSS.n305 8.45768
R9716 VSS.n3572 VSS.n3571 8.45768
R9717 VSS.n3571 VSS.n300 8.45768
R9718 VSS.n3581 VSS.n297 8.45768
R9719 VSS.n3581 VSS.n3580 8.45768
R9720 VSS.n3722 VSS.n83 8.45768
R9721 VSS.n3723 VSS.n3722 8.45768
R9722 VSS.n3716 VSS.n93 8.45768
R9723 VSS.n3716 VSS.n3715 8.45768
R9724 VSS.n3696 VSS.n116 8.45768
R9725 VSS.n3697 VSS.n3696 8.45768
R9726 VSS.n3690 VSS.n135 8.45768
R9727 VSS.n3690 VSS.n3689 8.45768
R9728 VSS.n3670 VSS.n158 8.45768
R9729 VSS.n3671 VSS.n3670 8.45768
R9730 VSS.n3664 VSS.n177 8.45768
R9731 VSS.n3664 VSS.n3663 8.45768
R9732 VSS.n3644 VSS.n200 8.45768
R9733 VSS.n3645 VSS.n3644 8.45768
R9734 VSS.n3638 VSS.n219 8.45768
R9735 VSS.n3638 VSS.n3637 8.45768
R9736 VSS.n3618 VSS.n242 8.45768
R9737 VSS.n3619 VSS.n3618 8.45768
R9738 VSS.n3612 VSS.n261 8.45768
R9739 VSS.n3612 VSS.n3611 8.45768
R9740 VSS.n3588 VSS.n280 8.45768
R9741 VSS.n3589 VSS.n3588 8.45768
R9742 VSS.n2328 VSS.n2327 8.45768
R9743 VSS.n2197 VSS.n2169 8.45768
R9744 VSS.n2198 VSS.n2197 8.45768
R9745 VSS.n1931 VSS.n1930 8.45768
R9746 VSS.n2312 VSS.n1930 8.45768
R9747 VSS.n2318 VSS.n1928 8.45768
R9748 VSS.n2321 VSS.n1928 8.45768
R9749 VSS.n2327 VSS.n1920 8.45768
R9750 VSS.n1764 VSS.n1760 8.45768
R9751 VSS.n2164 VSS.n2128 8.45768
R9752 VSS.n2165 VSS.n2164 8.45768
R9753 VSS.n2158 VSS.n2144 8.45768
R9754 VSS.n2158 VSS.n2157 8.45768
R9755 VSS.n2342 VSS.n1525 8.45768
R9756 VSS.n2343 VSS.n2342 8.45768
R9757 VSS.n2336 VSS.n1535 8.45768
R9758 VSS.n2336 VSS.n2335 8.45768
R9759 VSS.n1913 VSS.n1543 8.45768
R9760 VSS.n1913 VSS.n1912 8.45768
R9761 VSS.n1893 VSS.n1584 8.45768
R9762 VSS.n1894 VSS.n1893 8.45768
R9763 VSS.n1887 VSS.n1603 8.45768
R9764 VSS.n1887 VSS.n1886 8.45768
R9765 VSS.n1867 VSS.n1626 8.45768
R9766 VSS.n1868 VSS.n1867 8.45768
R9767 VSS.n1861 VSS.n1645 8.45768
R9768 VSS.n1861 VSS.n1860 8.45768
R9769 VSS.n1841 VSS.n1668 8.45768
R9770 VSS.n1842 VSS.n1841 8.45768
R9771 VSS.n1835 VSS.n1687 8.45768
R9772 VSS.n1835 VSS.n1834 8.45768
R9773 VSS.n1815 VSS.n1710 8.45768
R9774 VSS.n1816 VSS.n1815 8.45768
R9775 VSS.n1809 VSS.n1729 8.45768
R9776 VSS.n1809 VSS.n1808 8.45768
R9777 VSS.n1774 VSS.n1737 8.45768
R9778 VSS.n1774 VSS.n1773 8.45768
R9779 VSS.n1764 VSS.n1763 8.45768
R9780 VSS.n1753 VSS.n1748 8.45768
R9781 VSS.n1753 VSS.n1752 8.45768
R9782 VSS.n2497 VSS.n2469 8.45768
R9783 VSS.n2498 VSS.n2497 8.45768
R9784 VSS.n1412 VSS.n1411 8.45768
R9785 VSS.n2571 VSS.n1411 8.45768
R9786 VSS.n2577 VSS.n1409 8.45768
R9787 VSS.n2580 VSS.n1409 8.45768
R9788 VSS.n1385 VSS.n1384 8.45768
R9789 VSS.n2625 VSS.n1384 8.45768
R9790 VSS.n2618 VSS.n2617 8.45768
R9791 VSS.n1432 VSS.n1422 8.45768
R9792 VSS.n2544 VSS.n1422 8.45768
R9793 VSS.n2563 VSS.n1415 8.45768
R9794 VSS.n2564 VSS.n2563 8.45768
R9795 VSS.n1397 VSS.n1396 8.45768
R9796 VSS.n2611 VSS.n1396 8.45768
R9797 VSS.n2617 VSS.n1388 8.45768
R9798 VSS.n3407 VSS.n3406 8.45768
R9799 VSS.n3399 VSS.n3398 8.45768
R9800 VSS.n3394 VSS.n3393 8.45768
R9801 VSS.n1085 VSS.n1083 8.45768
R9802 VSS.n1080 VSS.n1079 8.45768
R9803 VSS.n3374 VSS.n1188 8.45768
R9804 VSS.n3367 VSS.n3366 8.45768
R9805 VSS.n3359 VSS.n3358 8.45768
R9806 VSS.n3351 VSS.n3350 8.45768
R9807 VSS.n3341 VSS.n3340 8.45768
R9808 VSS.n3346 VSS.n3345 8.45768
R9809 VSS.n3334 VSS.n3333 8.45768
R9810 VSS.n3326 VSS.n3325 8.45768
R9811 VSS.n3318 VSS.n3317 8.45768
R9812 VSS.n3308 VSS.n3307 8.45768
R9813 VSS.n3313 VSS.n3312 8.45768
R9814 VSS.n2999 VSS.n1362 8.45768
R9815 VSS.n3052 VSS.n3051 8.45768
R9816 VSS.n3057 VSS.n3056 8.45768
R9817 VSS.n3277 VSS.n3276 8.45768
R9818 VSS.n3282 VSS.n3281 8.45768
R9819 VSS.n3258 VSS.n3257 8.45768
R9820 VSS.n3248 VSS.n3247 8.45768
R9821 VSS.n2995 VSS.n2994 8.45768
R9822 VSS.n3020 VSS.n1349 8.45768
R9823 VSS.n3029 VSS.n3028 8.45768
R9824 VSS.n3080 VSS.n1315 8.45768
R9825 VSS.n3077 VSS.n1318 8.45768
R9826 VSS.n3074 VSS.n1321 8.45768
R9827 VSS.n3089 VSS.n3088 8.45768
R9828 VSS.n3122 VSS.n1287 8.45768
R9829 VSS.n3136 VSS.n1275 8.45768
R9830 VSS.n3133 VSS.n1278 8.45768
R9831 VSS.n3130 VSS.n1281 8.45768
R9832 VSS.n3147 VSS.n1269 8.45768
R9833 VSS.n3201 VSS.n1263 8.45768
R9834 VSS.n3204 VSS.n1259 8.45768
R9835 VSS.n3207 VSS.n1254 8.45768
R9836 VSS.n3210 VSS.n1251 8.45768
R9837 VSS.n3500 VSS.n3499 8.45768
R9838 VSS.n3499 VSS.n963 8.45768
R9839 VSS.n3238 VSS.n3223 8.45768
R9840 VSS.n3236 VSS.n3223 8.45768
R9841 VSS.n3217 VSS.n3216 8.45768
R9842 VSS.n3218 VSS.n3217 8.45768
R9843 VSS.n973 VSS.n972 8.45768
R9844 VSS.n3493 VSS.n972 8.45768
R9845 VSS.n3463 VSS.n3462 8.45768
R9846 VSS.n3458 VSS.n3457 8.45768
R9847 VSS.n1007 VSS.n1006 8.45768
R9848 VSS.n2911 VSS.n2818 8.45768
R9849 VSS.n2911 VSS.n2910 8.45768
R9850 VSS.n2891 VSS.n2870 8.45768
R9851 VSS.n2892 VSS.n2891 8.45768
R9852 VSS.n3462 VSS.n983 8.45768
R9853 VSS.n2928 VSS.n2810 8.45768
R9854 VSS.n3454 VSS.n1012 8.45768
R9855 VSS.n2953 VSS.n2765 8.45768
R9856 VSS.n2934 VSS.n2797 8.45768
R9857 VSS.n2935 VSS.n2934 8.45768
R9858 VSS.n2928 VSS.n2925 8.45768
R9859 VSS.n2953 VSS.n2952 8.45768
R9860 VSS.n2959 VSS.n2958 8.45768
R9861 VSS.n2966 VSS.n2662 8.45768
R9862 VSS.n2967 VSS.n2966 8.45768
R9863 VSS.n2690 VSS.n2689 8.45768
R9864 VSS.n2736 VSS.n2735 8.45768
R9865 VSS.n2741 VSS.n2740 8.45768
R9866 VSS.n3424 VSS.n3423 8.45768
R9867 VSS.n3429 VSS.n3428 8.45768
R9868 VSS.n3175 VSS.n3174 8.45768
R9869 VSS.n3166 VSS.n3165 8.45768
R9870 VSS.n2641 VSS.n1377 8.45768
R9871 VSS.n2642 VSS.n2641 8.45768
R9872 VSS.n2986 VSS.n1366 8.45768
R9873 VSS.n2986 VSS.n2985 8.45768
R9874 VSS.n2598 VSS.n2591 8.45768
R9875 VSS.n2537 VSS.n2502 8.45768
R9876 VSS.n2538 VSS.n2537 8.45768
R9877 VSS.n2531 VSS.n2518 8.45768
R9878 VSS.n2531 VSS.n2530 8.45768
R9879 VSS.n2604 VSS.n1399 8.45768
R9880 VSS.n2605 VSS.n2604 8.45768
R9881 VSS.n2598 VSS.n2597 8.45768
R9882 VSS.n2123 VSS.n2104 8.45768
R9883 VSS.n2124 VSS.n2123 8.45768
R9884 VSS.n2357 VSS.n1512 8.45768
R9885 VSS.n2358 VSS.n2357 8.45768
R9886 VSS.n2351 VSS.n1522 8.45768
R9887 VSS.n2351 VSS.n2350 8.45768
R9888 VSS.n1566 VSS.n1552 8.45768
R9889 VSS.n1569 VSS.n1552 8.45768
R9890 VSS.n2434 VSS.n1496 8.45768
R9891 VSS.n2379 VSS.n2369 8.45768
R9892 VSS.n2382 VSS.n2369 8.45768
R9893 VSS.n2398 VSS.n2362 8.45768
R9894 VSS.n2399 VSS.n2398 8.45768
R9895 VSS.n2440 VSS.n1490 8.45768
R9896 VSS.n2441 VSS.n2440 8.45768
R9897 VSS.n2434 VSS.n2433 8.45768
R9898 VSS.n2422 VSS.n2421 8.45768
R9899 VSS.n2099 VSS.n2071 8.45768
R9900 VSS.n2100 VSS.n2099 8.45768
R9901 VSS.n1510 VSS.n1509 8.45768
R9902 VSS.n2406 VSS.n1509 8.45768
R9903 VSS.n2412 VSS.n1507 8.45768
R9904 VSS.n2415 VSS.n1507 8.45768
R9905 VSS.n2421 VSS.n1499 8.45768
R9906 VSS.n1906 VSS.n1545 8.45768
R9907 VSS.n1907 VSS.n1906 8.45768
R9908 VSS.n1900 VSS.n1582 8.45768
R9909 VSS.n1900 VSS.n1899 8.45768
R9910 VSS.n1880 VSS.n1605 8.45768
R9911 VSS.n1881 VSS.n1880 8.45768
R9912 VSS.n1874 VSS.n1624 8.45768
R9913 VSS.n1874 VSS.n1873 8.45768
R9914 VSS.n1854 VSS.n1647 8.45768
R9915 VSS.n1855 VSS.n1854 8.45768
R9916 VSS.n1848 VSS.n1666 8.45768
R9917 VSS.n1848 VSS.n1847 8.45768
R9918 VSS.n1828 VSS.n1689 8.45768
R9919 VSS.n1829 VSS.n1828 8.45768
R9920 VSS.n1822 VSS.n1708 8.45768
R9921 VSS.n1822 VSS.n1821 8.45768
R9922 VSS.n1802 VSS.n1780 8.45768
R9923 VSS.n1803 VSS.n1802 8.45768
R9924 VSS.n3529 VSS.n945 8.45768
R9925 VSS.n3544 VSS.n927 8.45768
R9926 VSS.n3529 VSS.n3528 8.45768
R9927 VSS.n928 VSS.n927 8.45768
R9928 VSS.n3536 VSS.n936 8.45768
R9929 VSS.n3533 VSS.n941 8.45768
R9930 VSS.n3552 VSS.n925 8.45768
R9931 VSS.n3550 VSS.n925 8.45768
R9932 VSS.n3505 VSS.n961 8.45768
R9933 VSS.n2464 VSS.n1434 8.45768
R9934 VSS.n2465 VSS.n2464 8.45768
R9935 VSS.n2458 VSS.n1450 8.45768
R9936 VSS.n2458 VSS.n2457 8.45768
R9937 VSS.n2449 VSS.n1458 8.45768
R9938 VSS.n2449 VSS.n2448 8.45768
R9939 VSS.n1483 VSS.n1466 8.45768
R9940 VSS.n1483 VSS.n1482 8.45768
R9941 VSS.n1376 VSS.n1375 8.45768
R9942 VSS.n2647 VSS.n1375 8.45768
R9943 VSS.n2979 VSS.n1368 8.45768
R9944 VSS.n2980 VSS.n2979 8.45768
R9945 VSS.n2973 VSS.n2660 8.45768
R9946 VSS.n2973 VSS.n2972 8.45768
R9947 VSS.n2947 VSS.n2776 8.45768
R9948 VSS.n2948 VSS.n2947 8.45768
R9949 VSS.n2941 VSS.n2795 8.45768
R9950 VSS.n2941 VSS.n2940 8.45768
R9951 VSS.n2840 VSS.n2827 8.45768
R9952 VSS.n2843 VSS.n2827 8.45768
R9953 VSS.n2904 VSS.n2820 8.45768
R9954 VSS.n2905 VSS.n2904 8.45768
R9955 VSS.n2898 VSS.n2856 8.45768
R9956 VSS.n2898 VSS.n2897 8.45768
R9957 VSS.n982 VSS.n981 8.45768
R9958 VSS.n3468 VSS.n981 8.45768
R9959 VSS.n3487 VSS.n974 8.45768
R9960 VSS.n3488 VSS.n3487 8.45768
R9961 VSS.n962 VSS.n961 8.45768
R9962 VSS.n3511 VSS.n953 8.45768
R9963 VSS.n3511 VSS.n955 8.45768
R9964 VSS.n3558 VSS.n917 8.45768
R9965 VSS.n3558 VSS.n919 8.45768
R9966 VSS.n900 VSS.n345 8.45768
R9967 VSS.n3790 VSS.n1 8.45768
R9968 VSS.n561 VSS.n1 8.45768
R9969 VSS.n574 VSS.n548 8.45768
R9970 VSS.n576 VSS.n574 8.45768
R9971 VSS.n582 VSS.n545 8.45768
R9972 VSS.n585 VSS.n545 8.45768
R9973 VSS.n604 VSS.n538 8.45768
R9974 VSS.n605 VSS.n604 8.45768
R9975 VSS.n481 VSS.n480 8.45768
R9976 VSS.n636 VSS.n480 8.45768
R9977 VSS.n655 VSS.n473 8.45768
R9978 VSS.n656 VSS.n655 8.45768
R9979 VSS.n463 VSS.n462 8.45768
R9980 VSS.n686 VSS.n462 8.45768
R9981 VSS.n705 VSS.n455 8.45768
R9982 VSS.n706 VSS.n705 8.45768
R9983 VSS.n445 VSS.n444 8.45768
R9984 VSS.n736 VSS.n444 8.45768
R9985 VSS.n755 VSS.n437 8.45768
R9986 VSS.n756 VSS.n755 8.45768
R9987 VSS.n427 VSS.n426 8.45768
R9988 VSS.n786 VSS.n426 8.45768
R9989 VSS.n805 VSS.n419 8.45768
R9990 VSS.n806 VSS.n805 8.45768
R9991 VSS.n409 VSS.n408 8.45768
R9992 VSS.n833 VSS.n408 8.45768
R9993 VSS.n852 VSS.n401 8.45768
R9994 VSS.n853 VSS.n852 8.45768
R9995 VSS.n346 VSS.n345 8.45768
R9996 VSS.n906 VSS.n337 8.45768
R9997 VSS.n906 VSS.n339 8.45768
R9998 VSS.n3410 VSS.n1040 8.45768
R9999 VSS.n3402 VSS.n1046 8.45768
R10000 VSS.n3371 VSS.n3370 8.45768
R10001 VSS.n3362 VSS.n1195 8.45768
R10002 VSS.n3354 VSS.n1201 8.45768
R10003 VSS.n3337 VSS.n1209 8.45768
R10004 VSS.n3329 VSS.n1215 8.45768
R10005 VSS.n3321 VSS.n1222 8.45768
R10006 VSS.n3010 VSS.n1359 8.45768
R10007 VSS.n3038 VSS.n1337 8.45768
R10008 VSS.n3064 VSS.n1331 8.45768
R10009 VSS.n3098 VSS.n1303 8.45768
R10010 VSS.n3112 VSS.n1297 8.45768
R10011 VSS.n3289 VSS.n1226 8.45768
R10012 VSS.n3273 VSS.n3272 8.45768
R10013 VSS.n3265 VSS.n1240 8.45768
R10014 VSS.n3017 VSS.n1351 8.45768
R10015 VSS.n3032 VSS.n1345 8.45768
R10016 VSS.n3071 VSS.n1323 8.45768
R10017 VSS.n3092 VSS.n1311 8.45768
R10018 VSS.n3119 VSS.n1289 8.45768
R10019 VSS.n3127 VSS.n1283 8.45768
R10020 VSS.n3144 VSS.n1271 8.45768
R10021 VSS.n3198 VSS.n1265 8.45768
R10022 VSS.n3451 VSS.n1014 8.45768
R10023 VSS.n2962 VSS.n2676 8.45768
R10024 VSS.n2697 VSS.n2686 8.45768
R10025 VSS.n2755 VSS.n2680 8.45768
R10026 VSS.n2748 VSS.n2707 8.45768
R10027 VSS.n2732 VSS.n2731 8.45768
R10028 VSS.n3443 VSS.n1019 8.45768
R10029 VSS.n3436 VSS.n1025 8.45768
R10030 VSS.n3420 VSS.n3419 8.45768
R10031 VSS.n3182 VSS.n3153 8.45768
R10032 VSS.n3382 VSS.n1123 8.4148
R10033 VSS.n3382 VSS.n1134 8.4148
R10034 VSS.n3382 VSS.n1114 8.4148
R10035 VSS.n3382 VSS.n1146 8.4148
R10036 VSS.n3386 VSS.n1074 8.4148
R10037 VSS.n3386 VSS.n1093 8.4148
R10038 VSS.n3386 VSS.n1065 8.4148
R10039 VSS.n3386 VSS.n1109 8.4148
R10040 VSS.n3378 VSS.n1160 8.4148
R10041 VSS.n3378 VSS.n1171 8.4148
R10042 VSS.n3378 VSS.n1151 8.4148
R10043 VSS.n3378 VSS.n1183 8.4148
R10044 VSS.n2508 VSS.n2504 8.17938
R10045 VSS.n47 VSS.n29 5.59122
R10046 VSS.n54 VSS.n50 5.59122
R10047 VSS.n505 VSS.n501 5.59122
R10048 VSS.n873 VSS.n360 5.59122
R10049 VSS.n17 VSS.n13 5.59122
R10050 VSS.n525 VSS.n522 5.59122
R10051 VSS.n534 VSS.n490 5.59122
R10052 VSS.n399 VSS.n396 5.59122
R10053 VSS.n884 VSS.n350 5.59122
R10054 VSS.n614 VSS.n487 5.59122
R10055 VSS.n622 VSS.n619 5.59122
R10056 VSS.n664 VSS.n469 5.59122
R10057 VSS.n672 VSS.n669 5.59122
R10058 VSS.n714 VSS.n451 5.59122
R10059 VSS.n722 VSS.n719 5.59122
R10060 VSS.n764 VSS.n433 5.59122
R10061 VSS.n772 VSS.n769 5.59122
R10062 VSS.n814 VSS.n415 5.59122
R10063 VSS.n822 VSS.n819 5.59122
R10064 VSS.n1984 VSS.n1980 5.59122
R10065 VSS.n1996 VSS.n1993 5.59122
R10066 VSS.n3744 VSS.n64 5.59122
R10067 VSS.n2216 VSS.n2213 5.59122
R10068 VSS.n1940 VSS.n1936 5.59122
R10069 VSS.n2266 VSS.n2262 5.59122
R10070 VSS.n2025 VSS.n2021 5.59122
R10071 VSS.n2054 VSS.n2032 5.59122
R10072 VSS.n2045 VSS.n2042 5.59122
R10073 VSS.n78 VSS.n74 5.59122
R10074 VSS.n104 VSS.n100 5.59122
R10075 VSS.n111 VSS.n107 5.59122
R10076 VSS.n146 VSS.n142 5.59122
R10077 VSS.n153 VSS.n149 5.59122
R10078 VSS.n188 VSS.n184 5.59122
R10079 VSS.n195 VSS.n191 5.59122
R10080 VSS.n230 VSS.n226 5.59122
R10081 VSS.n237 VSS.n233 5.59122
R10082 VSS.n272 VSS.n268 5.59122
R10083 VSS.n3595 VSS.n275 5.59122
R10084 VSS.n328 VSS.n324 5.59122
R10085 VSS.n2232 VSS.n1953 5.59122
R10086 VSS.n2241 VSS.n1950 5.59122
R10087 VSS.n2248 VSS.n2244 5.59122
R10088 VSS.n312 VSS.n308 5.59122
R10089 VSS.n2278 VSS.n2275 5.59122
R10090 VSS.n90 VSS.n86 5.59122
R10091 VSS.n125 VSS.n121 5.59122
R10092 VSS.n132 VSS.n128 5.59122
R10093 VSS.n167 VSS.n163 5.59122
R10094 VSS.n174 VSS.n170 5.59122
R10095 VSS.n209 VSS.n205 5.59122
R10096 VSS.n216 VSS.n212 5.59122
R10097 VSS.n251 VSS.n247 5.59122
R10098 VSS.n258 VSS.n254 5.59122
R10099 VSS.n289 VSS.n285 5.59122
R10100 VSS.n2183 VSS.n2180 5.59122
R10101 VSS.n2315 VSS.n1929 5.59122
R10102 VSS.n2324 VSS.n1926 5.59122
R10103 VSS.n2141 VSS.n2137 5.59122
R10104 VSS.n2153 VSS.n2150 5.59122
R10105 VSS.n1532 VSS.n1528 5.59122
R10106 VSS.n1917 VSS.n1539 5.59122
R10107 VSS.n1593 VSS.n1589 5.59122
R10108 VSS.n1600 VSS.n1596 5.59122
R10109 VSS.n1635 VSS.n1631 5.59122
R10110 VSS.n1642 VSS.n1638 5.59122
R10111 VSS.n1677 VSS.n1673 5.59122
R10112 VSS.n1684 VSS.n1680 5.59122
R10113 VSS.n1719 VSS.n1715 5.59122
R10114 VSS.n1726 VSS.n1722 5.59122
R10115 VSS.n1778 VSS.n1733 5.59122
R10116 VSS.n1768 VSS.n1741 5.59122
R10117 VSS.n1757 VSS.n1746 5.59122
R10118 VSS.n2483 VSS.n2480 5.59122
R10119 VSS.n2574 VSS.n1410 5.59122
R10120 VSS.n2583 VSS.n1407 5.59122
R10121 VSS.n2547 VSS.n1420 5.59122
R10122 VSS.n2555 VSS.n2552 5.59122
R10123 VSS.n2614 VSS.n1394 5.59122
R10124 VSS.n3233 VSS.n3230 5.59122
R10125 VSS.n3241 VSS.n3221 5.59122
R10126 VSS.n3496 VSS.n970 5.59122
R10127 VSS.n1001 VSS.n998 5.59122
R10128 VSS.n2879 VSS.n2875 5.59122
R10129 VSS.n2887 VSS.n2884 5.59122
R10130 VSS.n2815 VSS.n2811 5.59122
R10131 VSS.n2806 VSS.n2802 5.59122
R10132 VSS.n2920 VSS.n2809 5.59122
R10133 VSS.n2772 VSS.n2769 5.59122
R10134 VSS.n2670 VSS.n2666 5.59122
R10135 VSS.n2628 VSS.n1382 5.59122
R10136 VSS.n2636 VSS.n2633 5.59122
R10137 VSS.n2515 VSS.n2511 5.59122
R10138 VSS.n2527 VSS.n2524 5.59122
R10139 VSS.n2594 VSS.n1402 5.59122
R10140 VSS.n2118 VSS.n2115 5.59122
R10141 VSS.n1519 VSS.n1515 5.59122
R10142 VSS.n1563 VSS.n1560 5.59122
R10143 VSS.n2385 VSS.n2367 5.59122
R10144 VSS.n2393 VSS.n2390 5.59122
R10145 VSS.n2430 VSS.n1493 5.59122
R10146 VSS.n2085 VSS.n2082 5.59122
R10147 VSS.n2409 VSS.n1508 5.59122
R10148 VSS.n2418 VSS.n1505 5.59122
R10149 VSS.n1572 VSS.n1550 5.59122
R10150 VSS.n1579 VSS.n1575 5.59122
R10151 VSS.n1614 VSS.n1610 5.59122
R10152 VSS.n1621 VSS.n1617 5.59122
R10153 VSS.n1656 VSS.n1652 5.59122
R10154 VSS.n1663 VSS.n1659 5.59122
R10155 VSS.n1698 VSS.n1694 5.59122
R10156 VSS.n1705 VSS.n1701 5.59122
R10157 VSS.n1789 VSS.n1785 5.59122
R10158 VSS.n1797 VSS.n1794 5.59122
R10159 VSS.n3526 VSS.n951 5.59122
R10160 VSS.n3547 VSS.n926 5.59122
R10161 VSS.n1447 VSS.n1443 5.59122
R10162 VSS.n2453 VSS.n1454 5.59122
R10163 VSS.n1487 VSS.n1462 5.59122
R10164 VSS.n1478 VSS.n1472 5.59122
R10165 VSS.n2650 VSS.n1373 5.59122
R10166 VSS.n2657 VSS.n2653 5.59122
R10167 VSS.n2785 VSS.n2781 5.59122
R10168 VSS.n2792 VSS.n2788 5.59122
R10169 VSS.n2837 VSS.n2834 5.59122
R10170 VSS.n2846 VSS.n2825 5.59122
R10171 VSS.n2853 VSS.n2849 5.59122
R10172 VSS.n2868 VSS.n2862 5.59122
R10173 VSS.n3471 VSS.n979 5.59122
R10174 VSS.n3479 VSS.n3476 5.59122
R10175 VSS.n3508 VSS.n959 5.59122
R10176 VSS.n3555 VSS.n923 5.59122
R10177 VSS.n564 VSS.n559 5.59122
R10178 VSS.n579 VSS.n546 5.59122
R10179 VSS.n588 VSS.n543 5.59122
R10180 VSS.n596 VSS.n593 5.59122
R10181 VSS.n639 VSS.n478 5.59122
R10182 VSS.n647 VSS.n644 5.59122
R10183 VSS.n689 VSS.n460 5.59122
R10184 VSS.n697 VSS.n694 5.59122
R10185 VSS.n739 VSS.n442 5.59122
R10186 VSS.n747 VSS.n744 5.59122
R10187 VSS.n789 VSS.n424 5.59122
R10188 VSS.n797 VSS.n794 5.59122
R10189 VSS.n836 VSS.n406 5.59122
R10190 VSS.n844 VSS.n841 5.59122
R10191 VSS.n903 VSS.n343 5.59122
R10192 VSS.n3376 VSS.t774 4.41443
R10193 VSS.n38 VSS.n37 4.18687
R10194 VSS.n367 VSS.n363 4.18687
R10195 VSS.n10 VSS.n9 4.18687
R10196 VSS.n1977 VSS.n1976 4.18687
R10197 VSS.n2208 VSS.n2207 4.18687
R10198 VSS.n2018 VSS.n2017 4.18687
R10199 VSS.n1967 VSS.n1966 4.18687
R10200 VSS.n3568 VSS.n3566 4.18687
R10201 VSS.n3577 VSS.n294 4.18687
R10202 VSS.n2175 VSS.n2174 4.18687
R10203 VSS.n2134 VSS.n2133 4.18687
R10204 VSS.n2475 VSS.n2474 4.18687
R10205 VSS.n1429 VSS.n1428 4.18687
R10206 VSS.n2508 VSS.n2507 4.18687
R10207 VSS.n2110 VSS.n2109 4.18687
R10208 VSS.n2376 VSS.n2375 4.18687
R10209 VSS.n2077 VSS.n2076 4.18687
R10210 VSS.n1440 VSS.n1439 4.18687
R10211 VSS.n551 VSS.n550 4.18687
R10212 VSS.n2628 VSS.n1379 3.66416
R10213 VSS.n2639 VSS.n2636 3.66416
R10214 VSS.n2641 VSS.n2640 3.66416
R10215 VSS.n2987 VSS.n2986 3.66416
R10216 VSS.n2598 VSS.n2589 3.24749
R10217 VSS.n2535 VSS.n2511 3.24749
R10218 VSS.n2537 VSS.n2536 3.24749
R10219 VSS.n2527 VSS.n2521 3.24749
R10220 VSS.n2531 VSS.n2519 3.24749
R10221 VSS.n2602 VSS.n1402 3.24749
R10222 VSS.n2604 VSS.n2603 3.24749
R10223 VSS.n3499 VSS.n965 3.2274
R10224 VSS.n3230 VSS.n3224 3.2274
R10225 VSS.n3225 VSS.n3223 3.2274
R10226 VSS.n3241 VSS.n3213 3.2274
R10227 VSS.n3217 VSS.n915 3.2274
R10228 VSS.n3496 VSS.n967 2.20675
R10229 VSS.n2670 VSS.n1363 2.20675
R10230 VSS.n3497 VSS.n966 1.95045
R10231 VSS.n991 VSS.n972 1.80181
R10232 VSS.n3555 VSS.n920 1.69954
R10233 VSS.n3559 VSS.n3558 1.69954
R10234 VSS.n2879 VSS.n2872 1.56153
R10235 VSS.n2911 VSS.n2819 1.56153
R10236 VSS.n2889 VSS.n2887 1.56153
R10237 VSS.n2891 VSS.n2890 1.56153
R10238 VSS.n2806 VSS.n2799 1.56153
R10239 VSS.n2953 VSS.n2766 1.56153
R10240 VSS.n2932 VSS.n2809 1.56153
R10241 VSS.n2934 VSS.n2933 1.56153
R10242 VSS.n2966 VSS.n2965 1.56153
R10243 VSS.n3447 VSS.n1016 1.43741
R10244 VSS.n614 VSS.n484 1.29786
R10245 VSS.n628 VSS.n622 1.29786
R10246 VSS.n630 VSS.n629 1.29786
R10247 VSS.n664 VSS.n466 1.29786
R10248 VSS.n623 VSS.n471 1.29786
R10249 VSS.n678 VSS.n672 1.29786
R10250 VSS.n680 VSS.n679 1.29786
R10251 VSS.n714 VSS.n448 1.29786
R10252 VSS.n673 VSS.n453 1.29786
R10253 VSS.n728 VSS.n722 1.29786
R10254 VSS.n730 VSS.n729 1.29786
R10255 VSS.n764 VSS.n430 1.29786
R10256 VSS.n723 VSS.n435 1.29786
R10257 VSS.n778 VSS.n772 1.29786
R10258 VSS.n780 VSS.n779 1.29786
R10259 VSS.n814 VSS.n412 1.29786
R10260 VSS.n773 VSS.n417 1.29786
R10261 VSS.n825 VSS.n822 1.29786
R10262 VSS.n827 VSS.n826 1.29786
R10263 VSS.n2278 VSS.n2272 1.29786
R10264 VSS.n3720 VSS.n86 1.29786
R10265 VSS.n3722 VSS.n3721 1.29786
R10266 VSS.n125 VSS.n118 1.29786
R10267 VSS.n3716 VSS.n94 1.29786
R10268 VSS.n3694 VSS.n128 1.29786
R10269 VSS.n3696 VSS.n3695 1.29786
R10270 VSS.n167 VSS.n160 1.29786
R10271 VSS.n3690 VSS.n136 1.29786
R10272 VSS.n3668 VSS.n170 1.29786
R10273 VSS.n3670 VSS.n3669 1.29786
R10274 VSS.n209 VSS.n202 1.29786
R10275 VSS.n3664 VSS.n178 1.29786
R10276 VSS.n3642 VSS.n212 1.29786
R10277 VSS.n3644 VSS.n3643 1.29786
R10278 VSS.n251 VSS.n244 1.29786
R10279 VSS.n3638 VSS.n220 1.29786
R10280 VSS.n3616 VSS.n254 1.29786
R10281 VSS.n3618 VSS.n3617 1.29786
R10282 VSS.n289 VSS.n282 1.29786
R10283 VSS.n3612 VSS.n262 1.29786
R10284 VSS.n3588 VSS.n3587 1.29786
R10285 VSS.n1572 VSS.n1547 1.29786
R10286 VSS.n1904 VSS.n1575 1.29786
R10287 VSS.n1906 VSS.n1905 1.29786
R10288 VSS.n1614 VSS.n1607 1.29786
R10289 VSS.n1900 VSS.n1583 1.29786
R10290 VSS.n1878 VSS.n1617 1.29786
R10291 VSS.n1880 VSS.n1879 1.29786
R10292 VSS.n1656 VSS.n1649 1.29786
R10293 VSS.n1874 VSS.n1625 1.29786
R10294 VSS.n1852 VSS.n1659 1.29786
R10295 VSS.n1854 VSS.n1853 1.29786
R10296 VSS.n1698 VSS.n1691 1.29786
R10297 VSS.n1848 VSS.n1667 1.29786
R10298 VSS.n1826 VSS.n1701 1.29786
R10299 VSS.n1828 VSS.n1827 1.29786
R10300 VSS.n1789 VSS.n1782 1.29786
R10301 VSS.n1822 VSS.n1709 1.29786
R10302 VSS.n1800 VSS.n1797 1.29786
R10303 VSS.n1802 VSS.n1801 1.29786
R10304 VSS.n3519 VSS.n926 1.29786
R10305 VSS.n3514 VSS.n925 1.29786
R10306 VSS.n3447 VSS.n3446 1.23501
R10307 VSS.n1001 VSS.n995 1.14288
R10308 VSS.n3462 VSS.n984 1.14288
R10309 VSS.n2916 VSS.n2811 1.14288
R10310 VSS.n2928 VSS.n2917 1.14288
R10311 VSS.n2769 VSS.n2673 1.14288
R10312 VSS.n3298 VSS.n3297 0.775529
R10313 VSS.n3413 VSS.n1038 0.775529
R10314 VSS.n3390 VSS.n3389 0.775529
R10315 VSS.n3192 VSS.n3187 0.775529
R10316 VSS.n1295 VSS.n1017 0.775529
R10317 VSS.n2725 VSS.n1309 0.775529
R10318 VSS.n2709 VSS.n1329 0.775529
R10319 VSS.n2678 VSS.n1343 0.775529
R10320 VSS.n2694 VSS.n1357 0.775529
R10321 VSS.n1183 VSS.n1182 0.486213
R10322 VSS.n1109 VSS.n1108 0.486213
R10323 VSS.n1074 VSS.n1073 0.486213
R10324 VSS.n1146 VSS.n1145 0.486213
R10325 VSS.n1123 VSS.n1122 0.486213
R10326 VSS.n1160 VSS.n1159 0.486213
R10327 VSS.n3187 VSS.n3185 0.441129
R10328 VSS.n608 VSS.n69 0.441129
R10329 VSS.n3740 VSS.n69 0.441129
R10330 VSS.n3740 VSS.n3739 0.441129
R10331 VSS.n3739 VSS.n70 0.441129
R10332 VSS.n1919 VSS.n70 0.441129
R10333 VSS.n2331 VSS.n1919 0.441129
R10334 VSS.n2332 VSS.n2331 0.441129
R10335 VSS.n2332 VSS.n1498 0.441129
R10336 VSS.n2425 VSS.n1498 0.441129
R10337 VSS.n2426 VSS.n2425 0.441129
R10338 VSS.n2426 VSS.n1386 0.441129
R10339 VSS.n2622 VSS.n1386 0.441129
R10340 VSS.n2622 VSS.n2621 0.441129
R10341 VSS.n3759 VSS.n59 0.441129
R10342 VSS.n3759 VSS.n3758 0.441129
R10343 VSS.n3758 VSS.n60 0.441129
R10344 VSS.n2293 VSS.n60 0.441129
R10345 VSS.n2294 VSS.n2293 0.441129
R10346 VSS.n2294 VSS.n1524 0.441129
R10347 VSS.n2346 VSS.n1524 0.441129
R10348 VSS.n2347 VSS.n2346 0.441129
R10349 VSS.n2347 VSS.n1489 0.441129
R10350 VSS.n2444 VSS.n1489 0.441129
R10351 VSS.n2445 VSS.n2444 0.441129
R10352 VSS.n2445 VSS.n1398 0.441129
R10353 VSS.n2608 VSS.n1398 0.441129
R10354 VSS.n3774 VSS.n3773 0.441129
R10355 VSS.n3773 VSS.n23 0.441129
R10356 VSS.n2056 VSS.n23 0.441129
R10357 VSS.n2056 VSS.n1932 0.441129
R10358 VSS.n2308 VSS.n1932 0.441129
R10359 VSS.n2309 VSS.n2308 0.441129
R10360 VSS.n2309 VSS.n1511 0.441129
R10361 VSS.n2361 VSS.n1511 0.441129
R10362 VSS.n2403 VSS.n2361 0.441129
R10363 VSS.n2403 VSS.n2402 0.441129
R10364 VSS.n2402 VSS.n1413 0.441129
R10365 VSS.n2568 VSS.n1413 0.441129
R10366 VSS.n2568 VSS.n2567 0.441129
R10367 VSS.n3446 VSS.n1017 0.441129
R10368 VSS.n2758 VSS.n2678 0.441129
R10369 VSS.n3788 VSS.n3 0.441129
R10370 VSS.n2011 VSS.n3 0.441129
R10371 VSS.n2070 VSS.n2011 0.441129
R10372 VSS.n2226 VSS.n2070 0.441129
R10373 VSS.n2226 VSS.n2225 0.441129
R10374 VSS.n2225 VSS.n2201 0.441129
R10375 VSS.n2201 VSS.n2168 0.441129
R10376 VSS.n2168 VSS.n2127 0.441129
R10377 VSS.n2127 VSS.n2103 0.441129
R10378 VSS.n2103 VSS.n1433 0.441129
R10379 VSS.n2468 VSS.n1433 0.441129
R10380 VSS.n2501 VSS.n2468 0.441129
R10381 VSS.n2541 VSS.n2501 0.441129
R10382 VSS.n3297 VSS.n3292 0.437357
R10383 VSS.n3140 VSS.n1038 0.437357
R10384 VSS.n3389 VSS.n1054 0.437357
R10385 VSS.n3194 VSS.n3192 0.437357
R10386 VSS.n3115 VSS.n1295 0.437357
R10387 VSS.n3095 VSS.n1309 0.437357
R10388 VSS.n3067 VSS.n1329 0.437357
R10389 VSS.n3035 VSS.n1343 0.437357
R10390 VSS.n3013 VSS.n1357 0.437357
R10391 VSS.n1182 VSS.n1181 0.351125
R10392 VSS.n1354 VSS.n1353 0.351125
R10393 VSS.n1175 VSS.n1174 0.351125
R10394 VSS.n1177 VSS.n1176 0.351125
R10395 VSS.n1340 VSS.n1339 0.351125
R10396 VSS.n1154 VSS.n1153 0.351125
R10397 VSS.n1169 VSS.n1168 0.351125
R10398 VSS.n1326 VSS.n1325 0.351125
R10399 VSS.n1162 VSS.n1161 0.351125
R10400 VSS.n1164 VSS.n1163 0.351125
R10401 VSS.n1108 VSS.n1107 0.351125
R10402 VSS.n1104 VSS.n1103 0.351125
R10403 VSS.n1097 VSS.n1096 0.351125
R10404 VSS.n1099 VSS.n1098 0.351125
R10405 VSS.n3189 VSS.n3188 0.351125
R10406 VSS.n1068 VSS.n1067 0.351125
R10407 VSS.n1091 VSS.n1090 0.351125
R10408 VSS.n1056 VSS.n1055 0.351125
R10409 VSS.n1059 VSS.n1058 0.351125
R10410 VSS.n1061 VSS.n1060 0.351125
R10411 VSS.n1073 VSS.n1072 0.351125
R10412 VSS.n1145 VSS.n1144 0.351125
R10413 VSS.n1306 VSS.n1305 0.351125
R10414 VSS.n1138 VSS.n1137 0.351125
R10415 VSS.n1140 VSS.n1139 0.351125
R10416 VSS.n1292 VSS.n1291 0.351125
R10417 VSS.n1117 VSS.n1116 0.351125
R10418 VSS.n1132 VSS.n1131 0.351125
R10419 VSS.n3294 VSS.n3293 0.351125
R10420 VSS.n1125 VSS.n1124 0.351125
R10421 VSS.n1127 VSS.n1126 0.351125
R10422 VSS.n1122 VSS.n1121 0.351125
R10423 VSS.n1159 VSS.n1158 0.351125
R10424 VSS.n1101 VSS.n1100 0.348833
R10425 VSS.n1092 VSS.n1069 0.348833
R10426 VSS.n3387 VSS.n1062 0.348833
R10427 VSS.n1142 VSS.n1141 0.348833
R10428 VSS.n1133 VSS.n1118 0.348833
R10429 VSS.n1129 VSS.n1128 0.348833
R10430 VSS.n1179 VSS.n1178 0.348833
R10431 VSS.n1170 VSS.n1155 0.348833
R10432 VSS.n1166 VSS.n1165 0.348833
R10433 VSS.n509 VSS.n508 0.333113
R10434 VSS.n47 VSS.n26 0.333113
R10435 VSS.n33 VSS.n31 0.333113
R10436 VSS.n3767 VSS.n50 0.333113
R10437 VSS.n3769 VSS.n3768 0.333113
R10438 VSS.n505 VSS.n498 0.333113
R10439 VSS.n3763 VSS.n58 0.333113
R10440 VSS.n876 VSS.n334 0.333113
R10441 VSS.n873 VSS.n357 0.333113
R10442 VSS.n371 VSS.n333 0.333113
R10443 VSS.n375 VSS.n363 0.333113
R10444 VSS.n3782 VSS.n13 0.333113
R10445 VSS.n3784 VSS.n3783 0.333113
R10446 VSS.n522 VSS.n492 0.333113
R10447 VSS.n3778 VSS.n21 0.333113
R10448 VSS.n516 VSS.n490 0.333113
R10449 VSS.n517 VSS.n491 0.333113
R10450 VSS.n511 VSS.n489 0.333113
R10451 VSS.n888 VSS.n335 0.333113
R10452 VSS.n399 VSS.n393 0.333113
R10453 VSS.n892 VSS.n350 0.333113
R10454 VSS.n894 VSS.n893 0.333113
R10455 VSS.n3748 VSS.n66 0.333113
R10456 VSS.n2005 VSS.n1980 0.333113
R10457 VSS.n2007 VSS.n2006 0.333113
R10458 VSS.n1996 VSS.n1990 0.333113
R10459 VSS.n2001 VSS.n1988 0.333113
R10460 VSS.n3752 VSS.n64 0.333113
R10461 VSS.n3754 VSS.n3753 0.333113
R10462 VSS.n2270 VSS.n2269 0.333113
R10463 VSS.n2219 VSS.n2216 0.333113
R10464 VSS.n2221 VSS.n2220 0.333113
R10465 VSS.n2302 VSS.n1936 0.333113
R10466 VSS.n2304 VSS.n2303 0.333113
R10467 VSS.n2266 VSS.n2259 0.333113
R10468 VSS.n2298 VSS.n1944 0.333113
R10469 VSS.n3599 VSS.n277 0.333113
R10470 VSS.n2064 VSS.n2021 0.333113
R10471 VSS.n2066 VSS.n2065 0.333113
R10472 VSS.n2054 VSS.n2031 0.333113
R10473 VSS.n2060 VSS.n2029 0.333113
R10474 VSS.n2045 VSS.n2039 0.333113
R10475 VSS.n2050 VSS.n2037 0.333113
R10476 VSS.n3733 VSS.n74 0.333113
R10477 VSS.n3735 VSS.n3734 0.333113
R10478 VSS.n104 VSS.n97 0.333113
R10479 VSS.n3729 VSS.n82 0.333113
R10480 VSS.n3707 VSS.n107 0.333113
R10481 VSS.n3709 VSS.n3708 0.333113
R10482 VSS.n146 VSS.n139 0.333113
R10483 VSS.n3703 VSS.n115 0.333113
R10484 VSS.n3681 VSS.n149 0.333113
R10485 VSS.n3683 VSS.n3682 0.333113
R10486 VSS.n188 VSS.n181 0.333113
R10487 VSS.n3677 VSS.n157 0.333113
R10488 VSS.n3655 VSS.n191 0.333113
R10489 VSS.n3657 VSS.n3656 0.333113
R10490 VSS.n230 VSS.n223 0.333113
R10491 VSS.n3651 VSS.n199 0.333113
R10492 VSS.n3629 VSS.n233 0.333113
R10493 VSS.n3631 VSS.n3630 0.333113
R10494 VSS.n272 VSS.n265 0.333113
R10495 VSS.n3625 VSS.n241 0.333113
R10496 VSS.n3603 VSS.n275 0.333113
R10497 VSS.n3605 VSS.n3604 0.333113
R10498 VSS.n328 VSS.n321 0.333113
R10499 VSS.n332 VSS.n331 0.333113
R10500 VSS.n1961 VSS.n1953 0.333113
R10501 VSS.n1962 VSS.n1954 0.333113
R10502 VSS.n2241 VSS.n1947 0.333113
R10503 VSS.n1956 VSS.n1952 0.333113
R10504 VSS.n2287 VSS.n2244 0.333113
R10505 VSS.n2289 VSS.n2288 0.333113
R10506 VSS.n2283 VSS.n2252 0.333113
R10507 VSS.n316 VSS.n315 0.333113
R10508 VSS.n312 VSS.n292 0.333113
R10509 VSS.n3571 VSS.n3563 0.333113
R10510 VSS.n3568 VSS.n293 0.333113
R10511 VSS.n3581 VSS.n296 0.333113
R10512 VSS.n3585 VSS.n294 0.333113
R10513 VSS.n2327 VSS.n1922 0.333113
R10514 VSS.n2195 VSS.n2183 0.333113
R10515 VSS.n2197 VSS.n2196 0.333113
R10516 VSS.n2189 VSS.n1929 0.333113
R10517 VSS.n2190 VSS.n1930 0.333113
R10518 VSS.n2324 VSS.n1923 0.333113
R10519 VSS.n2184 VSS.n1928 0.333113
R10520 VSS.n1764 VSS.n1743 0.333113
R10521 VSS.n2162 VSS.n2137 0.333113
R10522 VSS.n2164 VSS.n2163 0.333113
R10523 VSS.n2153 VSS.n2147 0.333113
R10524 VSS.n2158 VSS.n2145 0.333113
R10525 VSS.n2340 VSS.n1528 0.333113
R10526 VSS.n2342 VSS.n2341 0.333113
R10527 VSS.n1917 VSS.n1538 0.333113
R10528 VSS.n2336 VSS.n1536 0.333113
R10529 VSS.n1593 VSS.n1586 0.333113
R10530 VSS.n1913 VSS.n1544 0.333113
R10531 VSS.n1891 VSS.n1596 0.333113
R10532 VSS.n1893 VSS.n1892 0.333113
R10533 VSS.n1635 VSS.n1628 0.333113
R10534 VSS.n1887 VSS.n1604 0.333113
R10535 VSS.n1865 VSS.n1638 0.333113
R10536 VSS.n1867 VSS.n1866 0.333113
R10537 VSS.n1677 VSS.n1670 0.333113
R10538 VSS.n1861 VSS.n1646 0.333113
R10539 VSS.n1839 VSS.n1680 0.333113
R10540 VSS.n1841 VSS.n1840 0.333113
R10541 VSS.n1719 VSS.n1712 0.333113
R10542 VSS.n1835 VSS.n1688 0.333113
R10543 VSS.n1813 VSS.n1722 0.333113
R10544 VSS.n1815 VSS.n1814 0.333113
R10545 VSS.n1778 VSS.n1732 0.333113
R10546 VSS.n1809 VSS.n1730 0.333113
R10547 VSS.n1768 VSS.n1740 0.333113
R10548 VSS.n1774 VSS.n1738 0.333113
R10549 VSS.n1757 VSS.n1745 0.333113
R10550 VSS.n1753 VSS.n914 0.333113
R10551 VSS.n2495 VSS.n2483 0.333113
R10552 VSS.n2497 VSS.n2496 0.333113
R10553 VSS.n2489 VSS.n1410 0.333113
R10554 VSS.n2490 VSS.n1411 0.333113
R10555 VSS.n2583 VSS.n1404 0.333113
R10556 VSS.n2484 VSS.n1409 0.333113
R10557 VSS.n2587 VSS.n1384 0.333113
R10558 VSS.n2617 VSS.n1390 0.333113
R10559 VSS.n2547 VSS.n1417 0.333113
R10560 VSS.n1424 VSS.n1422 0.333113
R10561 VSS.n2561 VSS.n2555 0.333113
R10562 VSS.n2563 VSS.n2562 0.333113
R10563 VSS.n2614 VSS.n1391 0.333113
R10564 VSS.n2556 VSS.n1396 0.333113
R10565 VSS.n2121 VSS.n2118 0.333113
R10566 VSS.n2123 VSS.n2122 0.333113
R10567 VSS.n2355 VSS.n1515 0.333113
R10568 VSS.n2357 VSS.n2356 0.333113
R10569 VSS.n1560 VSS.n1553 0.333113
R10570 VSS.n2351 VSS.n1523 0.333113
R10571 VSS.n1555 VSS.n1552 0.333113
R10572 VSS.n2434 VSS.n1495 0.333113
R10573 VSS.n2385 VSS.n2364 0.333113
R10574 VSS.n2371 VSS.n2369 0.333113
R10575 VSS.n2396 VSS.n2393 0.333113
R10576 VSS.n2398 VSS.n2397 0.333113
R10577 VSS.n2438 VSS.n1493 0.333113
R10578 VSS.n2440 VSS.n2439 0.333113
R10579 VSS.n2421 VSS.n1501 0.333113
R10580 VSS.n2097 VSS.n2085 0.333113
R10581 VSS.n2099 VSS.n2098 0.333113
R10582 VSS.n2091 VSS.n1508 0.333113
R10583 VSS.n2092 VSS.n1509 0.333113
R10584 VSS.n2418 VSS.n1502 0.333113
R10585 VSS.n2086 VSS.n1507 0.333113
R10586 VSS.n3521 VSS.n927 0.333113
R10587 VSS.n3526 VSS.n943 0.333113
R10588 VSS.n3480 VSS.n961 0.333113
R10589 VSS.n2462 VSS.n1443 0.333113
R10590 VSS.n2464 VSS.n2463 0.333113
R10591 VSS.n2453 VSS.n1453 0.333113
R10592 VSS.n2458 VSS.n1451 0.333113
R10593 VSS.n1487 VSS.n1461 0.333113
R10594 VSS.n2449 VSS.n1459 0.333113
R10595 VSS.n1478 VSS.n1469 0.333113
R10596 VSS.n1483 VSS.n1467 0.333113
R10597 VSS.n2650 VSS.n1370 0.333113
R10598 VSS.n1473 VSS.n1375 0.333113
R10599 VSS.n2977 VSS.n2653 0.333113
R10600 VSS.n2979 VSS.n2978 0.333113
R10601 VSS.n2785 VSS.n2778 0.333113
R10602 VSS.n2973 VSS.n2661 0.333113
R10603 VSS.n2945 VSS.n2788 0.333113
R10604 VSS.n2947 VSS.n2946 0.333113
R10605 VSS.n2834 VSS.n2828 0.333113
R10606 VSS.n2941 VSS.n2796 0.333113
R10607 VSS.n2846 VSS.n2822 0.333113
R10608 VSS.n2829 VSS.n2827 0.333113
R10609 VSS.n2902 VSS.n2849 0.333113
R10610 VSS.n2904 VSS.n2903 0.333113
R10611 VSS.n2868 VSS.n2859 0.333113
R10612 VSS.n2898 VSS.n2857 0.333113
R10613 VSS.n3471 VSS.n976 0.333113
R10614 VSS.n2863 VSS.n981 0.333113
R10615 VSS.n3485 VSS.n3479 0.333113
R10616 VSS.n3487 VSS.n3486 0.333113
R10617 VSS.n3508 VSS.n956 0.333113
R10618 VSS.n3512 VSS.n3511 0.333113
R10619 VSS.n845 VSS.n345 0.333113
R10620 VSS.n564 VSS.n556 0.333113
R10621 VSS.n555 VSS.n1 0.333113
R10622 VSS.n572 VSS.n546 0.333113
R10623 VSS.n574 VSS.n573 0.333113
R10624 VSS.n588 VSS.n540 0.333113
R10625 VSS.n567 VSS.n545 0.333113
R10626 VSS.n602 VSS.n596 0.333113
R10627 VSS.n604 VSS.n603 0.333113
R10628 VSS.n639 VSS.n475 0.333113
R10629 VSS.n597 VSS.n480 0.333113
R10630 VSS.n653 VSS.n647 0.333113
R10631 VSS.n655 VSS.n654 0.333113
R10632 VSS.n689 VSS.n457 0.333113
R10633 VSS.n648 VSS.n462 0.333113
R10634 VSS.n703 VSS.n697 0.333113
R10635 VSS.n705 VSS.n704 0.333113
R10636 VSS.n739 VSS.n439 0.333113
R10637 VSS.n698 VSS.n444 0.333113
R10638 VSS.n753 VSS.n747 0.333113
R10639 VSS.n755 VSS.n754 0.333113
R10640 VSS.n789 VSS.n421 0.333113
R10641 VSS.n748 VSS.n426 0.333113
R10642 VSS.n803 VSS.n797 0.333113
R10643 VSS.n805 VSS.n804 0.333113
R10644 VSS.n836 VSS.n403 0.333113
R10645 VSS.n798 VSS.n408 0.333113
R10646 VSS.n850 VSS.n844 0.333113
R10647 VSS.n852 VSS.n851 0.333113
R10648 VSS.n903 VSS.n340 0.333113
R10649 VSS.n907 VSS.n906 0.333113
R10650 VSS.n1355 VSS.n1354 0.313313
R10651 VSS.n1179 VSS.n1175 0.313313
R10652 VSS.n1178 VSS.n1177 0.313313
R10653 VSS.n1341 VSS.n1340 0.313313
R10654 VSS.n1155 VSS.n1154 0.313313
R10655 VSS.n1170 VSS.n1169 0.313313
R10656 VSS.n1327 VSS.n1326 0.313313
R10657 VSS.n1166 VSS.n1162 0.313313
R10658 VSS.n1165 VSS.n1164 0.313313
R10659 VSS.n1106 VSS.n1104 0.313313
R10660 VSS.n1101 VSS.n1097 0.313313
R10661 VSS.n1100 VSS.n1099 0.313313
R10662 VSS.n3190 VSS.n3189 0.313313
R10663 VSS.n1069 VSS.n1068 0.313313
R10664 VSS.n1092 VSS.n1091 0.313313
R10665 VSS.n1057 VSS.n1056 0.313313
R10666 VSS.n3387 VSS.n1059 0.313313
R10667 VSS.n1062 VSS.n1061 0.313313
R10668 VSS.n1307 VSS.n1306 0.313313
R10669 VSS.n1142 VSS.n1138 0.313313
R10670 VSS.n1141 VSS.n1140 0.313313
R10671 VSS.n1293 VSS.n1292 0.313313
R10672 VSS.n1118 VSS.n1117 0.313313
R10673 VSS.n1133 VSS.n1132 0.313313
R10674 VSS.n3295 VSS.n3294 0.313313
R10675 VSS.n1129 VSS.n1125 0.313313
R10676 VSS.n1128 VSS.n1127 0.313313
R10677 VSS.n1105 VSS.n1101 0.283139
R10678 VSS.n1308 VSS.n1142 0.283139
R10679 VSS.n1356 VSS.n1179 0.283139
R10680 VSS.n320 VSS.n319 0.261806
R10681 VSS.n1752 VSS.n1749 0.261806
R10682 VSS.n3237 VSS.n3236 0.261806
R10683 VSS.n3218 VSS.n3214 0.261806
R10684 VSS.n955 VSS.n954 0.261806
R10685 VSS.n3551 VSS.n3550 0.261806
R10686 VSS.n919 VSS.n918 0.261806
R10687 VSS.n339 VSS.n338 0.261806
R10688 VSS.n3388 VSS.n1057 0.255639
R10689 VSS.n3296 VSS.n3295 0.255639
R10690 VSS.n1328 VSS.n1327 0.255639
R10691 VSS VSS.n44 0.228195
R10692 VSS.n3770 VSS 0.228195
R10693 VSS.n3762 VSS 0.228195
R10694 VSS.n494 VSS 0.228195
R10695 VSS.n877 VSS 0.228195
R10696 VSS.n366 VSS 0.228195
R10697 VSS.n3785 VSS 0.228195
R10698 VSS.n3777 VSS 0.228195
R10699 VSS VSS.n531 0.228195
R10700 VSS VSS.n611 0.228195
R10701 VSS.n631 VSS 0.228195
R10702 VSS VSS.n661 0.228195
R10703 VSS.n681 VSS 0.228195
R10704 VSS VSS.n711 0.228195
R10705 VSS.n731 VSS 0.228195
R10706 VSS VSS.n761 0.228195
R10707 VSS.n781 VSS 0.228195
R10708 VSS VSS.n811 0.228195
R10709 VSS.n828 VSS 0.228195
R10710 VSS.n858 VSS 0.228195
R10711 VSS.n895 VSS 0.228195
R10712 VSS.n352 VSS 0.228195
R10713 VSS.n2008 VSS 0.228195
R10714 VSS.n2000 VSS 0.228195
R10715 VSS.n3755 VSS 0.228195
R10716 VSS.n67 VSS 0.228195
R10717 VSS.n2222 VSS 0.228195
R10718 VSS.n2305 VSS 0.228195
R10719 VSS.n2297 VSS 0.228195
R10720 VSS.n2255 VSS 0.228195
R10721 VSS.n297 VSS 0.228195
R10722 VSS.n3572 VSS 0.228195
R10723 VSS.n2067 VSS 0.228195
R10724 VSS.n2059 VSS 0.228195
R10725 VSS.n2049 VSS 0.228195
R10726 VSS.n3736 VSS 0.228195
R10727 VSS.n3728 VSS 0.228195
R10728 VSS.n3710 VSS 0.228195
R10729 VSS.n3702 VSS 0.228195
R10730 VSS.n3684 VSS 0.228195
R10731 VSS.n3676 VSS 0.228195
R10732 VSS.n3658 VSS 0.228195
R10733 VSS.n3650 VSS 0.228195
R10734 VSS.n3632 VSS 0.228195
R10735 VSS.n3606 VSS 0.228195
R10736 VSS VSS.n278 0.228195
R10737 VSS.n318 VSS 0.228195
R10738 VSS VSS.n2229 0.228195
R10739 VSS VSS.n2238 0.228195
R10740 VSS.n2290 VSS 0.228195
R10741 VSS.n2282 VSS 0.228195
R10742 VSS.n3723 VSS 0.228195
R10743 VSS.n3715 VSS 0.228195
R10744 VSS.n3697 VSS 0.228195
R10745 VSS.n3689 VSS 0.228195
R10746 VSS.n3671 VSS 0.228195
R10747 VSS.n3663 VSS 0.228195
R10748 VSS.n3645 VSS 0.228195
R10749 VSS.n3637 VSS 0.228195
R10750 VSS.n3619 VSS 0.228195
R10751 VSS.n3611 VSS 0.228195
R10752 VSS.n3589 VSS 0.228195
R10753 VSS.n304 VSS 0.228195
R10754 VSS.n2198 VSS 0.228195
R10755 VSS VSS.n2312 0.228195
R10756 VSS VSS.n2321 0.228195
R10757 VSS.n2328 VSS 0.228195
R10758 VSS.n2165 VSS 0.228195
R10759 VSS.n2157 VSS 0.228195
R10760 VSS.n2343 VSS 0.228195
R10761 VSS.n2335 VSS 0.228195
R10762 VSS.n1912 VSS 0.228195
R10763 VSS.n1894 VSS 0.228195
R10764 VSS.n1886 VSS 0.228195
R10765 VSS.n1868 VSS 0.228195
R10766 VSS.n1860 VSS 0.228195
R10767 VSS.n1842 VSS 0.228195
R10768 VSS.n1834 VSS 0.228195
R10769 VSS.n1816 VSS 0.228195
R10770 VSS.n1773 VSS 0.228195
R10771 VSS.n1760 VSS 0.228195
R10772 VSS.n1748 VSS 0.228195
R10773 VSS.n2100 VSS 0.228195
R10774 VSS VSS.n2406 0.228195
R10775 VSS VSS.n2415 0.228195
R10776 VSS.n2422 VSS 0.228195
R10777 VSS VSS.n2382 0.228195
R10778 VSS.n2399 VSS 0.228195
R10779 VSS.n2441 VSS 0.228195
R10780 VSS.n1496 VSS 0.228195
R10781 VSS.n2498 VSS 0.228195
R10782 VSS VSS.n2571 0.228195
R10783 VSS VSS.n2580 0.228195
R10784 VSS VSS.n2625 0.228195
R10785 VSS.n2642 VSS 0.228195
R10786 VSS.n2985 VSS 0.228195
R10787 VSS.n2967 VSS 0.228195
R10788 VSS VSS.n2765 0.228195
R10789 VSS.n2935 VSS 0.228195
R10790 VSS VSS.n2810 0.228195
R10791 VSS.n2910 VSS 0.228195
R10792 VSS.n2892 VSS 0.228195
R10793 VSS.n3463 VSS 0.228195
R10794 VSS VSS.n3493 0.228195
R10795 VSS.n3500 VSS 0.228195
R10796 VSS VSS.n3238 0.228195
R10797 VSS.n3216 VSS 0.228195
R10798 VSS VSS.n2544 0.228195
R10799 VSS.n2564 VSS 0.228195
R10800 VSS VSS.n2611 0.228195
R10801 VSS.n2618 VSS 0.228195
R10802 VSS.n2465 VSS 0.228195
R10803 VSS.n2457 VSS 0.228195
R10804 VSS.n2448 VSS 0.228195
R10805 VSS.n1482 VSS 0.228195
R10806 VSS VSS.n2647 0.228195
R10807 VSS.n2980 VSS 0.228195
R10808 VSS.n2972 VSS 0.228195
R10809 VSS.n2948 VSS 0.228195
R10810 VSS.n2940 VSS 0.228195
R10811 VSS VSS.n2843 0.228195
R10812 VSS.n2905 VSS 0.228195
R10813 VSS.n2897 VSS 0.228195
R10814 VSS.n3488 VSS 0.228195
R10815 VSS VSS.n3505 0.228195
R10816 VSS.n953 VSS 0.228195
R10817 VSS.n2689 VSS 0.228195
R10818 VSS.n2735 VSS 0.228195
R10819 VSS.n3423 VSS 0.228195
R10820 VSS.n3345 VSS 0.228195
R10821 VSS.n3312 VSS 0.228195
R10822 VSS VSS.n1080 0.228195
R10823 VSS VSS.n1318 0.228195
R10824 VSS VSS.n1278 0.228195
R10825 VSS VSS.n1251 0.228195
R10826 VSS.n1362 VSS 0.228195
R10827 VSS.n3051 VSS 0.228195
R10828 VSS.n3276 VSS 0.228195
R10829 VSS.n2538 VSS 0.228195
R10830 VSS.n2530 VSS 0.228195
R10831 VSS.n2605 VSS 0.228195
R10832 VSS.n2591 VSS 0.228195
R10833 VSS.n2124 VSS 0.228195
R10834 VSS.n2358 VSS 0.228195
R10835 VSS.n2350 VSS 0.228195
R10836 VSS VSS.n1569 0.228195
R10837 VSS.n1907 VSS 0.228195
R10838 VSS.n1899 VSS 0.228195
R10839 VSS.n1881 VSS 0.228195
R10840 VSS.n1873 VSS 0.228195
R10841 VSS.n1855 VSS 0.228195
R10842 VSS.n1847 VSS 0.228195
R10843 VSS.n1829 VSS 0.228195
R10844 VSS.n1821 VSS 0.228195
R10845 VSS.n1803 VSS 0.228195
R10846 VSS.n3528 VSS 0.228195
R10847 VSS VSS.n3544 0.228195
R10848 VSS VSS.n3552 0.228195
R10849 VSS.n917 VSS 0.228195
R10850 VSS VSS.n561 0.228195
R10851 VSS VSS.n576 0.228195
R10852 VSS VSS.n585 0.228195
R10853 VSS.n605 VSS 0.228195
R10854 VSS VSS.n636 0.228195
R10855 VSS.n656 VSS 0.228195
R10856 VSS VSS.n686 0.228195
R10857 VSS.n706 VSS 0.228195
R10858 VSS VSS.n736 0.228195
R10859 VSS.n756 VSS 0.228195
R10860 VSS VSS.n786 0.228195
R10861 VSS.n806 VSS 0.228195
R10862 VSS.n853 VSS 0.228195
R10863 VSS VSS.n900 0.228195
R10864 VSS.n337 VSS 0.228195
R10865 VSS.n3191 VSS.n1069 0.228139
R10866 VSS.n1294 VSS.n1118 0.228139
R10867 VSS.n1342 VSS.n1155 0.228139
R10868 VSS.n39 VSS.n38 0.216787
R10869 VSS.n368 VSS.n367 0.216787
R10870 VSS.n9 VSS.n8 0.216787
R10871 VSS.n1976 VSS.n1975 0.216787
R10872 VSS.n2207 VSS.n2206 0.216787
R10873 VSS.n2017 VSS.n2016 0.216787
R10874 VSS.n1968 VSS.n1967 0.216787
R10875 VSS.n3566 VSS.n3565 0.216787
R10876 VSS.n3578 VSS.n3577 0.216787
R10877 VSS.n2174 VSS.n2173 0.216787
R10878 VSS.n2133 VSS.n2132 0.216787
R10879 VSS.n2474 VSS.n2473 0.216787
R10880 VSS.n1430 VSS.n1429 0.216787
R10881 VSS.n2507 VSS.n2506 0.216787
R10882 VSS.n2109 VSS.n2108 0.216787
R10883 VSS.n2377 VSS.n2376 0.216787
R10884 VSS.n2076 VSS.n2075 0.216787
R10885 VSS.n1439 VSS.n1438 0.216787
R10886 VSS.n550 VSS.n0 0.216787
R10887 VSS.n3624 VSS 0.209862
R10888 VSS.n1808 VSS 0.209862
R10889 VSS VSS.n3468 0.209862
R10890 VSS VSS.n833 0.209862
R10891 VSS.n42 VSS.n41 0.174723
R10892 VSS.n3772 VSS.n24 0.174723
R10893 VSS.n3760 VSS.n57 0.174723
R10894 VSS.n497 VSS.n496 0.174723
R10895 VSS.n879 VSS.n355 0.174723
R10896 VSS.n370 VSS.n354 0.174723
R10897 VSS.n3787 VSS.n4 0.174723
R10898 VSS.n3775 VSS.n20 0.174723
R10899 VSS.n529 VSS.n528 0.174723
R10900 VSS.n609 VSS.n537 0.174723
R10901 VSS.n633 VSS.n482 0.174723
R10902 VSS.n659 VSS.n472 0.174723
R10903 VSS.n683 VSS.n464 0.174723
R10904 VSS.n709 VSS.n454 0.174723
R10905 VSS.n733 VSS.n446 0.174723
R10906 VSS.n759 VSS.n436 0.174723
R10907 VSS.n783 VSS.n428 0.174723
R10908 VSS.n809 VSS.n418 0.174723
R10909 VSS.n830 VSS.n410 0.174723
R10910 VSS.n856 VSS.n390 0.174723
R10911 VSS.n897 VSS.n347 0.174723
R10912 VSS.n887 VSS.n881 0.174723
R10913 VSS.n2010 VSS.n1971 0.174723
R10914 VSS.n1998 VSS.n1987 0.174723
R10915 VSS.n3757 VSS.n61 0.174723
R10916 VSS.n3747 VSS.n3741 0.174723
R10917 VSS.n2224 VSS.n2202 0.174723
R10918 VSS.n2307 VSS.n1933 0.174723
R10919 VSS.n2295 VSS.n1943 0.174723
R10920 VSS.n2258 VSS.n2257 0.174723
R10921 VSS.n3580 VSS.n3576 0.174723
R10922 VSS.n3574 VSS.n300 0.174723
R10923 VSS.n2069 VSS.n2012 0.174723
R10924 VSS.n2057 VSS.n2028 0.174723
R10925 VSS.n2047 VSS.n2036 0.174723
R10926 VSS.n3738 VSS.n71 0.174723
R10927 VSS.n3726 VSS.n81 0.174723
R10928 VSS.n3712 VSS.n95 0.174723
R10929 VSS.n3700 VSS.n114 0.174723
R10930 VSS.n3686 VSS.n137 0.174723
R10931 VSS.n3674 VSS.n156 0.174723
R10932 VSS.n3660 VSS.n179 0.174723
R10933 VSS.n3648 VSS.n198 0.174723
R10934 VSS.n3634 VSS.n221 0.174723
R10935 VSS.n3622 VSS.n240 0.174723
R10936 VSS.n3608 VSS.n263 0.174723
R10937 VSS.n3598 VSS.n3592 0.174723
R10938 VSS.n2227 VSS.n1970 0.174723
R10939 VSS.n2236 VSS.n2235 0.174723
R10940 VSS.n2292 VSS.n1945 0.174723
R10941 VSS.n2280 VSS.n2251 0.174723
R10942 VSS.n3725 VSS.n83 0.174723
R10943 VSS.n3713 VSS.n93 0.174723
R10944 VSS.n3699 VSS.n116 0.174723
R10945 VSS.n3687 VSS.n135 0.174723
R10946 VSS.n3673 VSS.n158 0.174723
R10947 VSS.n3661 VSS.n177 0.174723
R10948 VSS.n3647 VSS.n200 0.174723
R10949 VSS.n3635 VSS.n219 0.174723
R10950 VSS.n3621 VSS.n242 0.174723
R10951 VSS.n3609 VSS.n261 0.174723
R10952 VSS.n3591 VSS.n280 0.174723
R10953 VSS.n305 VSS.n299 0.174723
R10954 VSS.n2200 VSS.n2169 0.174723
R10955 VSS.n2310 VSS.n1931 0.174723
R10956 VSS.n2319 VSS.n2318 0.174723
R10957 VSS.n2330 VSS.n1920 0.174723
R10958 VSS.n2167 VSS.n2128 0.174723
R10959 VSS.n2155 VSS.n2144 0.174723
R10960 VSS.n2345 VSS.n1525 0.174723
R10961 VSS.n2333 VSS.n1535 0.174723
R10962 VSS.n1910 VSS.n1543 0.174723
R10963 VSS.n1896 VSS.n1584 0.174723
R10964 VSS.n1884 VSS.n1603 0.174723
R10965 VSS.n1870 VSS.n1626 0.174723
R10966 VSS.n1858 VSS.n1645 0.174723
R10967 VSS.n1844 VSS.n1668 0.174723
R10968 VSS.n1832 VSS.n1687 0.174723
R10969 VSS.n1818 VSS.n1710 0.174723
R10970 VSS.n1806 VSS.n1729 0.174723
R10971 VSS.n1771 VSS.n1737 0.174723
R10972 VSS.n1763 VSS.n929 0.174723
R10973 VSS.n2102 VSS.n2071 0.174723
R10974 VSS.n2404 VSS.n1510 0.174723
R10975 VSS.n2413 VSS.n2412 0.174723
R10976 VSS.n2424 VSS.n1499 0.174723
R10977 VSS.n2380 VSS.n2379 0.174723
R10978 VSS.n2401 VSS.n2362 0.174723
R10979 VSS.n2443 VSS.n1490 0.174723
R10980 VSS.n2433 VSS.n2427 0.174723
R10981 VSS.n2500 VSS.n2469 0.174723
R10982 VSS.n2569 VSS.n1412 0.174723
R10983 VSS.n2578 VSS.n2577 0.174723
R10984 VSS.n2623 VSS.n1385 0.174723
R10985 VSS.n2644 VSS.n1377 0.174723
R10986 VSS.n2983 VSS.n1366 0.174723
R10987 VSS.n2969 VSS.n2662 0.174723
R10988 VSS.n2952 VSS.n2951 0.174723
R10989 VSS.n2937 VSS.n2797 0.174723
R10990 VSS.n2925 VSS.n2924 0.174723
R10991 VSS.n2908 VSS.n2818 0.174723
R10992 VSS.n2894 VSS.n2870 0.174723
R10993 VSS.n3465 VSS.n983 0.174723
R10994 VSS.n3491 VSS.n973 0.174723
R10995 VSS.n3502 VSS.n963 0.174723
R10996 VSS.n2542 VSS.n1432 0.174723
R10997 VSS.n2566 VSS.n1415 0.174723
R10998 VSS.n2609 VSS.n1397 0.174723
R10999 VSS.n2620 VSS.n1388 0.174723
R11000 VSS.n2467 VSS.n1434 0.174723
R11001 VSS.n2455 VSS.n1450 0.174723
R11002 VSS.n2446 VSS.n1458 0.174723
R11003 VSS.n1480 VSS.n1466 0.174723
R11004 VSS.n2645 VSS.n1376 0.174723
R11005 VSS.n2982 VSS.n1368 0.174723
R11006 VSS.n2970 VSS.n2660 0.174723
R11007 VSS.n2950 VSS.n2776 0.174723
R11008 VSS.n2938 VSS.n2795 0.174723
R11009 VSS.n2841 VSS.n2840 0.174723
R11010 VSS.n2907 VSS.n2820 0.174723
R11011 VSS.n2895 VSS.n2856 0.174723
R11012 VSS.n3466 VSS.n982 0.174723
R11013 VSS.n3490 VSS.n974 0.174723
R11014 VSS.n3503 VSS.n962 0.174723
R11015 VSS.n2540 VSS.n2502 0.174723
R11016 VSS.n2518 VSS.n1414 0.174723
R11017 VSS.n2607 VSS.n1399 0.174723
R11018 VSS.n2597 VSS.n1387 0.174723
R11019 VSS.n2126 VSS.n2104 0.174723
R11020 VSS.n2360 VSS.n1512 0.174723
R11021 VSS.n2348 VSS.n1522 0.174723
R11022 VSS.n1567 VSS.n1566 0.174723
R11023 VSS.n1909 VSS.n1545 0.174723
R11024 VSS.n1897 VSS.n1582 0.174723
R11025 VSS.n1883 VSS.n1605 0.174723
R11026 VSS.n1871 VSS.n1624 0.174723
R11027 VSS.n1857 VSS.n1647 0.174723
R11028 VSS.n1845 VSS.n1666 0.174723
R11029 VSS.n1831 VSS.n1689 0.174723
R11030 VSS.n1819 VSS.n1708 0.174723
R11031 VSS.n1805 VSS.n1780 0.174723
R11032 VSS.n1770 VSS.n945 0.174723
R11033 VSS.n3542 VSS.n928 0.174723
R11034 VSS.n3790 VSS.n3789 0.174723
R11035 VSS.n548 VSS.n22 0.174723
R11036 VSS.n583 VSS.n582 0.174723
R11037 VSS.n607 VSS.n538 0.174723
R11038 VSS.n634 VSS.n481 0.174723
R11039 VSS.n658 VSS.n473 0.174723
R11040 VSS.n684 VSS.n463 0.174723
R11041 VSS.n708 VSS.n455 0.174723
R11042 VSS.n734 VSS.n445 0.174723
R11043 VSS.n758 VSS.n437 0.174723
R11044 VSS.n784 VSS.n427 0.174723
R11045 VSS.n808 VSS.n419 0.174723
R11046 VSS.n831 VSS.n409 0.174723
R11047 VSS.n855 VSS.n401 0.174723
R11048 VSS.n898 VSS.n346 0.174723
R11049 VSS.n46 VSS.n45 0.174667
R11050 VSS.n53 VSS.n52 0.174667
R11051 VSS.n504 VSS.n503 0.174667
R11052 VSS.n872 VSS.n871 0.174667
R11053 VSS.n16 VSS.n15 0.174667
R11054 VSS.n524 VSS.n523 0.174667
R11055 VSS.n533 VSS.n532 0.174667
R11056 VSS.n613 VSS.n612 0.174667
R11057 VSS.n621 VSS.n620 0.174667
R11058 VSS.n663 VSS.n662 0.174667
R11059 VSS.n671 VSS.n670 0.174667
R11060 VSS.n713 VSS.n712 0.174667
R11061 VSS.n721 VSS.n720 0.174667
R11062 VSS.n763 VSS.n762 0.174667
R11063 VSS.n771 VSS.n770 0.174667
R11064 VSS.n813 VSS.n812 0.174667
R11065 VSS.n821 VSS.n820 0.174667
R11066 VSS.n400 VSS.n392 0.174667
R11067 VSS.n883 VSS.n882 0.174667
R11068 VSS.n1983 VSS.n1982 0.174667
R11069 VSS.n1997 VSS.n1989 0.174667
R11070 VSS.n3743 VSS.n3742 0.174667
R11071 VSS.n2215 VSS.n2214 0.174667
R11072 VSS.n1939 VSS.n1938 0.174667
R11073 VSS.n2265 VSS.n2264 0.174667
R11074 VSS.n2024 VSS.n2023 0.174667
R11075 VSS.n2055 VSS.n2030 0.174667
R11076 VSS.n2046 VSS.n2038 0.174667
R11077 VSS.n77 VSS.n76 0.174667
R11078 VSS.n103 VSS.n102 0.174667
R11079 VSS.n110 VSS.n109 0.174667
R11080 VSS.n145 VSS.n144 0.174667
R11081 VSS.n152 VSS.n151 0.174667
R11082 VSS.n187 VSS.n186 0.174667
R11083 VSS.n194 VSS.n193 0.174667
R11084 VSS.n229 VSS.n228 0.174667
R11085 VSS.n236 VSS.n235 0.174667
R11086 VSS.n271 VSS.n270 0.174667
R11087 VSS.n3594 VSS.n3593 0.174667
R11088 VSS.n327 VSS.n326 0.174667
R11089 VSS.n2231 VSS.n2230 0.174667
R11090 VSS.n2240 VSS.n2239 0.174667
R11091 VSS.n2247 VSS.n2246 0.174667
R11092 VSS.n2279 VSS.n2253 0.174667
R11093 VSS.n89 VSS.n88 0.174667
R11094 VSS.n124 VSS.n123 0.174667
R11095 VSS.n131 VSS.n130 0.174667
R11096 VSS.n166 VSS.n165 0.174667
R11097 VSS.n173 VSS.n172 0.174667
R11098 VSS.n208 VSS.n207 0.174667
R11099 VSS.n215 VSS.n214 0.174667
R11100 VSS.n250 VSS.n249 0.174667
R11101 VSS.n257 VSS.n256 0.174667
R11102 VSS.n288 VSS.n287 0.174667
R11103 VSS.n311 VSS.n310 0.174667
R11104 VSS.n2182 VSS.n2181 0.174667
R11105 VSS.n2314 VSS.n2313 0.174667
R11106 VSS.n2323 VSS.n2322 0.174667
R11107 VSS.n2140 VSS.n2139 0.174667
R11108 VSS.n2154 VSS.n2146 0.174667
R11109 VSS.n1531 VSS.n1530 0.174667
R11110 VSS.n1918 VSS.n1537 0.174667
R11111 VSS.n1592 VSS.n1591 0.174667
R11112 VSS.n1599 VSS.n1598 0.174667
R11113 VSS.n1634 VSS.n1633 0.174667
R11114 VSS.n1641 VSS.n1640 0.174667
R11115 VSS.n1676 VSS.n1675 0.174667
R11116 VSS.n1683 VSS.n1682 0.174667
R11117 VSS.n1718 VSS.n1717 0.174667
R11118 VSS.n1725 VSS.n1724 0.174667
R11119 VSS.n1779 VSS.n1731 0.174667
R11120 VSS.n1769 VSS.n1739 0.174667
R11121 VSS.n1758 VSS.n1744 0.174667
R11122 VSS.n2084 VSS.n2083 0.174667
R11123 VSS.n2408 VSS.n2407 0.174667
R11124 VSS.n2417 VSS.n2416 0.174667
R11125 VSS.n2384 VSS.n2383 0.174667
R11126 VSS.n2392 VSS.n2391 0.174667
R11127 VSS.n2429 VSS.n2428 0.174667
R11128 VSS.n2482 VSS.n2481 0.174667
R11129 VSS.n2573 VSS.n2572 0.174667
R11130 VSS.n2582 VSS.n2581 0.174667
R11131 VSS.n2627 VSS.n2626 0.174667
R11132 VSS.n2635 VSS.n2634 0.174667
R11133 VSS.n2669 VSS.n2668 0.174667
R11134 VSS.n2771 VSS.n2770 0.174667
R11135 VSS.n2805 VSS.n2804 0.174667
R11136 VSS.n2919 VSS.n2918 0.174667
R11137 VSS.n2814 VSS.n2813 0.174667
R11138 VSS.n2878 VSS.n2877 0.174667
R11139 VSS.n2886 VSS.n2885 0.174667
R11140 VSS.n1000 VSS.n999 0.174667
R11141 VSS.n3495 VSS.n3494 0.174667
R11142 VSS.n3232 VSS.n3231 0.174667
R11143 VSS.n3240 VSS.n3239 0.174667
R11144 VSS.n2546 VSS.n2545 0.174667
R11145 VSS.n2554 VSS.n2553 0.174667
R11146 VSS.n2613 VSS.n2612 0.174667
R11147 VSS.n1446 VSS.n1445 0.174667
R11148 VSS.n2454 VSS.n1452 0.174667
R11149 VSS.n1488 VSS.n1460 0.174667
R11150 VSS.n1479 VSS.n1468 0.174667
R11151 VSS.n2649 VSS.n2648 0.174667
R11152 VSS.n2656 VSS.n2655 0.174667
R11153 VSS.n2784 VSS.n2783 0.174667
R11154 VSS.n2791 VSS.n2790 0.174667
R11155 VSS.n2836 VSS.n2835 0.174667
R11156 VSS.n2845 VSS.n2844 0.174667
R11157 VSS.n2852 VSS.n2851 0.174667
R11158 VSS.n2869 VSS.n2858 0.174667
R11159 VSS.n3470 VSS.n3469 0.174667
R11160 VSS.n3478 VSS.n3477 0.174667
R11161 VSS.n3507 VSS.n3506 0.174667
R11162 VSS.n2514 VSS.n2513 0.174667
R11163 VSS.n2528 VSS.n2520 0.174667
R11164 VSS.n2593 VSS.n2592 0.174667
R11165 VSS.n2117 VSS.n2116 0.174667
R11166 VSS.n1518 VSS.n1517 0.174667
R11167 VSS.n1562 VSS.n1561 0.174667
R11168 VSS.n1571 VSS.n1570 0.174667
R11169 VSS.n1578 VSS.n1577 0.174667
R11170 VSS.n1613 VSS.n1612 0.174667
R11171 VSS.n1620 VSS.n1619 0.174667
R11172 VSS.n1655 VSS.n1654 0.174667
R11173 VSS.n1662 VSS.n1661 0.174667
R11174 VSS.n1697 VSS.n1696 0.174667
R11175 VSS.n1704 VSS.n1703 0.174667
R11176 VSS.n1788 VSS.n1787 0.174667
R11177 VSS.n1796 VSS.n1795 0.174667
R11178 VSS.n3527 VSS.n948 0.174667
R11179 VSS.n3546 VSS.n3545 0.174667
R11180 VSS.n3554 VSS.n3553 0.174667
R11181 VSS.n563 VSS.n562 0.174667
R11182 VSS.n578 VSS.n577 0.174667
R11183 VSS.n587 VSS.n586 0.174667
R11184 VSS.n595 VSS.n594 0.174667
R11185 VSS.n638 VSS.n637 0.174667
R11186 VSS.n646 VSS.n645 0.174667
R11187 VSS.n688 VSS.n687 0.174667
R11188 VSS.n696 VSS.n695 0.174667
R11189 VSS.n738 VSS.n737 0.174667
R11190 VSS.n746 VSS.n745 0.174667
R11191 VSS.n788 VSS.n787 0.174667
R11192 VSS.n796 VSS.n795 0.174667
R11193 VSS.n835 VSS.n834 0.174667
R11194 VSS.n843 VSS.n842 0.174667
R11195 VSS.n902 VSS.n901 0.174667
R11196 VSS.n29 VSS.n28 0.174067
R11197 VSS.n55 VSS.n54 0.174067
R11198 VSS.n501 VSS.n500 0.174067
R11199 VSS.n360 VSS.n359 0.174067
R11200 VSS.n18 VSS.n17 0.174067
R11201 VSS.n526 VSS.n525 0.174067
R11202 VSS.n535 VSS.n534 0.174067
R11203 VSS.n396 VSS.n395 0.174067
R11204 VSS.n885 VSS.n884 0.174067
R11205 VSS.n487 VSS.n486 0.174067
R11206 VSS.n619 VSS.n618 0.174067
R11207 VSS.n469 VSS.n468 0.174067
R11208 VSS.n669 VSS.n668 0.174067
R11209 VSS.n451 VSS.n450 0.174067
R11210 VSS.n719 VSS.n718 0.174067
R11211 VSS.n433 VSS.n432 0.174067
R11212 VSS.n769 VSS.n768 0.174067
R11213 VSS.n415 VSS.n414 0.174067
R11214 VSS.n819 VSS.n818 0.174067
R11215 VSS.n1985 VSS.n1984 0.174067
R11216 VSS.n1993 VSS.n1992 0.174067
R11217 VSS.n3745 VSS.n3744 0.174067
R11218 VSS.n2213 VSS.n2212 0.174067
R11219 VSS.n1941 VSS.n1940 0.174067
R11220 VSS.n2262 VSS.n2261 0.174067
R11221 VSS.n2026 VSS.n2025 0.174067
R11222 VSS.n2034 VSS.n2032 0.174067
R11223 VSS.n2042 VSS.n2041 0.174067
R11224 VSS.n79 VSS.n78 0.174067
R11225 VSS.n100 VSS.n99 0.174067
R11226 VSS.n112 VSS.n111 0.174067
R11227 VSS.n142 VSS.n141 0.174067
R11228 VSS.n154 VSS.n153 0.174067
R11229 VSS.n184 VSS.n183 0.174067
R11230 VSS.n196 VSS.n195 0.174067
R11231 VSS.n226 VSS.n225 0.174067
R11232 VSS.n238 VSS.n237 0.174067
R11233 VSS.n268 VSS.n267 0.174067
R11234 VSS.n3596 VSS.n3595 0.174067
R11235 VSS.n324 VSS.n323 0.174067
R11236 VSS.n2233 VSS.n2232 0.174067
R11237 VSS.n1950 VSS.n1949 0.174067
R11238 VSS.n2249 VSS.n2248 0.174067
R11239 VSS.n308 VSS.n307 0.174067
R11240 VSS.n2275 VSS.n2274 0.174067
R11241 VSS.n91 VSS.n90 0.174067
R11242 VSS.n121 VSS.n120 0.174067
R11243 VSS.n133 VSS.n132 0.174067
R11244 VSS.n163 VSS.n162 0.174067
R11245 VSS.n175 VSS.n174 0.174067
R11246 VSS.n205 VSS.n204 0.174067
R11247 VSS.n217 VSS.n216 0.174067
R11248 VSS.n247 VSS.n246 0.174067
R11249 VSS.n259 VSS.n258 0.174067
R11250 VSS.n285 VSS.n284 0.174067
R11251 VSS.n2180 VSS.n2179 0.174067
R11252 VSS.n2316 VSS.n2315 0.174067
R11253 VSS.n1926 VSS.n1925 0.174067
R11254 VSS.n2142 VSS.n2141 0.174067
R11255 VSS.n2150 VSS.n2149 0.174067
R11256 VSS.n1533 VSS.n1532 0.174067
R11257 VSS.n1541 VSS.n1539 0.174067
R11258 VSS.n1589 VSS.n1588 0.174067
R11259 VSS.n1601 VSS.n1600 0.174067
R11260 VSS.n1631 VSS.n1630 0.174067
R11261 VSS.n1643 VSS.n1642 0.174067
R11262 VSS.n1673 VSS.n1672 0.174067
R11263 VSS.n1685 VSS.n1684 0.174067
R11264 VSS.n1715 VSS.n1714 0.174067
R11265 VSS.n1727 VSS.n1726 0.174067
R11266 VSS.n1735 VSS.n1733 0.174067
R11267 VSS.n1761 VSS.n1741 0.174067
R11268 VSS.n1750 VSS.n1746 0.174067
R11269 VSS.n2480 VSS.n2479 0.174067
R11270 VSS.n2575 VSS.n2574 0.174067
R11271 VSS.n1407 VSS.n1406 0.174067
R11272 VSS.n1420 VSS.n1419 0.174067
R11273 VSS.n2552 VSS.n2551 0.174067
R11274 VSS.n1394 VSS.n1393 0.174067
R11275 VSS.n970 VSS.n969 0.174067
R11276 VSS.n3234 VSS.n3233 0.174067
R11277 VSS.n3221 VSS.n3220 0.174067
R11278 VSS.n998 VSS.n997 0.174067
R11279 VSS.n2875 VSS.n2874 0.174067
R11280 VSS.n2884 VSS.n2883 0.174067
R11281 VSS.n2816 VSS.n2815 0.174067
R11282 VSS.n2802 VSS.n2801 0.174067
R11283 VSS.n2921 VSS.n2920 0.174067
R11284 VSS.n2773 VSS.n2772 0.174067
R11285 VSS.n2666 VSS.n2665 0.174067
R11286 VSS.n1382 VSS.n1381 0.174067
R11287 VSS.n2633 VSS.n2632 0.174067
R11288 VSS.n2516 VSS.n2515 0.174067
R11289 VSS.n2524 VSS.n2523 0.174067
R11290 VSS.n2595 VSS.n2594 0.174067
R11291 VSS.n2115 VSS.n2114 0.174067
R11292 VSS.n1520 VSS.n1519 0.174067
R11293 VSS.n1564 VSS.n1563 0.174067
R11294 VSS.n2367 VSS.n2366 0.174067
R11295 VSS.n2390 VSS.n2389 0.174067
R11296 VSS.n2431 VSS.n2430 0.174067
R11297 VSS.n2082 VSS.n2081 0.174067
R11298 VSS.n2410 VSS.n2409 0.174067
R11299 VSS.n1505 VSS.n1504 0.174067
R11300 VSS.n1550 VSS.n1549 0.174067
R11301 VSS.n1580 VSS.n1579 0.174067
R11302 VSS.n1610 VSS.n1609 0.174067
R11303 VSS.n1622 VSS.n1621 0.174067
R11304 VSS.n1652 VSS.n1651 0.174067
R11305 VSS.n1664 VSS.n1663 0.174067
R11306 VSS.n1694 VSS.n1693 0.174067
R11307 VSS.n1706 VSS.n1705 0.174067
R11308 VSS.n1785 VSS.n1784 0.174067
R11309 VSS.n1794 VSS.n1793 0.174067
R11310 VSS.n951 VSS.n950 0.174067
R11311 VSS.n3548 VSS.n3547 0.174067
R11312 VSS.n1448 VSS.n1447 0.174067
R11313 VSS.n1456 VSS.n1454 0.174067
R11314 VSS.n1464 VSS.n1462 0.174067
R11315 VSS.n1472 VSS.n1471 0.174067
R11316 VSS.n1373 VSS.n1372 0.174067
R11317 VSS.n2658 VSS.n2657 0.174067
R11318 VSS.n2781 VSS.n2780 0.174067
R11319 VSS.n2793 VSS.n2792 0.174067
R11320 VSS.n2838 VSS.n2837 0.174067
R11321 VSS.n2825 VSS.n2824 0.174067
R11322 VSS.n2854 VSS.n2853 0.174067
R11323 VSS.n2862 VSS.n2861 0.174067
R11324 VSS.n979 VSS.n978 0.174067
R11325 VSS.n3476 VSS.n3475 0.174067
R11326 VSS.n959 VSS.n958 0.174067
R11327 VSS.n923 VSS.n922 0.174067
R11328 VSS.n559 VSS.n558 0.174067
R11329 VSS.n580 VSS.n579 0.174067
R11330 VSS.n543 VSS.n542 0.174067
R11331 VSS.n593 VSS.n592 0.174067
R11332 VSS.n478 VSS.n477 0.174067
R11333 VSS.n644 VSS.n643 0.174067
R11334 VSS.n460 VSS.n459 0.174067
R11335 VSS.n694 VSS.n693 0.174067
R11336 VSS.n442 VSS.n441 0.174067
R11337 VSS.n744 VSS.n743 0.174067
R11338 VSS.n424 VSS.n423 0.174067
R11339 VSS.n794 VSS.n793 0.174067
R11340 VSS.n406 VSS.n405 0.174067
R11341 VSS.n841 VSS.n840 0.174067
R11342 VSS.n343 VSS.n342 0.174067
R11343 VSS.n45 VSS.n29 0.173724
R11344 VSS.n54 VSS.n53 0.173724
R11345 VSS.n503 VSS.n501 0.173724
R11346 VSS.n871 VSS.n360 0.173724
R11347 VSS.n17 VSS.n16 0.173724
R11348 VSS.n525 VSS.n524 0.173724
R11349 VSS.n534 VSS.n533 0.173724
R11350 VSS.n612 VSS.n487 0.173724
R11351 VSS.n620 VSS.n619 0.173724
R11352 VSS.n662 VSS.n469 0.173724
R11353 VSS.n670 VSS.n669 0.173724
R11354 VSS.n712 VSS.n451 0.173724
R11355 VSS.n720 VSS.n719 0.173724
R11356 VSS.n762 VSS.n433 0.173724
R11357 VSS.n770 VSS.n769 0.173724
R11358 VSS.n812 VSS.n415 0.173724
R11359 VSS.n820 VSS.n819 0.173724
R11360 VSS.n396 VSS.n392 0.173724
R11361 VSS.n884 VSS.n883 0.173724
R11362 VSS.n1984 VSS.n1983 0.173724
R11363 VSS.n1993 VSS.n1989 0.173724
R11364 VSS.n3744 VSS.n3743 0.173724
R11365 VSS.n2214 VSS.n2213 0.173724
R11366 VSS.n1940 VSS.n1939 0.173724
R11367 VSS.n2264 VSS.n2262 0.173724
R11368 VSS.n2025 VSS.n2024 0.173724
R11369 VSS.n2032 VSS.n2030 0.173724
R11370 VSS.n2042 VSS.n2038 0.173724
R11371 VSS.n78 VSS.n77 0.173724
R11372 VSS.n102 VSS.n100 0.173724
R11373 VSS.n111 VSS.n110 0.173724
R11374 VSS.n144 VSS.n142 0.173724
R11375 VSS.n153 VSS.n152 0.173724
R11376 VSS.n186 VSS.n184 0.173724
R11377 VSS.n195 VSS.n194 0.173724
R11378 VSS.n228 VSS.n226 0.173724
R11379 VSS.n237 VSS.n236 0.173724
R11380 VSS.n270 VSS.n268 0.173724
R11381 VSS.n3595 VSS.n3594 0.173724
R11382 VSS.n326 VSS.n324 0.173724
R11383 VSS.n2232 VSS.n2231 0.173724
R11384 VSS.n2239 VSS.n1950 0.173724
R11385 VSS.n2248 VSS.n2247 0.173724
R11386 VSS.n2275 VSS.n2253 0.173724
R11387 VSS.n90 VSS.n89 0.173724
R11388 VSS.n123 VSS.n121 0.173724
R11389 VSS.n132 VSS.n131 0.173724
R11390 VSS.n165 VSS.n163 0.173724
R11391 VSS.n174 VSS.n173 0.173724
R11392 VSS.n207 VSS.n205 0.173724
R11393 VSS.n216 VSS.n215 0.173724
R11394 VSS.n249 VSS.n247 0.173724
R11395 VSS.n258 VSS.n257 0.173724
R11396 VSS.n287 VSS.n285 0.173724
R11397 VSS.n310 VSS.n308 0.173724
R11398 VSS.n2181 VSS.n2180 0.173724
R11399 VSS.n2315 VSS.n2314 0.173724
R11400 VSS.n2322 VSS.n1926 0.173724
R11401 VSS.n2141 VSS.n2140 0.173724
R11402 VSS.n2150 VSS.n2146 0.173724
R11403 VSS.n1532 VSS.n1531 0.173724
R11404 VSS.n1539 VSS.n1537 0.173724
R11405 VSS.n1591 VSS.n1589 0.173724
R11406 VSS.n1600 VSS.n1599 0.173724
R11407 VSS.n1633 VSS.n1631 0.173724
R11408 VSS.n1642 VSS.n1641 0.173724
R11409 VSS.n1675 VSS.n1673 0.173724
R11410 VSS.n1684 VSS.n1683 0.173724
R11411 VSS.n1717 VSS.n1715 0.173724
R11412 VSS.n1726 VSS.n1725 0.173724
R11413 VSS.n1733 VSS.n1731 0.173724
R11414 VSS.n1741 VSS.n1739 0.173724
R11415 VSS.n1746 VSS.n1744 0.173724
R11416 VSS.n2083 VSS.n2082 0.173724
R11417 VSS.n2409 VSS.n2408 0.173724
R11418 VSS.n2416 VSS.n1505 0.173724
R11419 VSS.n2383 VSS.n2367 0.173724
R11420 VSS.n2391 VSS.n2390 0.173724
R11421 VSS.n2430 VSS.n2429 0.173724
R11422 VSS.n2481 VSS.n2480 0.173724
R11423 VSS.n2574 VSS.n2573 0.173724
R11424 VSS.n2581 VSS.n1407 0.173724
R11425 VSS.n2626 VSS.n1382 0.173724
R11426 VSS.n2634 VSS.n2633 0.173724
R11427 VSS.n2668 VSS.n2666 0.173724
R11428 VSS.n2772 VSS.n2771 0.173724
R11429 VSS.n2804 VSS.n2802 0.173724
R11430 VSS.n2920 VSS.n2919 0.173724
R11431 VSS.n2815 VSS.n2814 0.173724
R11432 VSS.n2877 VSS.n2875 0.173724
R11433 VSS.n2885 VSS.n2884 0.173724
R11434 VSS.n999 VSS.n998 0.173724
R11435 VSS.n3494 VSS.n970 0.173724
R11436 VSS.n3233 VSS.n3232 0.173724
R11437 VSS.n3239 VSS.n3221 0.173724
R11438 VSS.n2545 VSS.n1420 0.173724
R11439 VSS.n2553 VSS.n2552 0.173724
R11440 VSS.n2612 VSS.n1394 0.173724
R11441 VSS.n1447 VSS.n1446 0.173724
R11442 VSS.n1454 VSS.n1452 0.173724
R11443 VSS.n1462 VSS.n1460 0.173724
R11444 VSS.n1472 VSS.n1468 0.173724
R11445 VSS.n2648 VSS.n1373 0.173724
R11446 VSS.n2657 VSS.n2656 0.173724
R11447 VSS.n2783 VSS.n2781 0.173724
R11448 VSS.n2792 VSS.n2791 0.173724
R11449 VSS.n2837 VSS.n2836 0.173724
R11450 VSS.n2844 VSS.n2825 0.173724
R11451 VSS.n2853 VSS.n2852 0.173724
R11452 VSS.n2862 VSS.n2858 0.173724
R11453 VSS.n3469 VSS.n979 0.173724
R11454 VSS.n3477 VSS.n3476 0.173724
R11455 VSS.n3506 VSS.n959 0.173724
R11456 VSS.n2515 VSS.n2514 0.173724
R11457 VSS.n2524 VSS.n2520 0.173724
R11458 VSS.n2594 VSS.n2593 0.173724
R11459 VSS.n2116 VSS.n2115 0.173724
R11460 VSS.n1519 VSS.n1518 0.173724
R11461 VSS.n1563 VSS.n1562 0.173724
R11462 VSS.n1570 VSS.n1550 0.173724
R11463 VSS.n1579 VSS.n1578 0.173724
R11464 VSS.n1612 VSS.n1610 0.173724
R11465 VSS.n1621 VSS.n1620 0.173724
R11466 VSS.n1654 VSS.n1652 0.173724
R11467 VSS.n1663 VSS.n1662 0.173724
R11468 VSS.n1696 VSS.n1694 0.173724
R11469 VSS.n1705 VSS.n1704 0.173724
R11470 VSS.n1787 VSS.n1785 0.173724
R11471 VSS.n1795 VSS.n1794 0.173724
R11472 VSS.n951 VSS.n948 0.173724
R11473 VSS.n3547 VSS.n3546 0.173724
R11474 VSS.n3553 VSS.n923 0.173724
R11475 VSS.n562 VSS.n559 0.173724
R11476 VSS.n579 VSS.n578 0.173724
R11477 VSS.n586 VSS.n543 0.173724
R11478 VSS.n594 VSS.n593 0.173724
R11479 VSS.n637 VSS.n478 0.173724
R11480 VSS.n645 VSS.n644 0.173724
R11481 VSS.n687 VSS.n460 0.173724
R11482 VSS.n695 VSS.n694 0.173724
R11483 VSS.n737 VSS.n442 0.173724
R11484 VSS.n745 VSS.n744 0.173724
R11485 VSS.n787 VSS.n424 0.173724
R11486 VSS.n795 VSS.n794 0.173724
R11487 VSS.n834 VSS.n406 0.173724
R11488 VSS.n842 VSS.n841 0.173724
R11489 VSS.n901 VSS.n343 0.173724
R11490 VSS.n1100 VSS.n1065 0.1734
R11491 VSS.n1093 VSS.n1092 0.1734
R11492 VSS.n1074 VSS.n1062 0.1734
R11493 VSS.n1141 VSS.n1114 0.1734
R11494 VSS.n1134 VSS.n1133 0.1734
R11495 VSS.n1128 VSS.n1123 0.1734
R11496 VSS.n3295 VSS.n1134 0.1734
R11497 VSS.n1293 VSS.n1114 0.1734
R11498 VSS.n1307 VSS.n1146 0.1734
R11499 VSS.n1093 VSS.n1057 0.1734
R11500 VSS.n3190 VSS.n1065 0.1734
R11501 VSS.n1109 VSS.n1106 0.1734
R11502 VSS.n1178 VSS.n1151 0.1734
R11503 VSS.n1171 VSS.n1170 0.1734
R11504 VSS.n1165 VSS.n1160 0.1734
R11505 VSS.n1327 VSS.n1171 0.1734
R11506 VSS.n1341 VSS.n1151 0.1734
R11507 VSS.n1355 VSS.n1183 0.1734
R11508 VSS.n2684 VSS 0.157861
R11509 VSS.n2751 VSS 0.157861
R11510 VSS.n2744 VSS 0.157861
R11511 VSS.n2727 VSS 0.157861
R11512 VSS.n3439 VSS 0.157861
R11513 VSS.n3432 VSS 0.157861
R11514 VSS.n3415 VSS 0.157861
R11515 VSS.n3178 VSS 0.157861
R11516 VSS.n3169 VSS 0.157861
R11517 VSS.n3006 VSS 0.157861
R11518 VSS.n1335 VSS 0.157861
R11519 VSS.n3060 VSS 0.157861
R11520 VSS.n1301 VSS 0.157861
R11521 VSS.n3108 VSS 0.157861
R11522 VSS.n3285 VSS 0.157861
R11523 VSS.n3268 VSS 0.157861
R11524 VSS.n3261 VSS 0.157861
R11525 VSS.n3251 VSS 0.157861
R11526 VSS VSS.n39 0.141056
R11527 VSS.n40 VSS 0.141056
R11528 VSS.n28 VSS 0.141056
R11529 VSS VSS.n27 0.141056
R11530 VSS.n52 VSS 0.141056
R11531 VSS VSS.n55 0.141056
R11532 VSS.n56 VSS 0.141056
R11533 VSS.n500 VSS 0.141056
R11534 VSS VSS.n499 0.141056
R11535 VSS.n872 VSS 0.141056
R11536 VSS.n359 VSS 0.141056
R11537 VSS VSS.n358 0.141056
R11538 VSS VSS.n368 0.141056
R11539 VSS.n369 VSS 0.141056
R11540 VSS.n8 VSS 0.141056
R11541 VSS VSS.n7 0.141056
R11542 VSS VSS.n18 0.141056
R11543 VSS.n19 VSS 0.141056
R11544 VSS.n523 VSS 0.141056
R11545 VSS VSS.n526 0.141056
R11546 VSS.n527 VSS 0.141056
R11547 VSS VSS.n535 0.141056
R11548 VSS.n536 VSS 0.141056
R11549 VSS.n613 VSS 0.141056
R11550 VSS.n486 VSS 0.141056
R11551 VSS VSS.n485 0.141056
R11552 VSS.n618 VSS 0.141056
R11553 VSS VSS.n617 0.141056
R11554 VSS.n663 VSS 0.141056
R11555 VSS.n468 VSS 0.141056
R11556 VSS VSS.n467 0.141056
R11557 VSS.n668 VSS 0.141056
R11558 VSS VSS.n667 0.141056
R11559 VSS.n713 VSS 0.141056
R11560 VSS.n450 VSS 0.141056
R11561 VSS VSS.n449 0.141056
R11562 VSS.n718 VSS 0.141056
R11563 VSS VSS.n717 0.141056
R11564 VSS.n763 VSS 0.141056
R11565 VSS.n432 VSS 0.141056
R11566 VSS VSS.n431 0.141056
R11567 VSS.n768 VSS 0.141056
R11568 VSS VSS.n767 0.141056
R11569 VSS.n813 VSS 0.141056
R11570 VSS.n414 VSS 0.141056
R11571 VSS VSS.n413 0.141056
R11572 VSS.n818 VSS 0.141056
R11573 VSS VSS.n817 0.141056
R11574 VSS VSS.n400 0.141056
R11575 VSS.n395 VSS 0.141056
R11576 VSS VSS.n394 0.141056
R11577 VSS.n882 VSS 0.141056
R11578 VSS VSS.n885 0.141056
R11579 VSS.n886 VSS 0.141056
R11580 VSS.n1975 VSS 0.141056
R11581 VSS VSS.n1974 0.141056
R11582 VSS VSS.n1985 0.141056
R11583 VSS.n1986 VSS 0.141056
R11584 VSS VSS.n1997 0.141056
R11585 VSS.n1992 VSS 0.141056
R11586 VSS VSS.n1991 0.141056
R11587 VSS VSS.n3745 0.141056
R11588 VSS.n3746 VSS 0.141056
R11589 VSS.n2206 VSS 0.141056
R11590 VSS VSS.n2205 0.141056
R11591 VSS.n2212 VSS 0.141056
R11592 VSS VSS.n2211 0.141056
R11593 VSS.n1938 VSS 0.141056
R11594 VSS VSS.n1941 0.141056
R11595 VSS.n1942 VSS 0.141056
R11596 VSS.n2261 VSS 0.141056
R11597 VSS VSS.n2260 0.141056
R11598 VSS VSS.n3578 0.141056
R11599 VSS.n3579 VSS 0.141056
R11600 VSS.n3565 VSS 0.141056
R11601 VSS VSS.n3564 0.141056
R11602 VSS.n2016 VSS 0.141056
R11603 VSS VSS.n2015 0.141056
R11604 VSS VSS.n2026 0.141056
R11605 VSS.n2027 VSS 0.141056
R11606 VSS VSS.n2055 0.141056
R11607 VSS VSS.n2034 0.141056
R11608 VSS.n2035 VSS 0.141056
R11609 VSS.n2041 VSS 0.141056
R11610 VSS VSS.n2040 0.141056
R11611 VSS.n76 VSS 0.141056
R11612 VSS VSS.n79 0.141056
R11613 VSS.n80 VSS 0.141056
R11614 VSS.n99 VSS 0.141056
R11615 VSS VSS.n98 0.141056
R11616 VSS.n109 VSS 0.141056
R11617 VSS VSS.n112 0.141056
R11618 VSS.n113 VSS 0.141056
R11619 VSS.n141 VSS 0.141056
R11620 VSS VSS.n140 0.141056
R11621 VSS.n151 VSS 0.141056
R11622 VSS VSS.n154 0.141056
R11623 VSS.n155 VSS 0.141056
R11624 VSS.n183 VSS 0.141056
R11625 VSS VSS.n182 0.141056
R11626 VSS.n193 VSS 0.141056
R11627 VSS VSS.n196 0.141056
R11628 VSS.n197 VSS 0.141056
R11629 VSS.n225 VSS 0.141056
R11630 VSS VSS.n224 0.141056
R11631 VSS.n235 VSS 0.141056
R11632 VSS VSS.n238 0.141056
R11633 VSS.n239 VSS 0.141056
R11634 VSS.n267 VSS 0.141056
R11635 VSS VSS.n266 0.141056
R11636 VSS.n3593 VSS 0.141056
R11637 VSS VSS.n3596 0.141056
R11638 VSS.n3597 VSS 0.141056
R11639 VSS.n323 VSS 0.141056
R11640 VSS VSS.n322 0.141056
R11641 VSS VSS.n1968 0.141056
R11642 VSS.n1969 VSS 0.141056
R11643 VSS VSS.n2233 0.141056
R11644 VSS.n2234 VSS 0.141056
R11645 VSS.n2240 VSS 0.141056
R11646 VSS.n1949 VSS 0.141056
R11647 VSS VSS.n1948 0.141056
R11648 VSS VSS.n2249 0.141056
R11649 VSS.n2250 VSS 0.141056
R11650 VSS VSS.n2279 0.141056
R11651 VSS.n2274 VSS 0.141056
R11652 VSS VSS.n2273 0.141056
R11653 VSS VSS.n91 0.141056
R11654 VSS.n92 VSS 0.141056
R11655 VSS.n124 VSS 0.141056
R11656 VSS.n120 VSS 0.141056
R11657 VSS VSS.n119 0.141056
R11658 VSS VSS.n133 0.141056
R11659 VSS.n134 VSS 0.141056
R11660 VSS.n166 VSS 0.141056
R11661 VSS.n162 VSS 0.141056
R11662 VSS VSS.n161 0.141056
R11663 VSS VSS.n175 0.141056
R11664 VSS.n176 VSS 0.141056
R11665 VSS.n208 VSS 0.141056
R11666 VSS.n204 VSS 0.141056
R11667 VSS VSS.n203 0.141056
R11668 VSS VSS.n217 0.141056
R11669 VSS.n218 VSS 0.141056
R11670 VSS.n250 VSS 0.141056
R11671 VSS.n246 VSS 0.141056
R11672 VSS VSS.n245 0.141056
R11673 VSS VSS.n259 0.141056
R11674 VSS.n260 VSS 0.141056
R11675 VSS.n288 VSS 0.141056
R11676 VSS.n284 VSS 0.141056
R11677 VSS VSS.n283 0.141056
R11678 VSS.n311 VSS 0.141056
R11679 VSS.n307 VSS 0.141056
R11680 VSS VSS.n306 0.141056
R11681 VSS.n2173 VSS 0.141056
R11682 VSS VSS.n2172 0.141056
R11683 VSS.n2179 VSS 0.141056
R11684 VSS VSS.n2178 0.141056
R11685 VSS.n2313 VSS 0.141056
R11686 VSS VSS.n2316 0.141056
R11687 VSS.n2317 VSS 0.141056
R11688 VSS.n1925 VSS 0.141056
R11689 VSS VSS.n1924 0.141056
R11690 VSS.n2132 VSS 0.141056
R11691 VSS VSS.n2131 0.141056
R11692 VSS VSS.n2142 0.141056
R11693 VSS.n2143 VSS 0.141056
R11694 VSS VSS.n2154 0.141056
R11695 VSS.n2149 VSS 0.141056
R11696 VSS VSS.n2148 0.141056
R11697 VSS VSS.n1533 0.141056
R11698 VSS.n1534 VSS 0.141056
R11699 VSS VSS.n1918 0.141056
R11700 VSS VSS.n1541 0.141056
R11701 VSS.n1542 VSS 0.141056
R11702 VSS.n1588 VSS 0.141056
R11703 VSS VSS.n1587 0.141056
R11704 VSS.n1598 VSS 0.141056
R11705 VSS VSS.n1601 0.141056
R11706 VSS.n1602 VSS 0.141056
R11707 VSS.n1630 VSS 0.141056
R11708 VSS VSS.n1629 0.141056
R11709 VSS.n1640 VSS 0.141056
R11710 VSS VSS.n1643 0.141056
R11711 VSS.n1644 VSS 0.141056
R11712 VSS.n1672 VSS 0.141056
R11713 VSS VSS.n1671 0.141056
R11714 VSS.n1682 VSS 0.141056
R11715 VSS VSS.n1685 0.141056
R11716 VSS.n1686 VSS 0.141056
R11717 VSS.n1714 VSS 0.141056
R11718 VSS VSS.n1713 0.141056
R11719 VSS.n1724 VSS 0.141056
R11720 VSS VSS.n1727 0.141056
R11721 VSS.n1728 VSS 0.141056
R11722 VSS VSS.n1735 0.141056
R11723 VSS.n1736 VSS 0.141056
R11724 VSS VSS.n1769 0.141056
R11725 VSS VSS.n1761 0.141056
R11726 VSS.n1762 VSS 0.141056
R11727 VSS VSS.n1750 0.141056
R11728 VSS.n1751 VSS 0.141056
R11729 VSS.n2075 VSS 0.141056
R11730 VSS VSS.n2074 0.141056
R11731 VSS.n2081 VSS 0.141056
R11732 VSS VSS.n2080 0.141056
R11733 VSS.n2407 VSS 0.141056
R11734 VSS VSS.n2410 0.141056
R11735 VSS.n2411 VSS 0.141056
R11736 VSS.n1504 VSS 0.141056
R11737 VSS VSS.n1503 0.141056
R11738 VSS VSS.n2377 0.141056
R11739 VSS.n2378 VSS 0.141056
R11740 VSS.n2366 VSS 0.141056
R11741 VSS VSS.n2365 0.141056
R11742 VSS.n2392 VSS 0.141056
R11743 VSS.n2389 VSS 0.141056
R11744 VSS VSS.n2388 0.141056
R11745 VSS VSS.n2431 0.141056
R11746 VSS.n2432 VSS 0.141056
R11747 VSS.n2473 VSS 0.141056
R11748 VSS VSS.n2472 0.141056
R11749 VSS.n2479 VSS 0.141056
R11750 VSS VSS.n2478 0.141056
R11751 VSS.n2572 VSS 0.141056
R11752 VSS VSS.n2575 0.141056
R11753 VSS.n2576 VSS 0.141056
R11754 VSS.n1406 VSS 0.141056
R11755 VSS VSS.n1405 0.141056
R11756 VSS.n2627 VSS 0.141056
R11757 VSS.n1381 VSS 0.141056
R11758 VSS VSS.n1380 0.141056
R11759 VSS.n2632 VSS 0.141056
R11760 VSS VSS.n2631 0.141056
R11761 VSS.n2669 VSS 0.141056
R11762 VSS.n2665 VSS 0.141056
R11763 VSS VSS.n2664 0.141056
R11764 VSS VSS.n2773 0.141056
R11765 VSS.n2774 VSS 0.141056
R11766 VSS.n2805 VSS 0.141056
R11767 VSS.n2801 VSS 0.141056
R11768 VSS VSS.n2800 0.141056
R11769 VSS VSS.n2921 0.141056
R11770 VSS.n2922 VSS 0.141056
R11771 VSS.n2813 VSS 0.141056
R11772 VSS VSS.n2816 0.141056
R11773 VSS.n2817 VSS 0.141056
R11774 VSS.n2874 VSS 0.141056
R11775 VSS VSS.n2873 0.141056
R11776 VSS.n2886 VSS 0.141056
R11777 VSS.n2883 VSS 0.141056
R11778 VSS VSS.n2882 0.141056
R11779 VSS.n997 VSS 0.141056
R11780 VSS VSS.n996 0.141056
R11781 VSS.n3495 VSS 0.141056
R11782 VSS.n969 VSS 0.141056
R11783 VSS VSS.n968 0.141056
R11784 VSS.n3231 VSS 0.141056
R11785 VSS VSS.n3234 0.141056
R11786 VSS.n3235 VSS 0.141056
R11787 VSS.n3240 VSS 0.141056
R11788 VSS.n3220 VSS 0.141056
R11789 VSS VSS.n3219 0.141056
R11790 VSS VSS.n1430 0.141056
R11791 VSS.n1431 VSS 0.141056
R11792 VSS.n1419 VSS 0.141056
R11793 VSS VSS.n1418 0.141056
R11794 VSS.n2554 VSS 0.141056
R11795 VSS.n2551 VSS 0.141056
R11796 VSS VSS.n2550 0.141056
R11797 VSS.n1393 VSS 0.141056
R11798 VSS VSS.n1392 0.141056
R11799 VSS.n1438 VSS 0.141056
R11800 VSS VSS.n1437 0.141056
R11801 VSS VSS.n1448 0.141056
R11802 VSS.n1449 VSS 0.141056
R11803 VSS VSS.n2454 0.141056
R11804 VSS VSS.n1456 0.141056
R11805 VSS.n1457 VSS 0.141056
R11806 VSS VSS.n1464 0.141056
R11807 VSS.n1465 VSS 0.141056
R11808 VSS VSS.n1479 0.141056
R11809 VSS.n1471 VSS 0.141056
R11810 VSS VSS.n1470 0.141056
R11811 VSS.n1372 VSS 0.141056
R11812 VSS VSS.n1371 0.141056
R11813 VSS.n2655 VSS 0.141056
R11814 VSS VSS.n2658 0.141056
R11815 VSS.n2659 VSS 0.141056
R11816 VSS.n2780 VSS 0.141056
R11817 VSS VSS.n2779 0.141056
R11818 VSS.n2790 VSS 0.141056
R11819 VSS VSS.n2793 0.141056
R11820 VSS.n2794 VSS 0.141056
R11821 VSS VSS.n2838 0.141056
R11822 VSS.n2839 VSS 0.141056
R11823 VSS.n2845 VSS 0.141056
R11824 VSS.n2824 VSS 0.141056
R11825 VSS VSS.n2823 0.141056
R11826 VSS VSS.n2854 0.141056
R11827 VSS.n2855 VSS 0.141056
R11828 VSS VSS.n2869 0.141056
R11829 VSS.n2861 VSS 0.141056
R11830 VSS VSS.n2860 0.141056
R11831 VSS.n978 VSS 0.141056
R11832 VSS VSS.n977 0.141056
R11833 VSS.n3478 VSS 0.141056
R11834 VSS.n3475 VSS 0.141056
R11835 VSS VSS.n3474 0.141056
R11836 VSS.n958 VSS 0.141056
R11837 VSS VSS.n957 0.141056
R11838 VSS.n2506 VSS 0.141056
R11839 VSS VSS.n2505 0.141056
R11840 VSS VSS.n2516 0.141056
R11841 VSS.n2517 VSS 0.141056
R11842 VSS VSS.n2528 0.141056
R11843 VSS.n2523 VSS 0.141056
R11844 VSS VSS.n2522 0.141056
R11845 VSS VSS.n2595 0.141056
R11846 VSS.n2596 VSS 0.141056
R11847 VSS.n2108 VSS 0.141056
R11848 VSS VSS.n2107 0.141056
R11849 VSS.n2114 VSS 0.141056
R11850 VSS VSS.n2113 0.141056
R11851 VSS.n1517 VSS 0.141056
R11852 VSS VSS.n1520 0.141056
R11853 VSS.n1521 VSS 0.141056
R11854 VSS VSS.n1564 0.141056
R11855 VSS.n1565 VSS 0.141056
R11856 VSS.n1571 VSS 0.141056
R11857 VSS.n1549 VSS 0.141056
R11858 VSS VSS.n1548 0.141056
R11859 VSS VSS.n1580 0.141056
R11860 VSS.n1581 VSS 0.141056
R11861 VSS.n1613 VSS 0.141056
R11862 VSS.n1609 VSS 0.141056
R11863 VSS VSS.n1608 0.141056
R11864 VSS VSS.n1622 0.141056
R11865 VSS.n1623 VSS 0.141056
R11866 VSS.n1655 VSS 0.141056
R11867 VSS.n1651 VSS 0.141056
R11868 VSS VSS.n1650 0.141056
R11869 VSS VSS.n1664 0.141056
R11870 VSS.n1665 VSS 0.141056
R11871 VSS.n1697 VSS 0.141056
R11872 VSS.n1693 VSS 0.141056
R11873 VSS VSS.n1692 0.141056
R11874 VSS VSS.n1706 0.141056
R11875 VSS.n1707 VSS 0.141056
R11876 VSS.n1788 VSS 0.141056
R11877 VSS.n1784 VSS 0.141056
R11878 VSS VSS.n1783 0.141056
R11879 VSS.n1793 VSS 0.141056
R11880 VSS VSS.n1792 0.141056
R11881 VSS VSS.n3527 0.141056
R11882 VSS.n950 VSS 0.141056
R11883 VSS VSS.n949 0.141056
R11884 VSS.n3545 VSS 0.141056
R11885 VSS VSS.n3548 0.141056
R11886 VSS.n3549 VSS 0.141056
R11887 VSS.n3554 VSS 0.141056
R11888 VSS.n922 VSS 0.141056
R11889 VSS VSS.n921 0.141056
R11890 VSS VSS.n0 0.141056
R11891 VSS VSS.n3791 0.141056
R11892 VSS.n558 VSS 0.141056
R11893 VSS VSS.n557 0.141056
R11894 VSS.n577 VSS 0.141056
R11895 VSS VSS.n580 0.141056
R11896 VSS.n581 VSS 0.141056
R11897 VSS.n542 VSS 0.141056
R11898 VSS VSS.n541 0.141056
R11899 VSS.n595 VSS 0.141056
R11900 VSS.n592 VSS 0.141056
R11901 VSS VSS.n591 0.141056
R11902 VSS.n477 VSS 0.141056
R11903 VSS VSS.n476 0.141056
R11904 VSS.n646 VSS 0.141056
R11905 VSS.n643 VSS 0.141056
R11906 VSS VSS.n642 0.141056
R11907 VSS.n459 VSS 0.141056
R11908 VSS VSS.n458 0.141056
R11909 VSS.n696 VSS 0.141056
R11910 VSS.n693 VSS 0.141056
R11911 VSS VSS.n692 0.141056
R11912 VSS.n441 VSS 0.141056
R11913 VSS VSS.n440 0.141056
R11914 VSS.n746 VSS 0.141056
R11915 VSS.n743 VSS 0.141056
R11916 VSS VSS.n742 0.141056
R11917 VSS.n423 VSS 0.141056
R11918 VSS VSS.n422 0.141056
R11919 VSS.n796 VSS 0.141056
R11920 VSS.n793 VSS 0.141056
R11921 VSS VSS.n792 0.141056
R11922 VSS.n405 VSS 0.141056
R11923 VSS VSS.n404 0.141056
R11924 VSS.n843 VSS 0.141056
R11925 VSS.n840 VSS 0.141056
R11926 VSS VSS.n839 0.141056
R11927 VSS.n342 VSS 0.141056
R11928 VSS VSS.n341 0.141056
R11929 VSS.n3191 VSS.n3190 0.121194
R11930 VSS.n1294 VSS.n1293 0.121194
R11931 VSS.n1342 VSS.n1341 0.121194
R11932 VSS.n46 VSS 0.107444
R11933 VSS.n504 VSS 0.107444
R11934 VSS.n15 VSS 0.107444
R11935 VSS.n532 VSS 0.107444
R11936 VSS.n621 VSS 0.107444
R11937 VSS.n671 VSS 0.107444
R11938 VSS.n721 VSS 0.107444
R11939 VSS.n771 VSS 0.107444
R11940 VSS.n821 VSS 0.107444
R11941 VSS.n1982 VSS 0.107444
R11942 VSS.n3742 VSS 0.107444
R11943 VSS.n2215 VSS 0.107444
R11944 VSS.n2265 VSS 0.107444
R11945 VSS.n2023 VSS 0.107444
R11946 VSS VSS.n2046 0.107444
R11947 VSS.n103 VSS 0.107444
R11948 VSS.n145 VSS 0.107444
R11949 VSS.n187 VSS 0.107444
R11950 VSS.n229 VSS 0.107444
R11951 VSS.n271 VSS 0.107444
R11952 VSS.n327 VSS 0.107444
R11953 VSS.n2230 VSS 0.107444
R11954 VSS.n2246 VSS 0.107444
R11955 VSS.n88 VSS 0.107444
R11956 VSS.n130 VSS 0.107444
R11957 VSS.n172 VSS 0.107444
R11958 VSS.n214 VSS 0.107444
R11959 VSS.n256 VSS 0.107444
R11960 VSS.n2182 VSS 0.107444
R11961 VSS.n2323 VSS 0.107444
R11962 VSS.n2139 VSS 0.107444
R11963 VSS.n1530 VSS 0.107444
R11964 VSS.n1592 VSS 0.107444
R11965 VSS.n1634 VSS 0.107444
R11966 VSS.n1676 VSS 0.107444
R11967 VSS.n1718 VSS 0.107444
R11968 VSS VSS.n1779 0.107444
R11969 VSS VSS.n1758 0.107444
R11970 VSS.n2084 VSS 0.107444
R11971 VSS.n2417 VSS 0.107444
R11972 VSS.n2384 VSS 0.107444
R11973 VSS.n2428 VSS 0.107444
R11974 VSS.n2482 VSS 0.107444
R11975 VSS.n2582 VSS 0.107444
R11976 VSS.n2635 VSS 0.107444
R11977 VSS.n2770 VSS 0.107444
R11978 VSS.n2918 VSS 0.107444
R11979 VSS.n2878 VSS 0.107444
R11980 VSS.n1000 VSS 0.107444
R11981 VSS.n2546 VSS 0.107444
R11982 VSS.n2613 VSS 0.107444
R11983 VSS.n1445 VSS 0.107444
R11984 VSS VSS.n1488 0.107444
R11985 VSS.n2649 VSS 0.107444
R11986 VSS.n2784 VSS 0.107444
R11987 VSS.n2835 VSS 0.107444
R11988 VSS.n2851 VSS 0.107444
R11989 VSS.n3470 VSS 0.107444
R11990 VSS.n3507 VSS 0.107444
R11991 VSS.n2513 VSS 0.107444
R11992 VSS.n2592 VSS 0.107444
R11993 VSS.n2117 VSS 0.107444
R11994 VSS.n1561 VSS 0.107444
R11995 VSS.n1577 VSS 0.107444
R11996 VSS.n1619 VSS 0.107444
R11997 VSS.n1661 VSS 0.107444
R11998 VSS.n1703 VSS 0.107444
R11999 VSS.n1796 VSS 0.107444
R12000 VSS.n563 VSS 0.107444
R12001 VSS.n587 VSS 0.107444
R12002 VSS.n638 VSS 0.107444
R12003 VSS.n688 VSS 0.107444
R12004 VSS.n738 VSS 0.107444
R12005 VSS.n788 VSS 0.107444
R12006 VSS.n835 VSS 0.107444
R12007 VSS.n902 VSS 0.107444
R12008 VSS.n2757 VSS 0.102861
R12009 VSS.n2710 VSS 0.102861
R12010 VSS.n3445 VSS 0.102861
R12011 VSS.n1223 VSS 0.102861
R12012 VSS.n3184 VSS 0.102861
R12013 VSS VSS.n1053 0.102861
R12014 VSS.n3388 VSS.n3387 0.0936944
R12015 VSS.n3296 VSS.n1129 0.0936944
R12016 VSS.n1328 VSS.n1166 0.0936944
R12017 VSS.n2958 VSS.n2957 0.0876395
R12018 VSS.n3449 VSS.n1012 0.0876395
R12019 VSS.n3457 VSS.n3456 0.0876395
R12020 VSS.n1006 VSS.n1005 0.0876395
R12021 VSS.n44 VSS.n43 0.0876395
R12022 VSS.n3771 VSS.n3770 0.0876395
R12023 VSS.n3762 VSS.n3761 0.0876395
R12024 VSS.n499 VSS.n497 0.0876395
R12025 VSS.n495 VSS.n494 0.0876395
R12026 VSS.n41 VSS.n40 0.0876395
R12027 VSS.n27 VSS.n24 0.0876395
R12028 VSS.n57 VSS.n56 0.0876395
R12029 VSS.n387 VSS.n386 0.0876395
R12030 VSS.n384 VSS.n382 0.0876395
R12031 VSS.n380 VSS.n378 0.0876395
R12032 VSS.n358 VSS.n355 0.0876395
R12033 VSS.n878 VSS.n877 0.0876395
R12034 VSS.n370 VSS.n369 0.0876395
R12035 VSS.n366 VSS.n365 0.0876395
R12036 VSS.n3786 VSS.n3785 0.0876395
R12037 VSS.n3777 VSS.n3776 0.0876395
R12038 VSS.n531 VSS.n530 0.0876395
R12039 VSS.n611 VSS.n610 0.0876395
R12040 VSS.n632 VSS.n631 0.0876395
R12041 VSS.n661 VSS.n660 0.0876395
R12042 VSS.n682 VSS.n681 0.0876395
R12043 VSS.n711 VSS.n710 0.0876395
R12044 VSS.n732 VSS.n731 0.0876395
R12045 VSS.n761 VSS.n760 0.0876395
R12046 VSS.n782 VSS.n781 0.0876395
R12047 VSS.n811 VSS.n810 0.0876395
R12048 VSS.n829 VSS.n828 0.0876395
R12049 VSS.n858 VSS.n857 0.0876395
R12050 VSS.n896 VSS.n895 0.0876395
R12051 VSS.n887 VSS.n886 0.0876395
R12052 VSS.n353 VSS.n352 0.0876395
R12053 VSS.n7 VSS.n4 0.0876395
R12054 VSS.n20 VSS.n19 0.0876395
R12055 VSS.n528 VSS.n527 0.0876395
R12056 VSS.n537 VSS.n536 0.0876395
R12057 VSS.n394 VSS.n347 0.0876395
R12058 VSS.n378 VSS 0.0876395
R12059 VSS.n382 VSS 0.0876395
R12060 VSS.n387 VSS 0.0876395
R12061 VSS.n485 VSS.n482 0.0876395
R12062 VSS.n617 VSS.n472 0.0876395
R12063 VSS.n467 VSS.n464 0.0876395
R12064 VSS.n667 VSS.n454 0.0876395
R12065 VSS.n449 VSS.n446 0.0876395
R12066 VSS.n717 VSS.n436 0.0876395
R12067 VSS.n431 VSS.n428 0.0876395
R12068 VSS.n767 VSS.n418 0.0876395
R12069 VSS.n413 VSS.n410 0.0876395
R12070 VSS.n817 VSS.n390 0.0876395
R12071 VSS.n2009 VSS.n2008 0.0876395
R12072 VSS.n2000 VSS.n1999 0.0876395
R12073 VSS.n3756 VSS.n3755 0.0876395
R12074 VSS.n3747 VSS.n3746 0.0876395
R12075 VSS.n68 VSS.n67 0.0876395
R12076 VSS.n1974 VSS.n1971 0.0876395
R12077 VSS.n1987 VSS.n1986 0.0876395
R12078 VSS.n1991 VSS.n61 0.0876395
R12079 VSS.n2223 VSS.n2222 0.0876395
R12080 VSS.n2306 VSS.n2305 0.0876395
R12081 VSS.n2297 VSS.n2296 0.0876395
R12082 VSS.n2260 VSS.n2258 0.0876395
R12083 VSS.n2256 VSS.n2255 0.0876395
R12084 VSS.n2205 VSS.n2202 0.0876395
R12085 VSS.n2211 VSS.n1933 0.0876395
R12086 VSS.n1943 VSS.n1942 0.0876395
R12087 VSS.n3580 VSS.n3579 0.0876395
R12088 VSS.n298 VSS.n297 0.0876395
R12089 VSS.n3564 VSS.n300 0.0876395
R12090 VSS.n3573 VSS.n3572 0.0876395
R12091 VSS.n2068 VSS.n2067 0.0876395
R12092 VSS.n2059 VSS.n2058 0.0876395
R12093 VSS.n2049 VSS.n2048 0.0876395
R12094 VSS.n3737 VSS.n3736 0.0876395
R12095 VSS.n3728 VSS.n3727 0.0876395
R12096 VSS.n3711 VSS.n3710 0.0876395
R12097 VSS.n3702 VSS.n3701 0.0876395
R12098 VSS.n3685 VSS.n3684 0.0876395
R12099 VSS.n3676 VSS.n3675 0.0876395
R12100 VSS.n3659 VSS.n3658 0.0876395
R12101 VSS.n3650 VSS.n3649 0.0876395
R12102 VSS.n3633 VSS.n3632 0.0876395
R12103 VSS.n3624 VSS.n3623 0.0876395
R12104 VSS.n3607 VSS.n3606 0.0876395
R12105 VSS.n3598 VSS.n3597 0.0876395
R12106 VSS.n279 VSS.n278 0.0876395
R12107 VSS.n322 VSS.n320 0.0876395
R12108 VSS.n319 VSS.n318 0.0876395
R12109 VSS.n2015 VSS.n2012 0.0876395
R12110 VSS.n2028 VSS.n2027 0.0876395
R12111 VSS.n2036 VSS.n2035 0.0876395
R12112 VSS.n2040 VSS.n71 0.0876395
R12113 VSS.n81 VSS.n80 0.0876395
R12114 VSS.n98 VSS.n95 0.0876395
R12115 VSS.n114 VSS.n113 0.0876395
R12116 VSS.n140 VSS.n137 0.0876395
R12117 VSS.n156 VSS.n155 0.0876395
R12118 VSS.n182 VSS.n179 0.0876395
R12119 VSS.n198 VSS.n197 0.0876395
R12120 VSS.n224 VSS.n221 0.0876395
R12121 VSS.n240 VSS.n239 0.0876395
R12122 VSS.n266 VSS.n263 0.0876395
R12123 VSS.n2229 VSS.n2228 0.0876395
R12124 VSS.n2238 VSS.n2237 0.0876395
R12125 VSS.n2291 VSS.n2290 0.0876395
R12126 VSS.n2282 VSS.n2281 0.0876395
R12127 VSS.n3724 VSS.n3723 0.0876395
R12128 VSS.n3715 VSS.n3714 0.0876395
R12129 VSS.n3698 VSS.n3697 0.0876395
R12130 VSS.n3689 VSS.n3688 0.0876395
R12131 VSS.n3672 VSS.n3671 0.0876395
R12132 VSS.n3663 VSS.n3662 0.0876395
R12133 VSS.n3646 VSS.n3645 0.0876395
R12134 VSS.n3637 VSS.n3636 0.0876395
R12135 VSS.n3620 VSS.n3619 0.0876395
R12136 VSS.n3611 VSS.n3610 0.0876395
R12137 VSS.n3590 VSS.n3589 0.0876395
R12138 VSS.n306 VSS.n305 0.0876395
R12139 VSS.n304 VSS.n303 0.0876395
R12140 VSS.n1970 VSS.n1969 0.0876395
R12141 VSS.n2235 VSS.n2234 0.0876395
R12142 VSS.n1948 VSS.n1945 0.0876395
R12143 VSS.n2251 VSS.n2250 0.0876395
R12144 VSS.n2273 VSS.n83 0.0876395
R12145 VSS.n93 VSS.n92 0.0876395
R12146 VSS.n119 VSS.n116 0.0876395
R12147 VSS.n135 VSS.n134 0.0876395
R12148 VSS.n161 VSS.n158 0.0876395
R12149 VSS.n177 VSS.n176 0.0876395
R12150 VSS.n203 VSS.n200 0.0876395
R12151 VSS.n219 VSS.n218 0.0876395
R12152 VSS.n245 VSS.n242 0.0876395
R12153 VSS.n261 VSS.n260 0.0876395
R12154 VSS.n283 VSS.n280 0.0876395
R12155 VSS.n2199 VSS.n2198 0.0876395
R12156 VSS.n2312 VSS.n2311 0.0876395
R12157 VSS.n2321 VSS.n2320 0.0876395
R12158 VSS.n1924 VSS.n1920 0.0876395
R12159 VSS.n2329 VSS.n2328 0.0876395
R12160 VSS.n2172 VSS.n2169 0.0876395
R12161 VSS.n2178 VSS.n1931 0.0876395
R12162 VSS.n2318 VSS.n2317 0.0876395
R12163 VSS.n941 VSS.n940 0.0876395
R12164 VSS.n938 VSS.n936 0.0876395
R12165 VSS.n2166 VSS.n2165 0.0876395
R12166 VSS.n2157 VSS.n2156 0.0876395
R12167 VSS.n2344 VSS.n2343 0.0876395
R12168 VSS.n2335 VSS.n2334 0.0876395
R12169 VSS.n1912 VSS.n1911 0.0876395
R12170 VSS.n1895 VSS.n1894 0.0876395
R12171 VSS.n1886 VSS.n1885 0.0876395
R12172 VSS.n1869 VSS.n1868 0.0876395
R12173 VSS.n1860 VSS.n1859 0.0876395
R12174 VSS.n1843 VSS.n1842 0.0876395
R12175 VSS.n1834 VSS.n1833 0.0876395
R12176 VSS.n1817 VSS.n1816 0.0876395
R12177 VSS.n1808 VSS.n1807 0.0876395
R12178 VSS.n1773 VSS.n1772 0.0876395
R12179 VSS.n1763 VSS.n1762 0.0876395
R12180 VSS.n1760 VSS.n1759 0.0876395
R12181 VSS.n1752 VSS.n1751 0.0876395
R12182 VSS.n1749 VSS.n1748 0.0876395
R12183 VSS.n2131 VSS.n2128 0.0876395
R12184 VSS.n2144 VSS.n2143 0.0876395
R12185 VSS.n2148 VSS.n1525 0.0876395
R12186 VSS.n1535 VSS.n1534 0.0876395
R12187 VSS.n1543 VSS.n1542 0.0876395
R12188 VSS.n1587 VSS.n1584 0.0876395
R12189 VSS.n1603 VSS.n1602 0.0876395
R12190 VSS.n1629 VSS.n1626 0.0876395
R12191 VSS.n1645 VSS.n1644 0.0876395
R12192 VSS.n1671 VSS.n1668 0.0876395
R12193 VSS.n1687 VSS.n1686 0.0876395
R12194 VSS.n1713 VSS.n1710 0.0876395
R12195 VSS.n1729 VSS.n1728 0.0876395
R12196 VSS.n1737 VSS.n1736 0.0876395
R12197 VSS.n2101 VSS.n2100 0.0876395
R12198 VSS.n2406 VSS.n2405 0.0876395
R12199 VSS.n2415 VSS.n2414 0.0876395
R12200 VSS.n1503 VSS.n1499 0.0876395
R12201 VSS.n2423 VSS.n2422 0.0876395
R12202 VSS.n2382 VSS.n2381 0.0876395
R12203 VSS.n2400 VSS.n2399 0.0876395
R12204 VSS.n2442 VSS.n2441 0.0876395
R12205 VSS.n2433 VSS.n2432 0.0876395
R12206 VSS.n1497 VSS.n1496 0.0876395
R12207 VSS.n2499 VSS.n2498 0.0876395
R12208 VSS.n2571 VSS.n2570 0.0876395
R12209 VSS.n2580 VSS.n2579 0.0876395
R12210 VSS.n2625 VSS.n2624 0.0876395
R12211 VSS.n2643 VSS.n2642 0.0876395
R12212 VSS.n2985 VSS.n2984 0.0876395
R12213 VSS.n2968 VSS.n2967 0.0876395
R12214 VSS.n2775 VSS.n2765 0.0876395
R12215 VSS.n2936 VSS.n2935 0.0876395
R12216 VSS.n2923 VSS.n2810 0.0876395
R12217 VSS.n2910 VSS.n2909 0.0876395
R12218 VSS.n2893 VSS.n2892 0.0876395
R12219 VSS.n2882 VSS.n983 0.0876395
R12220 VSS.n3464 VSS.n3463 0.0876395
R12221 VSS.n3493 VSS.n3492 0.0876395
R12222 VSS.n968 VSS.n963 0.0876395
R12223 VSS.n3501 VSS.n3500 0.0876395
R12224 VSS.n3236 VSS.n3235 0.0876395
R12225 VSS.n3238 VSS.n3237 0.0876395
R12226 VSS.n3219 VSS.n3218 0.0876395
R12227 VSS.n3216 VSS.n3214 0.0876395
R12228 VSS.n2472 VSS.n2469 0.0876395
R12229 VSS.n2478 VSS.n1412 0.0876395
R12230 VSS.n2577 VSS.n2576 0.0876395
R12231 VSS.n1405 VSS.n1385 0.0876395
R12232 VSS.n2544 VSS.n2543 0.0876395
R12233 VSS.n2565 VSS.n2564 0.0876395
R12234 VSS.n2611 VSS.n2610 0.0876395
R12235 VSS.n1392 VSS.n1388 0.0876395
R12236 VSS.n2619 VSS.n2618 0.0876395
R12237 VSS.n1432 VSS.n1431 0.0876395
R12238 VSS.n1418 VSS.n1415 0.0876395
R12239 VSS.n2550 VSS.n1397 0.0876395
R12240 VSS.n2466 VSS.n2465 0.0876395
R12241 VSS.n2457 VSS.n2456 0.0876395
R12242 VSS.n2448 VSS.n2447 0.0876395
R12243 VSS.n1482 VSS.n1481 0.0876395
R12244 VSS.n2647 VSS.n2646 0.0876395
R12245 VSS.n2981 VSS.n2980 0.0876395
R12246 VSS.n2972 VSS.n2971 0.0876395
R12247 VSS.n2949 VSS.n2948 0.0876395
R12248 VSS.n2940 VSS.n2939 0.0876395
R12249 VSS.n2843 VSS.n2842 0.0876395
R12250 VSS.n2906 VSS.n2905 0.0876395
R12251 VSS.n2897 VSS.n2896 0.0876395
R12252 VSS.n3468 VSS.n3467 0.0876395
R12253 VSS.n3489 VSS.n3488 0.0876395
R12254 VSS.n3474 VSS.n962 0.0876395
R12255 VSS.n3505 VSS.n3504 0.0876395
R12256 VSS.n957 VSS.n955 0.0876395
R12257 VSS.n954 VSS.n953 0.0876395
R12258 VSS.n2689 VSS.n2688 0.0876395
R12259 VSS.n2740 VSS.n2739 0.0876395
R12260 VSS.n2735 VSS.n2734 0.0876395
R12261 VSS.n3428 VSS.n3427 0.0876395
R12262 VSS.n3423 VSS.n3422 0.0876395
R12263 VSS.n3174 VSS.n3173 0.0876395
R12264 VSS.n3165 VSS.n3164 0.0876395
R12265 VSS.n1188 VSS.n1187 0.0876395
R12266 VSS.n3366 VSS.n3365 0.0876395
R12267 VSS.n3358 VSS.n3357 0.0876395
R12268 VSS.n3350 VSS.n3349 0.0876395
R12269 VSS.n3342 VSS.n3341 0.0876395
R12270 VSS.n3333 VSS.n3332 0.0876395
R12271 VSS.n3325 VSS.n3324 0.0876395
R12272 VSS.n3317 VSS.n3316 0.0876395
R12273 VSS.n3309 VSS.n3308 0.0876395
R12274 VSS.n3406 VSS.n3405 0.0876395
R12275 VSS.n3398 VSS.n3397 0.0876395
R12276 VSS.n3393 VSS.n3392 0.0876395
R12277 VSS.n1083 VSS.n1082 0.0876395
R12278 VSS.n3406 VSS 0.0876395
R12279 VSS.n3398 VSS 0.0876395
R12280 VSS.n3393 VSS 0.0876395
R12281 VSS.n1083 VSS 0.0876395
R12282 VSS.n1080 VSS.n1077 0.0876395
R12283 VSS VSS.n1188 0.0876395
R12284 VSS.n3366 VSS 0.0876395
R12285 VSS.n3358 VSS 0.0876395
R12286 VSS.n3350 VSS 0.0876395
R12287 VSS.n3341 VSS 0.0876395
R12288 VSS.n3345 VSS.n3344 0.0876395
R12289 VSS.n3333 VSS 0.0876395
R12290 VSS.n3325 VSS 0.0876395
R12291 VSS.n3317 VSS 0.0876395
R12292 VSS.n3308 VSS 0.0876395
R12293 VSS.n3312 VSS.n3311 0.0876395
R12294 VSS.n2994 VSS.n2993 0.0876395
R12295 VSS.n3015 VSS.n1349 0.0876395
R12296 VSS.n3028 VSS.n3027 0.0876395
R12297 VSS.n3069 VSS.n1321 0.0876395
R12298 VSS.n1316 VSS.n1315 0.0876395
R12299 VSS.n3088 VSS.n3087 0.0876395
R12300 VSS.n3117 VSS.n1287 0.0876395
R12301 VSS.n3125 VSS.n1281 0.0876395
R12302 VSS.n1276 VSS.n1275 0.0876395
R12303 VSS.n3142 VSS.n1269 0.0876395
R12304 VSS.n3196 VSS.n1263 0.0876395
R12305 VSS.n1261 VSS.n1259 0.0876395
R12306 VSS.n1256 VSS.n1254 0.0876395
R12307 VSS.n1362 VSS.n1361 0.0876395
R12308 VSS.n3056 VSS.n3055 0.0876395
R12309 VSS.n3051 VSS.n3050 0.0876395
R12310 VSS.n3281 VSS.n3280 0.0876395
R12311 VSS.n3276 VSS.n3275 0.0876395
R12312 VSS.n3257 VSS.n3256 0.0876395
R12313 VSS.n3247 VSS.n3246 0.0876395
R12314 VSS.n3056 VSS 0.0876395
R12315 VSS.n3281 VSS 0.0876395
R12316 VSS.n3257 VSS 0.0876395
R12317 VSS.n3247 VSS 0.0876395
R12318 VSS.n2994 VSS 0.0876395
R12319 VSS.n1349 VSS 0.0876395
R12320 VSS.n3028 VSS 0.0876395
R12321 VSS.n1315 VSS 0.0876395
R12322 VSS.n1318 VSS.n1317 0.0876395
R12323 VSS.n1321 VSS 0.0876395
R12324 VSS.n3088 VSS 0.0876395
R12325 VSS.n1287 VSS 0.0876395
R12326 VSS.n1275 VSS 0.0876395
R12327 VSS.n1278 VSS.n1277 0.0876395
R12328 VSS.n1281 VSS 0.0876395
R12329 VSS.n1269 VSS 0.0876395
R12330 VSS.n1263 VSS 0.0876395
R12331 VSS.n1259 VSS 0.0876395
R12332 VSS.n1254 VSS 0.0876395
R12333 VSS.n1251 VSS.n1250 0.0876395
R12334 VSS.n996 VSS.n973 0.0876395
R12335 VSS.n3457 VSS 0.0876395
R12336 VSS.n1006 VSS 0.0876395
R12337 VSS.n2818 VSS.n2817 0.0876395
R12338 VSS.n2873 VSS.n2870 0.0876395
R12339 VSS.n1012 VSS 0.0876395
R12340 VSS.n2800 VSS.n2797 0.0876395
R12341 VSS.n2925 VSS.n2922 0.0876395
R12342 VSS.n2952 VSS.n2774 0.0876395
R12343 VSS.n2958 VSS 0.0876395
R12344 VSS.n2664 VSS.n2662 0.0876395
R12345 VSS.n2740 VSS 0.0876395
R12346 VSS.n3428 VSS 0.0876395
R12347 VSS.n3174 VSS 0.0876395
R12348 VSS.n3165 VSS 0.0876395
R12349 VSS.n1380 VSS.n1377 0.0876395
R12350 VSS.n2631 VSS.n1366 0.0876395
R12351 VSS.n2539 VSS.n2538 0.0876395
R12352 VSS.n2530 VSS.n2529 0.0876395
R12353 VSS.n2606 VSS.n2605 0.0876395
R12354 VSS.n2597 VSS.n2596 0.0876395
R12355 VSS.n2591 VSS.n2590 0.0876395
R12356 VSS.n2505 VSS.n2502 0.0876395
R12357 VSS.n2518 VSS.n2517 0.0876395
R12358 VSS.n2522 VSS.n1399 0.0876395
R12359 VSS.n2125 VSS.n2124 0.0876395
R12360 VSS.n2359 VSS.n2358 0.0876395
R12361 VSS.n2350 VSS.n2349 0.0876395
R12362 VSS.n1569 VSS.n1568 0.0876395
R12363 VSS.n1908 VSS.n1907 0.0876395
R12364 VSS.n1899 VSS.n1898 0.0876395
R12365 VSS.n1882 VSS.n1881 0.0876395
R12366 VSS.n1873 VSS.n1872 0.0876395
R12367 VSS.n1856 VSS.n1855 0.0876395
R12368 VSS.n1847 VSS.n1846 0.0876395
R12369 VSS.n1830 VSS.n1829 0.0876395
R12370 VSS.n1821 VSS.n1820 0.0876395
R12371 VSS.n1804 VSS.n1803 0.0876395
R12372 VSS.n949 VSS.n928 0.0876395
R12373 VSS.n3544 VSS.n3543 0.0876395
R12374 VSS.n3550 VSS.n3549 0.0876395
R12375 VSS.n3552 VSS.n3551 0.0876395
R12376 VSS.n921 VSS.n919 0.0876395
R12377 VSS.n918 VSS.n917 0.0876395
R12378 VSS.n2107 VSS.n2104 0.0876395
R12379 VSS.n2113 VSS.n1512 0.0876395
R12380 VSS.n1522 VSS.n1521 0.0876395
R12381 VSS.n1566 VSS.n1565 0.0876395
R12382 VSS.n2379 VSS.n2378 0.0876395
R12383 VSS.n2365 VSS.n2362 0.0876395
R12384 VSS.n2388 VSS.n1490 0.0876395
R12385 VSS.n2074 VSS.n2071 0.0876395
R12386 VSS.n2080 VSS.n1510 0.0876395
R12387 VSS.n2412 VSS.n2411 0.0876395
R12388 VSS.n1548 VSS.n1545 0.0876395
R12389 VSS.n1582 VSS.n1581 0.0876395
R12390 VSS.n1608 VSS.n1605 0.0876395
R12391 VSS.n1624 VSS.n1623 0.0876395
R12392 VSS.n1650 VSS.n1647 0.0876395
R12393 VSS.n1666 VSS.n1665 0.0876395
R12394 VSS.n1692 VSS.n1689 0.0876395
R12395 VSS.n1708 VSS.n1707 0.0876395
R12396 VSS.n1783 VSS.n1780 0.0876395
R12397 VSS.n1792 VSS.n945 0.0876395
R12398 VSS.n3528 VSS.n947 0.0876395
R12399 VSS.n936 VSS 0.0876395
R12400 VSS.n941 VSS 0.0876395
R12401 VSS.n1437 VSS.n1434 0.0876395
R12402 VSS.n1450 VSS.n1449 0.0876395
R12403 VSS.n1458 VSS.n1457 0.0876395
R12404 VSS.n1466 VSS.n1465 0.0876395
R12405 VSS.n1470 VSS.n1376 0.0876395
R12406 VSS.n1371 VSS.n1368 0.0876395
R12407 VSS.n2660 VSS.n2659 0.0876395
R12408 VSS.n2779 VSS.n2776 0.0876395
R12409 VSS.n2795 VSS.n2794 0.0876395
R12410 VSS.n2840 VSS.n2839 0.0876395
R12411 VSS.n2823 VSS.n2820 0.0876395
R12412 VSS.n2856 VSS.n2855 0.0876395
R12413 VSS.n2860 VSS.n982 0.0876395
R12414 VSS.n977 VSS.n974 0.0876395
R12415 VSS.n561 VSS.n2 0.0876395
R12416 VSS.n576 VSS.n575 0.0876395
R12417 VSS.n585 VSS.n584 0.0876395
R12418 VSS.n606 VSS.n605 0.0876395
R12419 VSS.n636 VSS.n635 0.0876395
R12420 VSS.n657 VSS.n656 0.0876395
R12421 VSS.n686 VSS.n685 0.0876395
R12422 VSS.n707 VSS.n706 0.0876395
R12423 VSS.n736 VSS.n735 0.0876395
R12424 VSS.n757 VSS.n756 0.0876395
R12425 VSS.n786 VSS.n785 0.0876395
R12426 VSS.n807 VSS.n806 0.0876395
R12427 VSS.n833 VSS.n832 0.0876395
R12428 VSS.n854 VSS.n853 0.0876395
R12429 VSS.n839 VSS.n346 0.0876395
R12430 VSS.n900 VSS.n899 0.0876395
R12431 VSS.n341 VSS.n339 0.0876395
R12432 VSS.n338 VSS.n337 0.0876395
R12433 VSS.n3791 VSS.n3790 0.0876395
R12434 VSS.n557 VSS.n548 0.0876395
R12435 VSS.n582 VSS.n581 0.0876395
R12436 VSS.n541 VSS.n538 0.0876395
R12437 VSS.n591 VSS.n481 0.0876395
R12438 VSS.n476 VSS.n473 0.0876395
R12439 VSS.n642 VSS.n463 0.0876395
R12440 VSS.n458 VSS.n455 0.0876395
R12441 VSS.n692 VSS.n445 0.0876395
R12442 VSS.n440 VSS.n437 0.0876395
R12443 VSS.n742 VSS.n427 0.0876395
R12444 VSS.n422 VSS.n419 0.0876395
R12445 VSS.n792 VSS.n409 0.0876395
R12446 VSS.n404 VSS.n401 0.0876395
R12447 VSS VSS.n2676 0.0876395
R12448 VSS VSS.n1014 0.0876395
R12449 VSS VSS.n2686 0.0876395
R12450 VSS.n2680 VSS 0.0876395
R12451 VSS VSS.n2707 0.0876395
R12452 VSS.n2732 VSS 0.0876395
R12453 VSS.n1019 VSS 0.0876395
R12454 VSS VSS.n1025 0.0876395
R12455 VSS.n3420 VSS 0.0876395
R12456 VSS.n3153 VSS 0.0876395
R12457 VSS.n3371 VSS 0.0876395
R12458 VSS VSS.n1195 0.0876395
R12459 VSS VSS.n1201 0.0876395
R12460 VSS VSS.n1209 0.0876395
R12461 VSS VSS.n1215 0.0876395
R12462 VSS VSS.n1222 0.0876395
R12463 VSS.n1040 VSS 0.0876395
R12464 VSS VSS.n1046 0.0876395
R12465 VSS.n3304 VSS.n1040 0.0876395
R12466 VSS.n1046 VSS.n1045 0.0876395
R12467 VSS.n3372 VSS.n3371 0.0876395
R12468 VSS.n1195 VSS.n1194 0.0876395
R12469 VSS.n1201 VSS.n1200 0.0876395
R12470 VSS.n1209 VSS.n1208 0.0876395
R12471 VSS.n1215 VSS.n1214 0.0876395
R12472 VSS.n1222 VSS.n1221 0.0876395
R12473 VSS VSS.n1351 0.0876395
R12474 VSS.n1345 VSS 0.0876395
R12475 VSS VSS.n1323 0.0876395
R12476 VSS.n1311 VSS 0.0876395
R12477 VSS VSS.n1289 0.0876395
R12478 VSS.n1283 VSS 0.0876395
R12479 VSS VSS.n1271 0.0876395
R12480 VSS VSS.n1265 0.0876395
R12481 VSS.n1359 VSS 0.0876395
R12482 VSS VSS.n1337 0.0876395
R12483 VSS.n1331 VSS 0.0876395
R12484 VSS VSS.n1303 0.0876395
R12485 VSS.n1297 VSS 0.0876395
R12486 VSS.n1226 VSS 0.0876395
R12487 VSS.n3273 VSS 0.0876395
R12488 VSS VSS.n1240 0.0876395
R12489 VSS.n1360 VSS.n1359 0.0876395
R12490 VSS.n3003 VSS.n1337 0.0876395
R12491 VSS.n1333 VSS.n1331 0.0876395
R12492 VSS.n3049 VSS.n1303 0.0876395
R12493 VSS.n1299 VSS.n1297 0.0876395
R12494 VSS.n3105 VSS.n1226 0.0876395
R12495 VSS.n3274 VSS.n3273 0.0876395
R12496 VSS.n1240 VSS.n1239 0.0876395
R12497 VSS.n2990 VSS.n1351 0.0876395
R12498 VSS.n1347 VSS.n1345 0.0876395
R12499 VSS.n3024 VSS.n1323 0.0876395
R12500 VSS.n1313 VSS.n1311 0.0876395
R12501 VSS.n3084 VSS.n1289 0.0876395
R12502 VSS.n1285 VSS.n1283 0.0876395
R12503 VSS.n1273 VSS.n1271 0.0876395
R12504 VSS.n1267 VSS.n1265 0.0876395
R12505 VSS.n2762 VSS.n1014 0.0876395
R12506 VSS.n2676 VSS.n2675 0.0876395
R12507 VSS.n2687 VSS.n2686 0.0876395
R12508 VSS.n2682 VSS.n2680 0.0876395
R12509 VSS.n2707 VSS.n2706 0.0876395
R12510 VSS.n2733 VSS.n2732 0.0876395
R12511 VSS.n2721 VSS.n1019 0.0876395
R12512 VSS.n1025 VSS.n1024 0.0876395
R12513 VSS.n3421 VSS.n3420 0.0876395
R12514 VSS.n3153 VSS.n3152 0.0876395
R12515 VSS.n2759 VSS 0.0875833
R12516 VSS.n3448 VSS 0.0875833
R12517 VSS.n3150 VSS 0.0875833
R12518 VSS.n43 VSS.n42 0.0875833
R12519 VSS.n3772 VSS.n3771 0.0875833
R12520 VSS.n3761 VSS.n3760 0.0875833
R12521 VSS.n496 VSS.n495 0.0875833
R12522 VSS.n879 VSS.n878 0.0875833
R12523 VSS.n365 VSS.n354 0.0875833
R12524 VSS.n3787 VSS.n3786 0.0875833
R12525 VSS.n3776 VSS.n3775 0.0875833
R12526 VSS.n530 VSS.n529 0.0875833
R12527 VSS.n610 VSS.n609 0.0875833
R12528 VSS.n633 VSS.n632 0.0875833
R12529 VSS.n660 VSS.n659 0.0875833
R12530 VSS.n683 VSS.n682 0.0875833
R12531 VSS.n710 VSS.n709 0.0875833
R12532 VSS.n733 VSS.n732 0.0875833
R12533 VSS.n760 VSS.n759 0.0875833
R12534 VSS.n783 VSS.n782 0.0875833
R12535 VSS.n810 VSS.n809 0.0875833
R12536 VSS.n830 VSS.n829 0.0875833
R12537 VSS.n857 VSS.n856 0.0875833
R12538 VSS.n897 VSS.n896 0.0875833
R12539 VSS.n881 VSS.n353 0.0875833
R12540 VSS.n2010 VSS.n2009 0.0875833
R12541 VSS.n1999 VSS.n1998 0.0875833
R12542 VSS.n3757 VSS.n3756 0.0875833
R12543 VSS.n3741 VSS.n68 0.0875833
R12544 VSS.n2224 VSS.n2223 0.0875833
R12545 VSS.n2307 VSS.n2306 0.0875833
R12546 VSS.n2296 VSS.n2295 0.0875833
R12547 VSS.n2257 VSS.n2256 0.0875833
R12548 VSS.n3576 VSS.n298 0.0875833
R12549 VSS.n3574 VSS.n3573 0.0875833
R12550 VSS.n2069 VSS.n2068 0.0875833
R12551 VSS.n2058 VSS.n2057 0.0875833
R12552 VSS.n2048 VSS.n2047 0.0875833
R12553 VSS.n3738 VSS.n3737 0.0875833
R12554 VSS.n3727 VSS.n3726 0.0875833
R12555 VSS.n3712 VSS.n3711 0.0875833
R12556 VSS.n3701 VSS.n3700 0.0875833
R12557 VSS.n3686 VSS.n3685 0.0875833
R12558 VSS.n3675 VSS.n3674 0.0875833
R12559 VSS.n3660 VSS.n3659 0.0875833
R12560 VSS.n3649 VSS.n3648 0.0875833
R12561 VSS.n3634 VSS.n3633 0.0875833
R12562 VSS.n3623 VSS.n3622 0.0875833
R12563 VSS.n3608 VSS.n3607 0.0875833
R12564 VSS.n3592 VSS.n279 0.0875833
R12565 VSS.n2228 VSS.n2227 0.0875833
R12566 VSS.n2237 VSS.n2236 0.0875833
R12567 VSS.n2292 VSS.n2291 0.0875833
R12568 VSS.n2281 VSS.n2280 0.0875833
R12569 VSS.n3725 VSS.n3724 0.0875833
R12570 VSS.n3714 VSS.n3713 0.0875833
R12571 VSS.n3699 VSS.n3698 0.0875833
R12572 VSS.n3688 VSS.n3687 0.0875833
R12573 VSS.n3673 VSS.n3672 0.0875833
R12574 VSS.n3662 VSS.n3661 0.0875833
R12575 VSS.n3647 VSS.n3646 0.0875833
R12576 VSS.n3636 VSS.n3635 0.0875833
R12577 VSS.n3621 VSS.n3620 0.0875833
R12578 VSS.n3610 VSS.n3609 0.0875833
R12579 VSS.n3591 VSS.n3590 0.0875833
R12580 VSS.n303 VSS.n299 0.0875833
R12581 VSS.n2200 VSS.n2199 0.0875833
R12582 VSS.n2311 VSS.n2310 0.0875833
R12583 VSS.n2320 VSS.n2319 0.0875833
R12584 VSS.n2330 VSS.n2329 0.0875833
R12585 VSS.n3540 VSS.n930 0.0875833
R12586 VSS.n3540 VSS 0.0875833
R12587 VSS.n2167 VSS.n2166 0.0875833
R12588 VSS.n2156 VSS.n2155 0.0875833
R12589 VSS.n2345 VSS.n2344 0.0875833
R12590 VSS.n2334 VSS.n2333 0.0875833
R12591 VSS.n1911 VSS.n1910 0.0875833
R12592 VSS.n1896 VSS.n1895 0.0875833
R12593 VSS.n1885 VSS.n1884 0.0875833
R12594 VSS.n1870 VSS.n1869 0.0875833
R12595 VSS.n1859 VSS.n1858 0.0875833
R12596 VSS.n1844 VSS.n1843 0.0875833
R12597 VSS.n1833 VSS.n1832 0.0875833
R12598 VSS.n1818 VSS.n1817 0.0875833
R12599 VSS.n1807 VSS.n1806 0.0875833
R12600 VSS.n1772 VSS.n1771 0.0875833
R12601 VSS.n1759 VSS.n929 0.0875833
R12602 VSS.n2102 VSS.n2101 0.0875833
R12603 VSS.n2405 VSS.n2404 0.0875833
R12604 VSS.n2414 VSS.n2413 0.0875833
R12605 VSS.n2424 VSS.n2423 0.0875833
R12606 VSS.n2381 VSS.n2380 0.0875833
R12607 VSS.n2401 VSS.n2400 0.0875833
R12608 VSS.n2443 VSS.n2442 0.0875833
R12609 VSS.n2427 VSS.n1497 0.0875833
R12610 VSS.n2500 VSS.n2499 0.0875833
R12611 VSS.n2570 VSS.n2569 0.0875833
R12612 VSS.n2579 VSS.n2578 0.0875833
R12613 VSS.n2624 VSS.n2623 0.0875833
R12614 VSS.n2644 VSS.n2643 0.0875833
R12615 VSS.n2984 VSS.n2983 0.0875833
R12616 VSS.n2969 VSS.n2968 0.0875833
R12617 VSS.n2951 VSS.n2775 0.0875833
R12618 VSS.n2937 VSS.n2936 0.0875833
R12619 VSS.n2924 VSS.n2923 0.0875833
R12620 VSS.n2909 VSS.n2908 0.0875833
R12621 VSS.n2894 VSS.n2893 0.0875833
R12622 VSS.n3465 VSS.n3464 0.0875833
R12623 VSS.n3492 VSS.n3491 0.0875833
R12624 VSS.n3502 VSS.n3501 0.0875833
R12625 VSS.n2543 VSS.n2542 0.0875833
R12626 VSS.n2566 VSS.n2565 0.0875833
R12627 VSS.n2610 VSS.n2609 0.0875833
R12628 VSS.n2620 VSS.n2619 0.0875833
R12629 VSS.n2467 VSS.n2466 0.0875833
R12630 VSS.n2456 VSS.n2455 0.0875833
R12631 VSS.n2447 VSS.n2446 0.0875833
R12632 VSS.n1481 VSS.n1480 0.0875833
R12633 VSS.n2646 VSS.n2645 0.0875833
R12634 VSS.n2982 VSS.n2981 0.0875833
R12635 VSS.n2971 VSS.n2970 0.0875833
R12636 VSS.n2950 VSS.n2949 0.0875833
R12637 VSS.n2939 VSS.n2938 0.0875833
R12638 VSS.n2842 VSS.n2841 0.0875833
R12639 VSS.n2907 VSS.n2906 0.0875833
R12640 VSS.n2896 VSS.n2895 0.0875833
R12641 VSS.n3467 VSS.n3466 0.0875833
R12642 VSS.n3490 VSS.n3489 0.0875833
R12643 VSS.n3504 VSS.n3503 0.0875833
R12644 VSS.n2540 VSS.n2539 0.0875833
R12645 VSS.n2529 VSS.n1414 0.0875833
R12646 VSS.n2607 VSS.n2606 0.0875833
R12647 VSS.n2590 VSS.n1387 0.0875833
R12648 VSS.n2126 VSS.n2125 0.0875833
R12649 VSS.n2360 VSS.n2359 0.0875833
R12650 VSS.n2349 VSS.n2348 0.0875833
R12651 VSS.n1568 VSS.n1567 0.0875833
R12652 VSS.n1909 VSS.n1908 0.0875833
R12653 VSS.n1898 VSS.n1897 0.0875833
R12654 VSS.n1883 VSS.n1882 0.0875833
R12655 VSS.n1872 VSS.n1871 0.0875833
R12656 VSS.n1857 VSS.n1856 0.0875833
R12657 VSS.n1846 VSS.n1845 0.0875833
R12658 VSS.n1831 VSS.n1830 0.0875833
R12659 VSS.n1820 VSS.n1819 0.0875833
R12660 VSS.n1805 VSS.n1804 0.0875833
R12661 VSS.n1770 VSS.n947 0.0875833
R12662 VSS.n3543 VSS.n3542 0.0875833
R12663 VSS.n3789 VSS.n2 0.0875833
R12664 VSS.n575 VSS.n22 0.0875833
R12665 VSS.n584 VSS.n583 0.0875833
R12666 VSS.n607 VSS.n606 0.0875833
R12667 VSS.n635 VSS.n634 0.0875833
R12668 VSS.n658 VSS.n657 0.0875833
R12669 VSS.n685 VSS.n684 0.0875833
R12670 VSS.n708 VSS.n707 0.0875833
R12671 VSS.n735 VSS.n734 0.0875833
R12672 VSS.n758 VSS.n757 0.0875833
R12673 VSS.n785 VSS.n784 0.0875833
R12674 VSS.n808 VSS.n807 0.0875833
R12675 VSS.n832 VSS.n831 0.0875833
R12676 VSS.n855 VSS.n854 0.0875833
R12677 VSS.n899 VSS.n898 0.0875833
R12678 VSS VSS.n3014 0.0799444
R12679 VSS.n3034 VSS 0.0799444
R12680 VSS VSS.n3068 0.0799444
R12681 VSS.n3094 VSS 0.0799444
R12682 VSS VSS.n3116 0.0799444
R12683 VSS VSS.n1224 0.0799444
R12684 VSS VSS.n3141 0.0799444
R12685 VSS VSS.n3195 0.0799444
R12686 VSS.n1258 VSS 0.0799444
R12687 VSS.n3343 VSS 0.0768889
R12688 VSS.n3310 VSS 0.0768889
R12689 VSS.n3036 VSS 0.0768889
R12690 VSS.n3066 VSS 0.0768889
R12691 VSS.n3114 VSS 0.0768889
R12692 VSS.n3291 VSS 0.0768889
R12693 VSS.n3193 VSS 0.0768889
R12694 VSS VSS.n3255 0.0768889
R12695 VSS.n2693 VSS 0.0707778
R12696 VSS.n2677 VSS 0.0707778
R12697 VSS.n2708 VSS 0.0707778
R12698 VSS.n2724 VSS 0.0707778
R12699 VSS.n1216 VSS 0.0707778
R12700 VSS.n3299 VSS 0.0707778
R12701 VSS.n3412 VSS 0.0707778
R12702 VSS.n3186 VSS 0.0707778
R12703 VSS VSS.n3391 0.0707778
R12704 VSS.n1106 VSS.n1105 0.0661944
R12705 VSS.n1308 VSS.n1307 0.0661944
R12706 VSS.n1356 VSS.n1355 0.0661944
R12707 VSS VSS.n3036 0.0646667
R12708 VSS.n3066 VSS 0.0646667
R12709 VSS.n3114 VSS 0.0646667
R12710 VSS.n3291 VSS 0.0646667
R12711 VSS.n3193 VSS 0.0646667
R12712 VSS.n3255 VSS 0.0646667
R12713 VSS VSS.n2759 0.0539722
R12714 VSS VSS.n3448 0.0539722
R12715 VSS.n3150 VSS 0.0539722
R12716 VSS.n2693 VSS 0.0539722
R12717 VSS.n2677 VSS 0.0539722
R12718 VSS.n2708 VSS 0.0539722
R12719 VSS.n2724 VSS 0.0539722
R12720 VSS VSS.n1216 0.0539722
R12721 VSS VSS.n3299 0.0539722
R12722 VSS.n3412 VSS 0.0539722
R12723 VSS.n3186 VSS 0.0539722
R12724 VSS.n3391 VSS 0.0539722
R12725 VSS VSS.n3343 0.0463333
R12726 VSS VSS.n3310 0.0463333
R12727 VSS.n3014 VSS 0.0448056
R12728 VSS.n3034 VSS 0.0448056
R12729 VSS.n3068 VSS 0.0448056
R12730 VSS.n3094 VSS 0.0448056
R12731 VSS.n3116 VSS 0.0448056
R12732 VSS VSS.n1224 0.0448056
R12733 VSS.n3141 VSS 0.0448056
R12734 VSS.n3195 VSS 0.0448056
R12735 VSS VSS.n1258 0.0448056
R12736 VSS.n2757 VSS 0.0386944
R12737 VSS VSS.n2710 0.0386944
R12738 VSS.n3445 VSS 0.0386944
R12739 VSS.n1223 VSS 0.0386944
R12740 VSS.n3184 VSS 0.0386944
R12741 VSS VSS.n1053 0.0386944
R12742 VSS.n2760 VSS 0.0341111
R12743 VSS VSS.n2763 0.0341111
R12744 VSS.n3450 VSS 0.0341111
R12745 VSS.n3455 VSS 0.0341111
R12746 VSS VSS.n988 0.0341111
R12747 VSS VSS.n990 0.0341111
R12748 VSS VSS.n385 0.0341111
R12749 VSS VSS.n381 0.0341111
R12750 VSS.n870 VSS 0.0341111
R12751 VSS VSS.n939 0.0341111
R12752 VSS VSS.n935 0.0341111
R12753 VSS.n932 VSS 0.0341111
R12754 VSS.n2696 VSS 0.0341111
R12755 VSS.n2683 VSS 0.0341111
R12756 VSS VSS.n2756 0.0341111
R12757 VSS.n2704 VSS 0.0341111
R12758 VSS.n2711 VSS 0.0341111
R12759 VSS.n2713 VSS 0.0341111
R12760 VSS VSS.n2715 0.0341111
R12761 VSS.n2719 VSS 0.0341111
R12762 VSS.n2722 VSS 0.0341111
R12763 VSS VSS.n3444 0.0341111
R12764 VSS.n1022 VSS 0.0341111
R12765 VSS VSS.n1026 0.0341111
R12766 VSS.n1028 VSS 0.0341111
R12767 VSS VSS.n1030 0.0341111
R12768 VSS.n1034 VSS 0.0341111
R12769 VSS.n1036 VSS 0.0341111
R12770 VSS VSS.n3183 0.0341111
R12771 VSS.n3156 VSS 0.0341111
R12772 VSS.n3158 VSS 0.0341111
R12773 VSS.n3160 VSS 0.0341111
R12774 VSS VSS.n3162 0.0341111
R12775 VSS.n3373 VSS 0.0341111
R12776 VSS VSS.n1190 0.0341111
R12777 VSS VSS.n1192 0.0341111
R12778 VSS VSS.n1196 0.0341111
R12779 VSS VSS.n1198 0.0341111
R12780 VSS VSS.n1202 0.0341111
R12781 VSS VSS.n1204 0.0341111
R12782 VSS.n1206 VSS 0.0341111
R12783 VSS VSS.n1210 0.0341111
R12784 VSS VSS.n1212 0.0341111
R12785 VSS.n1217 VSS 0.0341111
R12786 VSS VSS.n1219 0.0341111
R12787 VSS.n3300 VSS 0.0341111
R12788 VSS VSS.n3302 0.0341111
R12789 VSS.n3305 VSS 0.0341111
R12790 VSS VSS.n3411 0.0341111
R12791 VSS VSS.n1043 0.0341111
R12792 VSS VSS.n1047 0.0341111
R12793 VSS VSS.n1049 0.0341111
R12794 VSS VSS.n1051 0.0341111
R12795 VSS VSS.n1081 0.0341111
R12796 VSS VSS.n2991 0.0341111
R12797 VSS.n3016 VSS 0.0341111
R12798 VSS VSS.n1348 0.0341111
R12799 VSS VSS.n3033 0.0341111
R12800 VSS VSS.n3025 0.0341111
R12801 VSS.n3070 VSS 0.0341111
R12802 VSS VSS.n1320 0.0341111
R12803 VSS VSS.n1314 0.0341111
R12804 VSS VSS.n3093 0.0341111
R12805 VSS VSS.n3085 0.0341111
R12806 VSS.n3118 VSS 0.0341111
R12807 VSS VSS.n1286 0.0341111
R12808 VSS.n3126 VSS 0.0341111
R12809 VSS VSS.n1280 0.0341111
R12810 VSS VSS.n1274 0.0341111
R12811 VSS.n3143 VSS 0.0341111
R12812 VSS VSS.n1268 0.0341111
R12813 VSS.n3197 VSS 0.0341111
R12814 VSS VSS.n1262 0.0341111
R12815 VSS VSS.n1257 0.0341111
R12816 VSS VSS.n1253 0.0341111
R12817 VSS.n3004 VSS 0.0341111
R12818 VSS.n3037 VSS 0.0341111
R12819 VSS.n1334 VSS 0.0341111
R12820 VSS VSS.n3065 0.0341111
R12821 VSS.n3045 VSS 0.0341111
R12822 VSS VSS.n3047 0.0341111
R12823 VSS.n1300 VSS 0.0341111
R12824 VSS VSS.n3113 0.0341111
R12825 VSS.n3106 VSS 0.0341111
R12826 VSS VSS.n3290 0.0341111
R12827 VSS.n1229 VSS 0.0341111
R12828 VSS VSS.n1231 0.0341111
R12829 VSS.n1237 VSS 0.0341111
R12830 VSS VSS.n1241 0.0341111
R12831 VSS.n1243 VSS 0.0341111
R12832 VSS VSS.n1245 0.0341111
R12833 VSS.n1247 VSS 0.0341111
R12834 VSS VSS.n1249 0.0341111
R12835 VSS.n2675 VSS 0.0188333
R12836 VSS VSS.n2760 0.0188333
R12837 VSS.n2957 VSS 0.0188333
R12838 VSS.n2763 VSS 0.0188333
R12839 VSS VSS.n2762 0.0188333
R12840 VSS.n3450 VSS 0.0188333
R12841 VSS VSS.n3449 0.0188333
R12842 VSS VSS.n3455 0.0188333
R12843 VSS.n3456 VSS 0.0188333
R12844 VSS VSS.n988 0.0188333
R12845 VSS.n1005 VSS 0.0188333
R12846 VSS.n990 VSS 0.0188333
R12847 VSS.n386 VSS 0.0188333
R12848 VSS.n385 VSS 0.0188333
R12849 VSS VSS.n384 0.0188333
R12850 VSS.n381 VSS 0.0188333
R12851 VSS VSS.n380 0.0188333
R12852 VSS VSS.n870 0.0188333
R12853 VSS.n940 VSS 0.0188333
R12854 VSS.n939 VSS 0.0188333
R12855 VSS VSS.n938 0.0188333
R12856 VSS.n935 VSS 0.0188333
R12857 VSS VSS.n930 0.0188333
R12858 VSS.n932 VSS 0.0188333
R12859 VSS VSS.n2687 0.0188333
R12860 VSS VSS.n2684 0.0188333
R12861 VSS.n2683 VSS 0.0188333
R12862 VSS VSS.n2682 0.0188333
R12863 VSS.n2756 VSS 0.0188333
R12864 VSS.n2751 VSS 0.0188333
R12865 VSS VSS.n2704 0.0188333
R12866 VSS.n2706 VSS 0.0188333
R12867 VSS VSS.n2711 0.0188333
R12868 VSS.n2744 VSS 0.0188333
R12869 VSS VSS.n2713 0.0188333
R12870 VSS.n2739 VSS 0.0188333
R12871 VSS VSS.n2715 0.0188333
R12872 VSS VSS.n2733 0.0188333
R12873 VSS.n2727 VSS 0.0188333
R12874 VSS.n2722 VSS 0.0188333
R12875 VSS VSS.n2721 0.0188333
R12876 VSS.n3444 VSS 0.0188333
R12877 VSS.n3439 VSS 0.0188333
R12878 VSS VSS.n1022 0.0188333
R12879 VSS.n1024 VSS 0.0188333
R12880 VSS VSS.n1026 0.0188333
R12881 VSS.n3432 VSS 0.0188333
R12882 VSS VSS.n1028 0.0188333
R12883 VSS.n3427 VSS 0.0188333
R12884 VSS VSS.n1030 0.0188333
R12885 VSS VSS.n3421 0.0188333
R12886 VSS.n3415 VSS 0.0188333
R12887 VSS VSS.n1036 0.0188333
R12888 VSS.n3152 VSS 0.0188333
R12889 VSS.n3183 VSS 0.0188333
R12890 VSS.n3178 VSS 0.0188333
R12891 VSS VSS.n3156 0.0188333
R12892 VSS.n3173 VSS 0.0188333
R12893 VSS VSS.n3158 0.0188333
R12894 VSS.n3169 VSS 0.0188333
R12895 VSS VSS.n3160 0.0188333
R12896 VSS.n3164 VSS 0.0188333
R12897 VSS.n3162 VSS 0.0188333
R12898 VSS.n1187 VSS 0.0188333
R12899 VSS.n3373 VSS 0.0188333
R12900 VSS VSS.n3372 0.0188333
R12901 VSS VSS.n1190 0.0188333
R12902 VSS.n3365 VSS 0.0188333
R12903 VSS VSS.n1192 0.0188333
R12904 VSS.n1194 VSS 0.0188333
R12905 VSS VSS.n1196 0.0188333
R12906 VSS.n3357 VSS 0.0188333
R12907 VSS VSS.n1198 0.0188333
R12908 VSS.n1200 VSS 0.0188333
R12909 VSS VSS.n1202 0.0188333
R12910 VSS.n3349 VSS 0.0188333
R12911 VSS VSS.n1204 0.0188333
R12912 VSS VSS.n3342 0.0188333
R12913 VSS VSS.n1206 0.0188333
R12914 VSS.n1208 VSS 0.0188333
R12915 VSS VSS.n1210 0.0188333
R12916 VSS.n3332 VSS 0.0188333
R12917 VSS VSS.n1212 0.0188333
R12918 VSS.n1214 VSS 0.0188333
R12919 VSS VSS.n1217 0.0188333
R12920 VSS.n3324 VSS 0.0188333
R12921 VSS VSS.n1219 0.0188333
R12922 VSS.n1221 VSS 0.0188333
R12923 VSS VSS.n3300 0.0188333
R12924 VSS.n3316 VSS 0.0188333
R12925 VSS VSS.n3302 0.0188333
R12926 VSS VSS.n3309 0.0188333
R12927 VSS.n3305 VSS 0.0188333
R12928 VSS VSS.n3304 0.0188333
R12929 VSS.n3411 VSS 0.0188333
R12930 VSS.n3405 VSS 0.0188333
R12931 VSS VSS.n1043 0.0188333
R12932 VSS.n1045 VSS 0.0188333
R12933 VSS VSS.n1047 0.0188333
R12934 VSS.n3397 VSS 0.0188333
R12935 VSS VSS.n1049 0.0188333
R12936 VSS.n3392 VSS 0.0188333
R12937 VSS VSS.n1051 0.0188333
R12938 VSS.n1082 VSS 0.0188333
R12939 VSS.n1081 VSS 0.0188333
R12940 VSS.n2993 VSS 0.0188333
R12941 VSS.n2991 VSS 0.0188333
R12942 VSS VSS.n2990 0.0188333
R12943 VSS.n3016 VSS 0.0188333
R12944 VSS VSS.n3015 0.0188333
R12945 VSS.n1348 VSS 0.0188333
R12946 VSS VSS.n1347 0.0188333
R12947 VSS.n3033 VSS 0.0188333
R12948 VSS.n3027 VSS 0.0188333
R12949 VSS.n3025 VSS 0.0188333
R12950 VSS VSS.n3024 0.0188333
R12951 VSS.n3070 VSS 0.0188333
R12952 VSS VSS.n3069 0.0188333
R12953 VSS.n1320 VSS 0.0188333
R12954 VSS VSS.n1316 0.0188333
R12955 VSS.n1314 VSS 0.0188333
R12956 VSS VSS.n1313 0.0188333
R12957 VSS.n3093 VSS 0.0188333
R12958 VSS.n3087 VSS 0.0188333
R12959 VSS.n3085 VSS 0.0188333
R12960 VSS VSS.n3084 0.0188333
R12961 VSS.n3118 VSS 0.0188333
R12962 VSS VSS.n3117 0.0188333
R12963 VSS.n1286 VSS 0.0188333
R12964 VSS VSS.n1285 0.0188333
R12965 VSS.n3126 VSS 0.0188333
R12966 VSS VSS.n3125 0.0188333
R12967 VSS.n1280 VSS 0.0188333
R12968 VSS VSS.n1276 0.0188333
R12969 VSS.n1274 VSS 0.0188333
R12970 VSS VSS.n1273 0.0188333
R12971 VSS.n3143 VSS 0.0188333
R12972 VSS VSS.n3142 0.0188333
R12973 VSS.n1268 VSS 0.0188333
R12974 VSS VSS.n1267 0.0188333
R12975 VSS.n3197 VSS 0.0188333
R12976 VSS VSS.n3196 0.0188333
R12977 VSS.n1262 VSS 0.0188333
R12978 VSS VSS.n1261 0.0188333
R12979 VSS.n1257 VSS 0.0188333
R12980 VSS VSS.n1256 0.0188333
R12981 VSS.n1253 VSS 0.0188333
R12982 VSS VSS.n1360 0.0188333
R12983 VSS.n3012 VSS.n3011 0.0188333
R12984 VSS.n3011 VSS 0.0188333
R12985 VSS.n3006 VSS 0.0188333
R12986 VSS.n3004 VSS 0.0188333
R12987 VSS VSS.n3003 0.0188333
R12988 VSS.n3037 VSS 0.0188333
R12989 VSS VSS.n1335 0.0188333
R12990 VSS.n1334 VSS 0.0188333
R12991 VSS VSS.n1333 0.0188333
R12992 VSS.n3065 VSS 0.0188333
R12993 VSS.n3060 VSS 0.0188333
R12994 VSS VSS.n3045 0.0188333
R12995 VSS.n3055 VSS 0.0188333
R12996 VSS VSS.n3047 0.0188333
R12997 VSS VSS.n3049 0.0188333
R12998 VSS.n3097 VSS.n3096 0.0188333
R12999 VSS.n3097 VSS 0.0188333
R13000 VSS VSS.n1301 0.0188333
R13001 VSS.n1300 VSS 0.0188333
R13002 VSS VSS.n1299 0.0188333
R13003 VSS.n3113 VSS 0.0188333
R13004 VSS.n3108 VSS 0.0188333
R13005 VSS.n3106 VSS 0.0188333
R13006 VSS VSS.n3105 0.0188333
R13007 VSS.n3290 VSS 0.0188333
R13008 VSS.n3285 VSS 0.0188333
R13009 VSS VSS.n1229 0.0188333
R13010 VSS.n3280 VSS 0.0188333
R13011 VSS VSS.n1231 0.0188333
R13012 VSS VSS.n3274 0.0188333
R13013 VSS.n3139 VSS.n1235 0.0188333
R13014 VSS VSS.n1235 0.0188333
R13015 VSS.n3268 VSS 0.0188333
R13016 VSS VSS.n1237 0.0188333
R13017 VSS.n1239 VSS 0.0188333
R13018 VSS VSS.n1241 0.0188333
R13019 VSS.n3261 VSS 0.0188333
R13020 VSS VSS.n1243 0.0188333
R13021 VSS.n3256 VSS 0.0188333
R13022 VSS VSS.n1245 0.0188333
R13023 VSS.n3251 VSS 0.0188333
R13024 VSS VSS.n1247 0.0188333
R13025 VSS.n3246 VSS 0.0188333
R13026 VSS.n1249 VSS 0.0188333
R13027 VSS.n3012 VSS 0.0157778
R13028 VSS.n3096 VSS 0.0157778
R13029 VSS.n3139 VSS 0.0157778
R13030 VSS.n2688 VSS 0.0111944
R13031 VSS.n2695 VSS 0.0111944
R13032 VSS.n2734 VSS 0.0111944
R13033 VSS VSS.n2726 0.0111944
R13034 VSS.n3422 VSS 0.0111944
R13035 VSS VSS.n3414 0.0111944
R13036 VSS.n3344 VSS 0.0111944
R13037 VSS.n3311 VSS 0.0111944
R13038 VSS.n1077 VSS 0.0111944
R13039 VSS.n1317 VSS 0.0111944
R13040 VSS.n1277 VSS 0.0111944
R13041 VSS.n1250 VSS 0.0111944
R13042 VSS.n1361 VSS 0.0111944
R13043 VSS.n3050 VSS 0.0111944
R13044 VSS.n3275 VSS 0.0111944
R13045 VSS.n2696 VSS.n2695 0.00813889
R13046 VSS.n2726 VSS.n2719 0.00813889
R13047 VSS.n3414 VSS.n1034 0.00813889
R13048 PH90.n0 PH90.t1 17.6089
R13049 PH90.n3 PH90.t18 17.6089
R13050 PH90.n6 PH90.t17 17.6089
R13051 PH90.n9 PH90.t30 17.6089
R13052 PH90.n12 PH90.t26 17.6089
R13053 PH90.n15 PH90.t8 17.6089
R13054 PH90.n18 PH90.t14 17.6089
R13055 PH90.n21 PH90.t24 17.6089
R13056 PH90.n46 PH90.t12 17.6089
R13057 PH90.n49 PH90.t4 17.6089
R13058 PH90.n52 PH90.t2 17.6089
R13059 PH90.n55 PH90.t19 17.6089
R13060 PH90.n58 PH90.t11 17.6089
R13061 PH90.n61 PH90.t29 17.6089
R13062 PH90.n64 PH90.t21 17.6089
R13063 PH90.n67 PH90.t7 17.6089
R13064 PH90.n23 PH90.t25 17.6089
R13065 PH90.n26 PH90.t16 17.6089
R13066 PH90.n29 PH90.t15 17.6089
R13067 PH90.n32 PH90.t28 17.6089
R13068 PH90.n35 PH90.t23 17.6089
R13069 PH90.n38 PH90.t5 17.6089
R13070 PH90.n41 PH90.t9 17.6089
R13071 PH90.n44 PH90.t20 17.6089
R13072 PH90.n70 PH90.t13 17.6089
R13073 PH90.n73 PH90.t27 17.6089
R13074 PH90.n76 PH90.t3 17.6089
R13075 PH90.n79 PH90.t0 17.6089
R13076 PH90.n85 PH90.t6 17.6089
R13077 PH90.n88 PH90.t22 17.6089
R13078 PH90.n91 PH90.t10 17.6089
R13079 PH90.n82 PH90.t31 17.6089
R13080 PH90 PH90.t39 17.5436
R13081 PH90 PH90.t77 17.5436
R13082 PH90 PH90.t36 17.5436
R13083 PH90 PH90.t60 17.5436
R13084 PH90.n22 PH90.t32 17.2136
R13085 PH90.n20 PH90.t79 17.2136
R13086 PH90.n19 PH90.t90 17.2136
R13087 PH90.n17 PH90.t54 17.2136
R13088 PH90.n16 PH90.t35 17.2136
R13089 PH90.n14 PH90.t87 17.2136
R13090 PH90.n13 PH90.t37 17.2136
R13091 PH90.n11 PH90.t66 17.2136
R13092 PH90.n10 PH90.t51 17.2136
R13093 PH90.n8 PH90.t52 17.2136
R13094 PH90.n7 PH90.t68 17.2136
R13095 PH90.n5 PH90.t41 17.2136
R13096 PH90.n4 PH90.t86 17.2136
R13097 PH90.n2 PH90.t65 17.2136
R13098 PH90.n1 PH90.t80 17.2136
R13099 PH90.n68 PH90.t72 17.2136
R13100 PH90.n66 PH90.t33 17.2136
R13101 PH90.n65 PH90.t56 17.2136
R13102 PH90.n63 PH90.t48 17.2136
R13103 PH90.n62 PH90.t75 17.2136
R13104 PH90.n60 PH90.t49 17.2136
R13105 PH90.n59 PH90.t76 17.2136
R13106 PH90.n57 PH90.t62 17.2136
R13107 PH90.n56 PH90.t83 17.2136
R13108 PH90.n54 PH90.t85 17.2136
R13109 PH90.n53 PH90.t93 17.2136
R13110 PH90.n51 PH90.t64 17.2136
R13111 PH90.n50 PH90.t46 17.2136
R13112 PH90.n48 PH90.t92 17.2136
R13113 PH90.n47 PH90.t38 17.2136
R13114 PH90.n45 PH90.t59 17.2136
R13115 PH90.n43 PH90.t61 17.2136
R13116 PH90.n42 PH90.t78 17.2136
R13117 PH90.n40 PH90.t71 17.2136
R13118 PH90.n39 PH90.t55 17.2136
R13119 PH90.n37 PH90.t73 17.2136
R13120 PH90.n36 PH90.t89 17.2136
R13121 PH90.n34 PH90.t45 17.2136
R13122 PH90.n33 PH90.t47 17.2136
R13123 PH90.n31 PH90.t95 17.2136
R13124 PH90.n30 PH90.t50 17.2136
R13125 PH90.n28 PH90.t82 17.2136
R13126 PH90.n27 PH90.t69 17.2136
R13127 PH90.n25 PH90.t42 17.2136
R13128 PH90.n24 PH90.t63 17.2136
R13129 PH90.n69 PH90.t53 17.2136
R13130 PH90.n90 PH90.t88 17.2136
R13131 PH90.n89 PH90.t34 17.2136
R13132 PH90.n87 PH90.t74 17.2136
R13133 PH90.n86 PH90.t57 17.2136
R13134 PH90.n84 PH90.t94 17.2136
R13135 PH90.n83 PH90.t58 17.2136
R13136 PH90.n81 PH90.t40 17.2136
R13137 PH90.n80 PH90.t67 17.2136
R13138 PH90.n78 PH90.t70 17.2136
R13139 PH90.n77 PH90.t84 17.2136
R13140 PH90.n75 PH90.t43 17.2136
R13141 PH90.n74 PH90.t44 17.2136
R13142 PH90.n72 PH90.t81 17.2136
R13143 PH90.n71 PH90.t91 17.2136
R13144 PH90 PH90.n22 5.49623
R13145 PH90 PH90.n68 5.12956
R13146 PH90 PH90.n45 5.12956
R13147 PH90.n69 PH90 5.12956
R13148 PH90.n17 PH90.n16 1.41675
R13149 PH90.n11 PH90.n10 1.41675
R13150 PH90.n5 PH90.n4 1.41675
R13151 PH90.n63 PH90.n62 1.41675
R13152 PH90.n57 PH90.n56 1.41675
R13153 PH90.n51 PH90.n50 1.41675
R13154 PH90.n40 PH90.n39 1.41675
R13155 PH90.n34 PH90.n33 1.41675
R13156 PH90.n28 PH90.n27 1.41675
R13157 PH90.n87 PH90.n86 1.41675
R13158 PH90.n81 PH90.n80 1.41675
R13159 PH90.n75 PH90.n74 1.41675
R13160 PH90.n20 PH90.n19 0.633
R13161 PH90.n14 PH90.n13 0.633
R13162 PH90.n8 PH90.n7 0.633
R13163 PH90.n2 PH90.n1 0.633
R13164 PH90.n66 PH90.n65 0.633
R13165 PH90.n60 PH90.n59 0.633
R13166 PH90.n54 PH90.n53 0.633
R13167 PH90.n48 PH90.n47 0.633
R13168 PH90.n43 PH90.n42 0.633
R13169 PH90.n37 PH90.n36 0.633
R13170 PH90.n31 PH90.n30 0.633
R13171 PH90.n25 PH90.n24 0.633
R13172 PH90.n90 PH90.n89 0.633
R13173 PH90.n84 PH90.n83 0.633
R13174 PH90.n78 PH90.n77 0.633
R13175 PH90.n72 PH90.n71 0.633
R13176 PH90.n19 PH90.n18 0.392375
R13177 PH90.n13 PH90.n12 0.392375
R13178 PH90.n7 PH90.n6 0.392375
R13179 PH90.n1 PH90.n0 0.392375
R13180 PH90.n65 PH90.n64 0.392375
R13181 PH90.n59 PH90.n58 0.392375
R13182 PH90.n53 PH90.n52 0.392375
R13183 PH90.n47 PH90.n46 0.392375
R13184 PH90.n42 PH90.n41 0.392375
R13185 PH90.n36 PH90.n35 0.392375
R13186 PH90.n30 PH90.n29 0.392375
R13187 PH90.n24 PH90.n23 0.392375
R13188 PH90.n89 PH90.n88 0.392375
R13189 PH90.n83 PH90.n82 0.392375
R13190 PH90.n77 PH90.n76 0.392375
R13191 PH90.n71 PH90.n70 0.392375
R13192 PH90.n21 PH90 0.358
R13193 PH90.n15 PH90 0.358
R13194 PH90.n9 PH90 0.358
R13195 PH90.n3 PH90 0.358
R13196 PH90.n67 PH90 0.358
R13197 PH90.n61 PH90 0.358
R13198 PH90.n55 PH90 0.358
R13199 PH90.n49 PH90 0.358
R13200 PH90.n44 PH90 0.358
R13201 PH90.n38 PH90 0.358
R13202 PH90.n32 PH90 0.358
R13203 PH90.n26 PH90 0.358
R13204 PH90.n91 PH90 0.358
R13205 PH90.n85 PH90 0.358
R13206 PH90.n79 PH90 0.358
R13207 PH90.n73 PH90 0.358
R13208 PH90 PH90.n17 0.3305
R13209 PH90.n16 PH90 0.3305
R13210 PH90 PH90.n11 0.3305
R13211 PH90 PH90.n5 0.3305
R13212 PH90.n4 PH90 0.3305
R13213 PH90 PH90.n63 0.3305
R13214 PH90.n62 PH90 0.3305
R13215 PH90 PH90.n57 0.3305
R13216 PH90 PH90.n51 0.3305
R13217 PH90.n50 PH90 0.3305
R13218 PH90 PH90.n40 0.3305
R13219 PH90.n39 PH90 0.3305
R13220 PH90 PH90.n34 0.3305
R13221 PH90 PH90.n28 0.3305
R13222 PH90.n27 PH90 0.3305
R13223 PH90 PH90.n87 0.3305
R13224 PH90.n86 PH90 0.3305
R13225 PH90 PH90.n81 0.3305
R13226 PH90 PH90.n75 0.3305
R13227 PH90.n74 PH90 0.3305
R13228 PH90.n22 PH90 0.113938
R13229 PH90.n10 PH90 0.113938
R13230 PH90.n68 PH90 0.113938
R13231 PH90.n56 PH90 0.113938
R13232 PH90.n45 PH90 0.113938
R13233 PH90.n33 PH90 0.113938
R13234 PH90 PH90.n69 0.113938
R13235 PH90.n80 PH90 0.113938
R13236 PH90 PH90.n21 0.062375
R13237 PH90.n18 PH90 0.062375
R13238 PH90 PH90.n15 0.062375
R13239 PH90.n12 PH90 0.062375
R13240 PH90 PH90.n9 0.062375
R13241 PH90.n6 PH90 0.062375
R13242 PH90 PH90.n3 0.062375
R13243 PH90.n0 PH90 0.062375
R13244 PH90 PH90.n67 0.062375
R13245 PH90.n64 PH90 0.062375
R13246 PH90 PH90.n61 0.062375
R13247 PH90.n58 PH90 0.062375
R13248 PH90 PH90.n55 0.062375
R13249 PH90.n52 PH90 0.062375
R13250 PH90 PH90.n49 0.062375
R13251 PH90.n46 PH90 0.062375
R13252 PH90 PH90.n44 0.062375
R13253 PH90.n41 PH90 0.062375
R13254 PH90 PH90.n38 0.062375
R13255 PH90.n35 PH90 0.062375
R13256 PH90 PH90.n32 0.062375
R13257 PH90.n29 PH90 0.062375
R13258 PH90 PH90.n26 0.062375
R13259 PH90.n23 PH90 0.062375
R13260 PH90 PH90.n91 0.062375
R13261 PH90.n88 PH90 0.062375
R13262 PH90 PH90.n85 0.062375
R13263 PH90.n82 PH90 0.062375
R13264 PH90 PH90.n79 0.062375
R13265 PH90.n76 PH90 0.062375
R13266 PH90 PH90.n73 0.062375
R13267 PH90.n70 PH90 0.062375
R13268 PH90 PH90.n20 0.034875
R13269 PH90 PH90.n14 0.034875
R13270 PH90 PH90.n8 0.034875
R13271 PH90 PH90.n2 0.034875
R13272 PH90 PH90.n66 0.034875
R13273 PH90 PH90.n60 0.034875
R13274 PH90 PH90.n54 0.034875
R13275 PH90 PH90.n48 0.034875
R13276 PH90 PH90.n43 0.034875
R13277 PH90 PH90.n37 0.034875
R13278 PH90 PH90.n31 0.034875
R13279 PH90 PH90.n25 0.034875
R13280 PH90 PH90.n90 0.034875
R13281 PH90 PH90.n84 0.034875
R13282 PH90 PH90.n78 0.034875
R13283 PH90 PH90.n72 0.034875
R13284 6to4_0.buff_PI_d32_2.inv_PI_d32_0.VIN.n71 6to4_0.buff_PI_d32_2.inv_PI_d32_0.VIN.t39 17.6089
R13285 6to4_0.buff_PI_d32_2.inv_PI_d32_0.VIN.n74 6to4_0.buff_PI_d32_2.inv_PI_d32_0.VIN.t9 17.6089
R13286 6to4_0.buff_PI_d32_2.inv_PI_d32_0.VIN.n77 6to4_0.buff_PI_d32_2.inv_PI_d32_0.VIN.t12 17.6089
R13287 6to4_0.buff_PI_d32_2.inv_PI_d32_0.VIN.n80 6to4_0.buff_PI_d32_2.inv_PI_d32_0.VIN.t24 17.6089
R13288 6to4_0.buff_PI_d32_2.inv_PI_d32_0.VIN.n83 6to4_0.buff_PI_d32_2.inv_PI_d32_0.VIN.t27 17.6089
R13289 6to4_0.buff_PI_d32_2.inv_PI_d32_0.VIN.n86 6to4_0.buff_PI_d32_2.inv_PI_d32_0.VIN.t42 17.6089
R13290 6to4_0.buff_PI_d32_2.inv_PI_d32_0.VIN.n89 6to4_0.buff_PI_d32_2.inv_PI_d32_0.VIN.t21 17.6089
R13291 6to4_0.buff_PI_d32_2.inv_PI_d32_0.VIN.n92 6to4_0.buff_PI_d32_2.inv_PI_d32_0.VIN.t33 17.6089
R13292 6to4_0.buff_PI_d32_2.inv_PI_d32_0.VIN.n97 6to4_0.buff_PI_d32_2.inv_PI_d32_0.VIN.t15 17.6089
R13293 6to4_0.buff_PI_d32_2.inv_PI_d32_0.VIN.n100 6to4_0.buff_PI_d32_2.inv_PI_d32_0.VIN.t6 17.6089
R13294 6to4_0.buff_PI_d32_2.inv_PI_d32_0.VIN.n103 6to4_0.buff_PI_d32_2.inv_PI_d32_0.VIN.t36 17.6089
R13295 6to4_0.buff_PI_d32_2.inv_PI_d32_0.VIN.n106 6to4_0.buff_PI_d32_2.inv_PI_d32_0.VIN.t18 17.6089
R13296 6to4_0.buff_PI_d32_2.inv_PI_d32_0.VIN.n109 6to4_0.buff_PI_d32_2.inv_PI_d32_0.VIN.t45 17.6089
R13297 6to4_0.buff_PI_d32_2.inv_PI_d32_0.VIN.n115 6to4_0.buff_PI_d32_2.inv_PI_d32_0.VIN.t3 17.6089
R13298 6to4_0.buff_PI_d32_2.inv_PI_d32_0.VIN.n118 6to4_0.buff_PI_d32_2.inv_PI_d32_0.VIN.t30 17.6089
R13299 6to4_0.buff_PI_d32_2.inv_PI_d32_0.VIN.n112 6to4_0.buff_PI_d32_2.inv_PI_d32_0.VIN.t0 17.6089
R13300 6to4_0.buff_PI_d32_2.inv_PI_d32_0.VIN 6to4_0.buff_PI_d32_2.inv_PI_d32_0.VIN.t40 17.5436
R13301 6to4_0.buff_PI_d32_2.inv_PI_d32_0.VIN 6to4_0.buff_PI_d32_2.inv_PI_d32_0.VIN.t16 17.5436
R13302 6to4_0.buff_PI_d32_2.inv_PI_d32_0.VIN.n93 6to4_0.buff_PI_d32_2.inv_PI_d32_0.VIN.t34 17.2136
R13303 6to4_0.buff_PI_d32_2.inv_PI_d32_0.VIN.n91 6to4_0.buff_PI_d32_2.inv_PI_d32_0.VIN.t35 17.2136
R13304 6to4_0.buff_PI_d32_2.inv_PI_d32_0.VIN.n90 6to4_0.buff_PI_d32_2.inv_PI_d32_0.VIN.t22 17.2136
R13305 6to4_0.buff_PI_d32_2.inv_PI_d32_0.VIN.n88 6to4_0.buff_PI_d32_2.inv_PI_d32_0.VIN.t23 17.2136
R13306 6to4_0.buff_PI_d32_2.inv_PI_d32_0.VIN.n87 6to4_0.buff_PI_d32_2.inv_PI_d32_0.VIN.t43 17.2136
R13307 6to4_0.buff_PI_d32_2.inv_PI_d32_0.VIN.n85 6to4_0.buff_PI_d32_2.inv_PI_d32_0.VIN.t44 17.2136
R13308 6to4_0.buff_PI_d32_2.inv_PI_d32_0.VIN.n84 6to4_0.buff_PI_d32_2.inv_PI_d32_0.VIN.t28 17.2136
R13309 6to4_0.buff_PI_d32_2.inv_PI_d32_0.VIN.n82 6to4_0.buff_PI_d32_2.inv_PI_d32_0.VIN.t29 17.2136
R13310 6to4_0.buff_PI_d32_2.inv_PI_d32_0.VIN.n81 6to4_0.buff_PI_d32_2.inv_PI_d32_0.VIN.t25 17.2136
R13311 6to4_0.buff_PI_d32_2.inv_PI_d32_0.VIN.n79 6to4_0.buff_PI_d32_2.inv_PI_d32_0.VIN.t26 17.2136
R13312 6to4_0.buff_PI_d32_2.inv_PI_d32_0.VIN.n78 6to4_0.buff_PI_d32_2.inv_PI_d32_0.VIN.t14 17.2136
R13313 6to4_0.buff_PI_d32_2.inv_PI_d32_0.VIN.n76 6to4_0.buff_PI_d32_2.inv_PI_d32_0.VIN.t13 17.2136
R13314 6to4_0.buff_PI_d32_2.inv_PI_d32_0.VIN.n75 6to4_0.buff_PI_d32_2.inv_PI_d32_0.VIN.t11 17.2136
R13315 6to4_0.buff_PI_d32_2.inv_PI_d32_0.VIN.n73 6to4_0.buff_PI_d32_2.inv_PI_d32_0.VIN.t10 17.2136
R13316 6to4_0.buff_PI_d32_2.inv_PI_d32_0.VIN.n72 6to4_0.buff_PI_d32_2.inv_PI_d32_0.VIN.t41 17.2136
R13317 6to4_0.buff_PI_d32_2.inv_PI_d32_0.VIN.n96 6to4_0.buff_PI_d32_2.inv_PI_d32_0.VIN.t32 17.2136
R13318 6to4_0.buff_PI_d32_2.inv_PI_d32_0.VIN.n117 6to4_0.buff_PI_d32_2.inv_PI_d32_0.VIN.t31 17.2136
R13319 6to4_0.buff_PI_d32_2.inv_PI_d32_0.VIN.n116 6to4_0.buff_PI_d32_2.inv_PI_d32_0.VIN.t4 17.2136
R13320 6to4_0.buff_PI_d32_2.inv_PI_d32_0.VIN.n114 6to4_0.buff_PI_d32_2.inv_PI_d32_0.VIN.t5 17.2136
R13321 6to4_0.buff_PI_d32_2.inv_PI_d32_0.VIN.n113 6to4_0.buff_PI_d32_2.inv_PI_d32_0.VIN.t1 17.2136
R13322 6to4_0.buff_PI_d32_2.inv_PI_d32_0.VIN.n111 6to4_0.buff_PI_d32_2.inv_PI_d32_0.VIN.t2 17.2136
R13323 6to4_0.buff_PI_d32_2.inv_PI_d32_0.VIN.n110 6to4_0.buff_PI_d32_2.inv_PI_d32_0.VIN.t47 17.2136
R13324 6to4_0.buff_PI_d32_2.inv_PI_d32_0.VIN.n108 6to4_0.buff_PI_d32_2.inv_PI_d32_0.VIN.t46 17.2136
R13325 6to4_0.buff_PI_d32_2.inv_PI_d32_0.VIN.n107 6to4_0.buff_PI_d32_2.inv_PI_d32_0.VIN.t19 17.2136
R13326 6to4_0.buff_PI_d32_2.inv_PI_d32_0.VIN.n105 6to4_0.buff_PI_d32_2.inv_PI_d32_0.VIN.t20 17.2136
R13327 6to4_0.buff_PI_d32_2.inv_PI_d32_0.VIN.n104 6to4_0.buff_PI_d32_2.inv_PI_d32_0.VIN.t38 17.2136
R13328 6to4_0.buff_PI_d32_2.inv_PI_d32_0.VIN.n102 6to4_0.buff_PI_d32_2.inv_PI_d32_0.VIN.t37 17.2136
R13329 6to4_0.buff_PI_d32_2.inv_PI_d32_0.VIN.n101 6to4_0.buff_PI_d32_2.inv_PI_d32_0.VIN.t7 17.2136
R13330 6to4_0.buff_PI_d32_2.inv_PI_d32_0.VIN.n99 6to4_0.buff_PI_d32_2.inv_PI_d32_0.VIN.t8 17.2136
R13331 6to4_0.buff_PI_d32_2.inv_PI_d32_0.VIN.n98 6to4_0.buff_PI_d32_2.inv_PI_d32_0.VIN.t17 17.2136
R13332 6to4_0.buff_PI_d32_2.inv_PI_d32_0.VIN.n0 6to4_0.buff_PI_d32_2.inv_PI_d32_0.VIN.t68 15.0005
R13333 6to4_0.buff_PI_d32_2.inv_PI_d32_0.VIN.n48 6to4_0.buff_PI_d32_2.inv_PI_d32_0.VIN.t65 15.0005
R13334 6to4_0.buff_PI_d32_2.inv_PI_d32_0.VIN.n41 6to4_0.buff_PI_d32_2.inv_PI_d32_0.VIN.t50 15.0005
R13335 6to4_0.buff_PI_d32_2.inv_PI_d32_0.VIN.n42 6to4_0.buff_PI_d32_2.inv_PI_d32_0.VIN.t61 15.0005
R13336 6to4_0.buff_PI_d32_2.inv_PI_d32_0.VIN.n54 6to4_0.buff_PI_d32_2.inv_PI_d32_0.VIN.t77 15.0005
R13337 6to4_0.buff_PI_d32_2.inv_PI_d32_0.VIN.n56 6to4_0.buff_PI_d32_2.inv_PI_d32_0.VIN.t53 15.0005
R13338 6to4_0.buff_PI_d32_2.inv_PI_d32_0.VIN.n44 6to4_0.buff_PI_d32_2.inv_PI_d32_0.VIN.t62 15.0005
R13339 6to4_0.buff_PI_d32_2.inv_PI_d32_0.VIN.n8 6to4_0.buff_PI_d32_2.inv_PI_d32_0.VIN.t72 15.0005
R13340 6to4_0.buff_PI_d32_2.inv_PI_d32_0.VIN.n46 6to4_0.buff_PI_d32_2.inv_PI_d32_0.VIN.t78 15.0005
R13341 6to4_0.buff_PI_d32_2.inv_PI_d32_0.VIN.n4 6to4_0.buff_PI_d32_2.inv_PI_d32_0.VIN.t51 15.0005
R13342 6to4_0.buff_PI_d32_2.inv_PI_d32_0.VIN.n2 6to4_0.buff_PI_d32_2.inv_PI_d32_0.VIN.t52 15.0005
R13343 6to4_0.buff_PI_d32_2.inv_PI_d32_0.VIN.n28 6to4_0.buff_PI_d32_2.inv_PI_d32_0.VIN.t56 15.0005
R13344 6to4_0.buff_PI_d32_2.inv_PI_d32_0.VIN.n26 6to4_0.buff_PI_d32_2.inv_PI_d32_0.VIN.t69 15.0005
R13345 6to4_0.buff_PI_d32_2.inv_PI_d32_0.VIN.n25 6to4_0.buff_PI_d32_2.inv_PI_d32_0.VIN.t60 15.0005
R13346 6to4_0.buff_PI_d32_2.inv_PI_d32_0.VIN.n13 6to4_0.buff_PI_d32_2.inv_PI_d32_0.VIN.t71 15.0005
R13347 6to4_0.buff_PI_d32_2.inv_PI_d32_0.VIN.n12 6to4_0.buff_PI_d32_2.inv_PI_d32_0.VIN.t75 15.0005
R13348 6to4_0.buff_PI_d32_2.inv_PI_d32_0.VIN.n36 6to4_0.buff_PI_d32_2.inv_PI_d32_0.VIN.t54 15.0005
R13349 6to4_0.buff_PI_d32_2.inv_PI_d32_0.VIN.n34 6to4_0.buff_PI_d32_2.inv_PI_d32_0.VIN.t59 15.0005
R13350 6to4_0.buff_PI_d32_2.inv_PI_d32_0.VIN.n18 6to4_0.buff_PI_d32_2.inv_PI_d32_0.VIN.t74 15.0005
R13351 6to4_0.buff_PI_d32_2.inv_PI_d32_0.VIN.n17 6to4_0.buff_PI_d32_2.inv_PI_d32_0.VIN.t49 15.0005
R13352 6to4_0.buff_PI_d32_2.inv_PI_d32_0.VIN.n10 6to4_0.buff_PI_d32_2.inv_PI_d32_0.VIN.t73 15.0005
R13353 6to4_0.buff_PI_d32_2.inv_PI_d32_0.VIN.n15 6to4_0.buff_PI_d32_2.inv_PI_d32_0.VIN.t63 15.0005
R13354 6to4_0.buff_PI_d32_2.inv_PI_d32_0.VIN.n23 6to4_0.buff_PI_d32_2.inv_PI_d32_0.VIN.t58 15.0005
R13355 6to4_0.buff_PI_d32_2.inv_PI_d32_0.VIN.n22 6to4_0.buff_PI_d32_2.inv_PI_d32_0.VIN.t76 15.0005
R13356 6to4_0.buff_PI_d32_2.inv_PI_d32_0.VIN.n6 6to4_0.buff_PI_d32_2.inv_PI_d32_0.VIN.t70 15.0005
R13357 6to4_0.buff_PI_d32_2.inv_PI_d32_0.VIN.n20 6to4_0.buff_PI_d32_2.inv_PI_d32_0.VIN.t64 15.0005
R13358 6to4_0.buff_PI_d32_2.inv_PI_d32_0.VIN.n64 6to4_0.buff_PI_d32_2.inv_PI_d32_0.VIN.t67 15.0005
R13359 6to4_0.buff_PI_d32_2.inv_PI_d32_0.VIN.n62 6to4_0.buff_PI_d32_2.inv_PI_d32_0.VIN.t48 15.0005
R13360 6to4_0.buff_PI_d32_2.inv_PI_d32_0.VIN.n69 6to4_0.buff_PI_d32_2.inv_PI_d32_0.VIN.t79 15.0005
R13361 6to4_0.buff_PI_d32_2.inv_PI_d32_0.VIN.n67 6to4_0.buff_PI_d32_2.inv_PI_d32_0.VIN.t55 15.0005
R13362 6to4_0.buff_PI_d32_2.inv_PI_d32_0.VIN.n38 6to4_0.buff_PI_d32_2.inv_PI_d32_0.VIN.t66 15.0005
R13363 6to4_0.buff_PI_d32_2.inv_PI_d32_0.VIN.n39 6to4_0.buff_PI_d32_2.inv_PI_d32_0.VIN.t57 15.0005
R13364 6to4_0.buff_PI_d32_2.inv_PI_d32_0.VIN.n43 6to4_0.buff_PI_d32_2.inv_PI_d32_0.VIN.n41 10.3469
R13365 6to4_0.buff_PI_d32_2.inv_PI_d32_0.VIN.n27 6to4_0.buff_PI_d32_2.inv_PI_d32_0.VIN.n25 10.3469
R13366 6to4_0.buff_PI_d32_2.inv_PI_d32_0.VIN.n14 6to4_0.buff_PI_d32_2.inv_PI_d32_0.VIN.n12 10.3469
R13367 6to4_0.buff_PI_d32_2.inv_PI_d32_0.VIN.n19 6to4_0.buff_PI_d32_2.inv_PI_d32_0.VIN.n17 10.3469
R13368 6to4_0.buff_PI_d32_2.inv_PI_d32_0.VIN.n24 6to4_0.buff_PI_d32_2.inv_PI_d32_0.VIN.n22 10.3469
R13369 6to4_0.buff_PI_d32_2.inv_PI_d32_0.VIN.n40 6to4_0.buff_PI_d32_2.inv_PI_d32_0.VIN.n38 10.3469
R13370 6to4_0.buff_PI_d32_2.inv_PI_d32_0.VIN.n43 6to4_0.buff_PI_d32_2.inv_PI_d32_0.VIN.n42 9.0005
R13371 6to4_0.buff_PI_d32_2.inv_PI_d32_0.VIN.n9 6to4_0.buff_PI_d32_2.inv_PI_d32_0.VIN.n8 9.0005
R13372 6to4_0.buff_PI_d32_2.inv_PI_d32_0.VIN.n45 6to4_0.buff_PI_d32_2.inv_PI_d32_0.VIN.n44 9.0005
R13373 6to4_0.buff_PI_d32_2.inv_PI_d32_0.VIN.n5 6to4_0.buff_PI_d32_2.inv_PI_d32_0.VIN.n4 9.0005
R13374 6to4_0.buff_PI_d32_2.inv_PI_d32_0.VIN.n47 6to4_0.buff_PI_d32_2.inv_PI_d32_0.VIN.n46 9.0005
R13375 6to4_0.buff_PI_d32_2.inv_PI_d32_0.VIN.n27 6to4_0.buff_PI_d32_2.inv_PI_d32_0.VIN.n26 9.0005
R13376 6to4_0.buff_PI_d32_2.inv_PI_d32_0.VIN.n35 6to4_0.buff_PI_d32_2.inv_PI_d32_0.VIN.n34 9.0005
R13377 6to4_0.buff_PI_d32_2.inv_PI_d32_0.VIN.n37 6to4_0.buff_PI_d32_2.inv_PI_d32_0.VIN.n36 9.0005
R13378 6to4_0.buff_PI_d32_2.inv_PI_d32_0.VIN.n14 6to4_0.buff_PI_d32_2.inv_PI_d32_0.VIN.n13 9.0005
R13379 6to4_0.buff_PI_d32_2.inv_PI_d32_0.VIN.n16 6to4_0.buff_PI_d32_2.inv_PI_d32_0.VIN.n15 9.0005
R13380 6to4_0.buff_PI_d32_2.inv_PI_d32_0.VIN.n11 6to4_0.buff_PI_d32_2.inv_PI_d32_0.VIN.n10 9.0005
R13381 6to4_0.buff_PI_d32_2.inv_PI_d32_0.VIN.n19 6to4_0.buff_PI_d32_2.inv_PI_d32_0.VIN.n18 9.0005
R13382 6to4_0.buff_PI_d32_2.inv_PI_d32_0.VIN.n21 6to4_0.buff_PI_d32_2.inv_PI_d32_0.VIN.n20 9.0005
R13383 6to4_0.buff_PI_d32_2.inv_PI_d32_0.VIN.n7 6to4_0.buff_PI_d32_2.inv_PI_d32_0.VIN.n6 9.0005
R13384 6to4_0.buff_PI_d32_2.inv_PI_d32_0.VIN.n24 6to4_0.buff_PI_d32_2.inv_PI_d32_0.VIN.n23 9.0005
R13385 6to4_0.buff_PI_d32_2.inv_PI_d32_0.VIN.n68 6to4_0.buff_PI_d32_2.inv_PI_d32_0.VIN.n67 9.0005
R13386 6to4_0.buff_PI_d32_2.inv_PI_d32_0.VIN.n70 6to4_0.buff_PI_d32_2.inv_PI_d32_0.VIN.n69 9.0005
R13387 6to4_0.buff_PI_d32_2.inv_PI_d32_0.VIN.n63 6to4_0.buff_PI_d32_2.inv_PI_d32_0.VIN.n62 9.0005
R13388 6to4_0.buff_PI_d32_2.inv_PI_d32_0.VIN.n65 6to4_0.buff_PI_d32_2.inv_PI_d32_0.VIN.n64 9.0005
R13389 6to4_0.buff_PI_d32_2.inv_PI_d32_0.VIN.n29 6to4_0.buff_PI_d32_2.inv_PI_d32_0.VIN.n28 9.0005
R13390 6to4_0.buff_PI_d32_2.inv_PI_d32_0.VIN.n3 6to4_0.buff_PI_d32_2.inv_PI_d32_0.VIN.n2 9.0005
R13391 6to4_0.buff_PI_d32_2.inv_PI_d32_0.VIN.n40 6to4_0.buff_PI_d32_2.inv_PI_d32_0.VIN.n39 9.0005
R13392 6to4_0.buff_PI_d32_2.inv_PI_d32_0.VIN.n57 6to4_0.buff_PI_d32_2.inv_PI_d32_0.VIN.n56 9.0005
R13393 6to4_0.buff_PI_d32_2.inv_PI_d32_0.VIN.n55 6to4_0.buff_PI_d32_2.inv_PI_d32_0.VIN.n54 9.0005
R13394 6to4_0.buff_PI_d32_2.inv_PI_d32_0.VIN.n49 6to4_0.buff_PI_d32_2.inv_PI_d32_0.VIN.n48 9.0005
R13395 6to4_0.buff_PI_d32_2.inv_PI_d32_0.VIN.n1 6to4_0.buff_PI_d32_2.inv_PI_d32_0.VIN.n0 9.0005
R13396 6to4_0.buff_PI_d32_2.inv_PI_d32_0.VIN.n94 6to4_0.buff_PI_d32_2.inv_PI_d32_0.VIN.n93 5.12956
R13397 6to4_0.buff_PI_d32_2.inv_PI_d32_0.VIN.n96 6to4_0.buff_PI_d32_2.inv_PI_d32_0.VIN 5.12956
R13398 6to4_0.buff_PI_d32_2.inv_PI_d32_0.VIN.n88 6to4_0.buff_PI_d32_2.inv_PI_d32_0.VIN.n87 1.41675
R13399 6to4_0.buff_PI_d32_2.inv_PI_d32_0.VIN.n82 6to4_0.buff_PI_d32_2.inv_PI_d32_0.VIN.n81 1.41675
R13400 6to4_0.buff_PI_d32_2.inv_PI_d32_0.VIN.n76 6to4_0.buff_PI_d32_2.inv_PI_d32_0.VIN.n75 1.41675
R13401 6to4_0.buff_PI_d32_2.inv_PI_d32_0.VIN.n114 6to4_0.buff_PI_d32_2.inv_PI_d32_0.VIN.n113 1.41675
R13402 6to4_0.buff_PI_d32_2.inv_PI_d32_0.VIN.n108 6to4_0.buff_PI_d32_2.inv_PI_d32_0.VIN.n107 1.41675
R13403 6to4_0.buff_PI_d32_2.inv_PI_d32_0.VIN.n102 6to4_0.buff_PI_d32_2.inv_PI_d32_0.VIN.n101 1.41675
R13404 6to4_0.buff_PI_d32_2.inv_PI_d32_0.VIN.n45 6to4_0.buff_PI_d32_2.inv_PI_d32_0.VIN.n9 1.3469
R13405 6to4_0.buff_PI_d32_2.inv_PI_d32_0.VIN.n47 6to4_0.buff_PI_d32_2.inv_PI_d32_0.VIN.n5 1.3469
R13406 6to4_0.buff_PI_d32_2.inv_PI_d32_0.VIN.n37 6to4_0.buff_PI_d32_2.inv_PI_d32_0.VIN.n35 1.3469
R13407 6to4_0.buff_PI_d32_2.inv_PI_d32_0.VIN.n16 6to4_0.buff_PI_d32_2.inv_PI_d32_0.VIN.n11 1.3469
R13408 6to4_0.buff_PI_d32_2.inv_PI_d32_0.VIN.n21 6to4_0.buff_PI_d32_2.inv_PI_d32_0.VIN.n7 1.3469
R13409 6to4_0.buff_PI_d32_2.inv_PI_d32_0.VIN.n70 6to4_0.buff_PI_d32_2.inv_PI_d32_0.VIN.n68 1.3469
R13410 6to4_0.buff_PI_d32_2.inv_PI_d32_0.VIN.n65 6to4_0.buff_PI_d32_2.inv_PI_d32_0.VIN.n63 1.3469
R13411 6to4_0.buff_PI_d32_2.inv_PI_d32_0.VIN.n29 6to4_0.buff_PI_d32_2.inv_PI_d32_0.VIN.n3 1.3469
R13412 6to4_0.buff_PI_d32_2.inv_PI_d32_0.VIN.n57 6to4_0.buff_PI_d32_2.inv_PI_d32_0.VIN.n55 1.3469
R13413 6to4_0.buff_PI_d32_2.inv_PI_d32_0.VIN.n49 6to4_0.buff_PI_d32_2.inv_PI_d32_0.VIN.n1 1.3469
R13414 6to4_0.buff_PI_d32_2.inv_PI_d32_0.VIN.n95 6to4_0.buff_PI_d32_2.inv_PI_d32_0.VIN 1.0984
R13415 6to4_0.buff_PI_d32_2.inv_PI_d32_0.VIN.n31 6to4_0.buff_PI_d32_2.inv_PI_d32_0.VIN.n30 0.67839
R13416 6to4_0.buff_PI_d32_2.inv_PI_d32_0.VIN.n32 6to4_0.buff_PI_d32_2.inv_PI_d32_0.VIN.n31 0.67839
R13417 6to4_0.buff_PI_d32_2.inv_PI_d32_0.VIN.n33 6to4_0.buff_PI_d32_2.inv_PI_d32_0.VIN.n32 0.67839
R13418 6to4_0.buff_PI_d32_2.inv_PI_d32_0.VIN.n61 6to4_0.buff_PI_d32_2.inv_PI_d32_0.VIN.n60 0.67839
R13419 6to4_0.buff_PI_d32_2.inv_PI_d32_0.VIN.n60 6to4_0.buff_PI_d32_2.inv_PI_d32_0.VIN.n59 0.67839
R13420 6to4_0.buff_PI_d32_2.inv_PI_d32_0.VIN.n59 6to4_0.buff_PI_d32_2.inv_PI_d32_0.VIN.n58 0.67839
R13421 6to4_0.buff_PI_d32_2.inv_PI_d32_0.VIN.n91 6to4_0.buff_PI_d32_2.inv_PI_d32_0.VIN.n90 0.633
R13422 6to4_0.buff_PI_d32_2.inv_PI_d32_0.VIN.n85 6to4_0.buff_PI_d32_2.inv_PI_d32_0.VIN.n84 0.633
R13423 6to4_0.buff_PI_d32_2.inv_PI_d32_0.VIN.n79 6to4_0.buff_PI_d32_2.inv_PI_d32_0.VIN.n78 0.633
R13424 6to4_0.buff_PI_d32_2.inv_PI_d32_0.VIN.n73 6to4_0.buff_PI_d32_2.inv_PI_d32_0.VIN.n72 0.633
R13425 6to4_0.buff_PI_d32_2.inv_PI_d32_0.VIN.n117 6to4_0.buff_PI_d32_2.inv_PI_d32_0.VIN.n116 0.633
R13426 6to4_0.buff_PI_d32_2.inv_PI_d32_0.VIN.n111 6to4_0.buff_PI_d32_2.inv_PI_d32_0.VIN.n110 0.633
R13427 6to4_0.buff_PI_d32_2.inv_PI_d32_0.VIN.n105 6to4_0.buff_PI_d32_2.inv_PI_d32_0.VIN.n104 0.633
R13428 6to4_0.buff_PI_d32_2.inv_PI_d32_0.VIN.n99 6to4_0.buff_PI_d32_2.inv_PI_d32_0.VIN.n98 0.633
R13429 6to4_0.buff_PI_d32_2.inv_PI_d32_0.VIN.n94 6to4_0.buff_PI_d32_2.inv_PI_d32_0.VIN.n70 0.587691
R13430 6to4_0.buff_PI_d32_2.inv_PI_d32_0.VIN.n52 6to4_0.buff_PI_d32_2.inv_PI_d32_0.VIN 0.586848
R13431 6to4_0.buff_PI_d32_2.inv_PI_d32_0.VIN.n95 6to4_0.buff_PI_d32_2.inv_PI_d32_0.VIN.n1 0.5835
R13432 6to4_0.buff_PI_d32_2.inv_PI_d32_0.VIN.n90 6to4_0.buff_PI_d32_2.inv_PI_d32_0.VIN.n89 0.392375
R13433 6to4_0.buff_PI_d32_2.inv_PI_d32_0.VIN.n84 6to4_0.buff_PI_d32_2.inv_PI_d32_0.VIN.n83 0.392375
R13434 6to4_0.buff_PI_d32_2.inv_PI_d32_0.VIN.n78 6to4_0.buff_PI_d32_2.inv_PI_d32_0.VIN.n77 0.392375
R13435 6to4_0.buff_PI_d32_2.inv_PI_d32_0.VIN.n72 6to4_0.buff_PI_d32_2.inv_PI_d32_0.VIN.n71 0.392375
R13436 6to4_0.buff_PI_d32_2.inv_PI_d32_0.VIN.n116 6to4_0.buff_PI_d32_2.inv_PI_d32_0.VIN.n115 0.392375
R13437 6to4_0.buff_PI_d32_2.inv_PI_d32_0.VIN.n110 6to4_0.buff_PI_d32_2.inv_PI_d32_0.VIN.n109 0.392375
R13438 6to4_0.buff_PI_d32_2.inv_PI_d32_0.VIN.n104 6to4_0.buff_PI_d32_2.inv_PI_d32_0.VIN.n103 0.392375
R13439 6to4_0.buff_PI_d32_2.inv_PI_d32_0.VIN.n98 6to4_0.buff_PI_d32_2.inv_PI_d32_0.VIN.n97 0.392375
R13440 6to4_0.buff_PI_d32_2.inv_PI_d32_0.VIN.n51 6to4_0.buff_PI_d32_2.inv_PI_d32_0.VIN.n45 0.3855
R13441 6to4_0.buff_PI_d32_2.inv_PI_d32_0.VIN.n50 6to4_0.buff_PI_d32_2.inv_PI_d32_0.VIN.n47 0.3855
R13442 6to4_0.buff_PI_d32_2.inv_PI_d32_0.VIN.n30 6to4_0.buff_PI_d32_2.inv_PI_d32_0.VIN.n27 0.3855
R13443 6to4_0.buff_PI_d32_2.inv_PI_d32_0.VIN.n58 6to4_0.buff_PI_d32_2.inv_PI_d32_0.VIN.n37 0.3855
R13444 6to4_0.buff_PI_d32_2.inv_PI_d32_0.VIN.n33 6to4_0.buff_PI_d32_2.inv_PI_d32_0.VIN.n14 0.3855
R13445 6to4_0.buff_PI_d32_2.inv_PI_d32_0.VIN.n59 6to4_0.buff_PI_d32_2.inv_PI_d32_0.VIN.n11 0.3855
R13446 6to4_0.buff_PI_d32_2.inv_PI_d32_0.VIN.n32 6to4_0.buff_PI_d32_2.inv_PI_d32_0.VIN.n19 0.3855
R13447 6to4_0.buff_PI_d32_2.inv_PI_d32_0.VIN.n60 6to4_0.buff_PI_d32_2.inv_PI_d32_0.VIN.n7 0.3855
R13448 6to4_0.buff_PI_d32_2.inv_PI_d32_0.VIN.n31 6to4_0.buff_PI_d32_2.inv_PI_d32_0.VIN.n24 0.3855
R13449 6to4_0.buff_PI_d32_2.inv_PI_d32_0.VIN.n66 6to4_0.buff_PI_d32_2.inv_PI_d32_0.VIN.n65 0.3855
R13450 6to4_0.buff_PI_d32_2.inv_PI_d32_0.VIN.n61 6to4_0.buff_PI_d32_2.inv_PI_d32_0.VIN.n3 0.3855
R13451 6to4_0.buff_PI_d32_2.inv_PI_d32_0.VIN.n55 6to4_0.buff_PI_d32_2.inv_PI_d32_0.VIN.n53 0.3855
R13452 6to4_0.buff_PI_d32_2.inv_PI_d32_0.VIN.n59 6to4_0.buff_PI_d32_2.inv_PI_d32_0.VIN.n9 0.3833
R13453 6to4_0.buff_PI_d32_2.inv_PI_d32_0.VIN.n60 6to4_0.buff_PI_d32_2.inv_PI_d32_0.VIN.n5 0.3833
R13454 6to4_0.buff_PI_d32_2.inv_PI_d32_0.VIN.n35 6to4_0.buff_PI_d32_2.inv_PI_d32_0.VIN.n33 0.3833
R13455 6to4_0.buff_PI_d32_2.inv_PI_d32_0.VIN.n32 6to4_0.buff_PI_d32_2.inv_PI_d32_0.VIN.n16 0.3833
R13456 6to4_0.buff_PI_d32_2.inv_PI_d32_0.VIN.n31 6to4_0.buff_PI_d32_2.inv_PI_d32_0.VIN.n21 0.3833
R13457 6to4_0.buff_PI_d32_2.inv_PI_d32_0.VIN.n68 6to4_0.buff_PI_d32_2.inv_PI_d32_0.VIN.n66 0.3833
R13458 6to4_0.buff_PI_d32_2.inv_PI_d32_0.VIN.n63 6to4_0.buff_PI_d32_2.inv_PI_d32_0.VIN.n61 0.3833
R13459 6to4_0.buff_PI_d32_2.inv_PI_d32_0.VIN.n30 6to4_0.buff_PI_d32_2.inv_PI_d32_0.VIN.n29 0.3833
R13460 6to4_0.buff_PI_d32_2.inv_PI_d32_0.VIN.n53 6to4_0.buff_PI_d32_2.inv_PI_d32_0.VIN.n40 0.3833
R13461 6to4_0.buff_PI_d32_2.inv_PI_d32_0.VIN.n58 6to4_0.buff_PI_d32_2.inv_PI_d32_0.VIN.n57 0.3833
R13462 6to4_0.buff_PI_d32_2.inv_PI_d32_0.VIN.n51 6to4_0.buff_PI_d32_2.inv_PI_d32_0.VIN.n43 0.3811
R13463 6to4_0.buff_PI_d32_2.inv_PI_d32_0.VIN.n50 6to4_0.buff_PI_d32_2.inv_PI_d32_0.VIN.n49 0.3811
R13464 6to4_0.buff_PI_d32_2.inv_PI_d32_0.VIN 6to4_0.buff_PI_d32_2.inv_PI_d32_0.VIN.n94 0.367167
R13465 6to4_0.buff_PI_d32_2.inv_PI_d32_0.VIN.n92 6to4_0.buff_PI_d32_2.inv_PI_d32_0.VIN 0.358
R13466 6to4_0.buff_PI_d32_2.inv_PI_d32_0.VIN.n86 6to4_0.buff_PI_d32_2.inv_PI_d32_0.VIN 0.358
R13467 6to4_0.buff_PI_d32_2.inv_PI_d32_0.VIN.n80 6to4_0.buff_PI_d32_2.inv_PI_d32_0.VIN 0.358
R13468 6to4_0.buff_PI_d32_2.inv_PI_d32_0.VIN.n74 6to4_0.buff_PI_d32_2.inv_PI_d32_0.VIN 0.358
R13469 6to4_0.buff_PI_d32_2.inv_PI_d32_0.VIN.n118 6to4_0.buff_PI_d32_2.inv_PI_d32_0.VIN 0.358
R13470 6to4_0.buff_PI_d32_2.inv_PI_d32_0.VIN.n112 6to4_0.buff_PI_d32_2.inv_PI_d32_0.VIN 0.358
R13471 6to4_0.buff_PI_d32_2.inv_PI_d32_0.VIN.n106 6to4_0.buff_PI_d32_2.inv_PI_d32_0.VIN 0.358
R13472 6to4_0.buff_PI_d32_2.inv_PI_d32_0.VIN.n100 6to4_0.buff_PI_d32_2.inv_PI_d32_0.VIN 0.358
R13473 6to4_0.buff_PI_d32_2.inv_PI_d32_0.VIN 6to4_0.buff_PI_d32_2.inv_PI_d32_0.VIN.n88 0.3305
R13474 6to4_0.buff_PI_d32_2.inv_PI_d32_0.VIN.n87 6to4_0.buff_PI_d32_2.inv_PI_d32_0.VIN 0.3305
R13475 6to4_0.buff_PI_d32_2.inv_PI_d32_0.VIN 6to4_0.buff_PI_d32_2.inv_PI_d32_0.VIN.n82 0.3305
R13476 6to4_0.buff_PI_d32_2.inv_PI_d32_0.VIN 6to4_0.buff_PI_d32_2.inv_PI_d32_0.VIN.n76 0.3305
R13477 6to4_0.buff_PI_d32_2.inv_PI_d32_0.VIN.n75 6to4_0.buff_PI_d32_2.inv_PI_d32_0.VIN 0.3305
R13478 6to4_0.buff_PI_d32_2.inv_PI_d32_0.VIN 6to4_0.buff_PI_d32_2.inv_PI_d32_0.VIN.n114 0.3305
R13479 6to4_0.buff_PI_d32_2.inv_PI_d32_0.VIN.n113 6to4_0.buff_PI_d32_2.inv_PI_d32_0.VIN 0.3305
R13480 6to4_0.buff_PI_d32_2.inv_PI_d32_0.VIN 6to4_0.buff_PI_d32_2.inv_PI_d32_0.VIN.n108 0.3305
R13481 6to4_0.buff_PI_d32_2.inv_PI_d32_0.VIN 6to4_0.buff_PI_d32_2.inv_PI_d32_0.VIN.n102 0.3305
R13482 6to4_0.buff_PI_d32_2.inv_PI_d32_0.VIN.n101 6to4_0.buff_PI_d32_2.inv_PI_d32_0.VIN 0.3305
R13483 6to4_0.buff_PI_d32_2.inv_PI_d32_0.VIN.n93 6to4_0.buff_PI_d32_2.inv_PI_d32_0.VIN 0.113938
R13484 6to4_0.buff_PI_d32_2.inv_PI_d32_0.VIN.n81 6to4_0.buff_PI_d32_2.inv_PI_d32_0.VIN 0.113938
R13485 6to4_0.buff_PI_d32_2.inv_PI_d32_0.VIN 6to4_0.buff_PI_d32_2.inv_PI_d32_0.VIN.n96 0.113938
R13486 6to4_0.buff_PI_d32_2.inv_PI_d32_0.VIN.n107 6to4_0.buff_PI_d32_2.inv_PI_d32_0.VIN 0.113938
R13487 6to4_0.buff_PI_d32_2.inv_PI_d32_0.VIN 6to4_0.buff_PI_d32_2.inv_PI_d32_0.VIN.n50 0.100935
R13488 6to4_0.buff_PI_d32_2.inv_PI_d32_0.VIN.n53 6to4_0.buff_PI_d32_2.inv_PI_d32_0.VIN 0.0662582
R13489 6to4_0.buff_PI_d32_2.inv_PI_d32_0.VIN.n50 6to4_0.buff_PI_d32_2.inv_PI_d32_0.VIN 0.066048
R13490 6to4_0.buff_PI_d32_2.inv_PI_d32_0.VIN 6to4_0.buff_PI_d32_2.inv_PI_d32_0.VIN.n92 0.062375
R13491 6to4_0.buff_PI_d32_2.inv_PI_d32_0.VIN.n89 6to4_0.buff_PI_d32_2.inv_PI_d32_0.VIN 0.062375
R13492 6to4_0.buff_PI_d32_2.inv_PI_d32_0.VIN 6to4_0.buff_PI_d32_2.inv_PI_d32_0.VIN.n86 0.062375
R13493 6to4_0.buff_PI_d32_2.inv_PI_d32_0.VIN.n83 6to4_0.buff_PI_d32_2.inv_PI_d32_0.VIN 0.062375
R13494 6to4_0.buff_PI_d32_2.inv_PI_d32_0.VIN 6to4_0.buff_PI_d32_2.inv_PI_d32_0.VIN.n80 0.062375
R13495 6to4_0.buff_PI_d32_2.inv_PI_d32_0.VIN.n77 6to4_0.buff_PI_d32_2.inv_PI_d32_0.VIN 0.062375
R13496 6to4_0.buff_PI_d32_2.inv_PI_d32_0.VIN 6to4_0.buff_PI_d32_2.inv_PI_d32_0.VIN.n74 0.062375
R13497 6to4_0.buff_PI_d32_2.inv_PI_d32_0.VIN.n71 6to4_0.buff_PI_d32_2.inv_PI_d32_0.VIN 0.062375
R13498 6to4_0.buff_PI_d32_2.inv_PI_d32_0.VIN 6to4_0.buff_PI_d32_2.inv_PI_d32_0.VIN.n118 0.062375
R13499 6to4_0.buff_PI_d32_2.inv_PI_d32_0.VIN.n115 6to4_0.buff_PI_d32_2.inv_PI_d32_0.VIN 0.062375
R13500 6to4_0.buff_PI_d32_2.inv_PI_d32_0.VIN 6to4_0.buff_PI_d32_2.inv_PI_d32_0.VIN.n112 0.062375
R13501 6to4_0.buff_PI_d32_2.inv_PI_d32_0.VIN.n109 6to4_0.buff_PI_d32_2.inv_PI_d32_0.VIN 0.062375
R13502 6to4_0.buff_PI_d32_2.inv_PI_d32_0.VIN 6to4_0.buff_PI_d32_2.inv_PI_d32_0.VIN.n106 0.062375
R13503 6to4_0.buff_PI_d32_2.inv_PI_d32_0.VIN.n103 6to4_0.buff_PI_d32_2.inv_PI_d32_0.VIN 0.062375
R13504 6to4_0.buff_PI_d32_2.inv_PI_d32_0.VIN 6to4_0.buff_PI_d32_2.inv_PI_d32_0.VIN.n100 0.062375
R13505 6to4_0.buff_PI_d32_2.inv_PI_d32_0.VIN.n97 6to4_0.buff_PI_d32_2.inv_PI_d32_0.VIN 0.062375
R13506 6to4_0.buff_PI_d32_2.inv_PI_d32_0.VIN.n66 6to4_0.buff_PI_d32_2.inv_PI_d32_0.VIN 0.059489
R13507 6to4_0.buff_PI_d32_2.inv_PI_d32_0.VIN.n48 6to4_0.buff_PI_d32_2.inv_PI_d32_0.VIN 0.0555
R13508 6to4_0.buff_PI_d32_2.inv_PI_d32_0.VIN.n42 6to4_0.buff_PI_d32_2.inv_PI_d32_0.VIN 0.0555
R13509 6to4_0.buff_PI_d32_2.inv_PI_d32_0.VIN.n56 6to4_0.buff_PI_d32_2.inv_PI_d32_0.VIN 0.0555
R13510 6to4_0.buff_PI_d32_2.inv_PI_d32_0.VIN.n8 6to4_0.buff_PI_d32_2.inv_PI_d32_0.VIN 0.0555
R13511 6to4_0.buff_PI_d32_2.inv_PI_d32_0.VIN.n4 6to4_0.buff_PI_d32_2.inv_PI_d32_0.VIN 0.0555
R13512 6to4_0.buff_PI_d32_2.inv_PI_d32_0.VIN.n28 6to4_0.buff_PI_d32_2.inv_PI_d32_0.VIN 0.0555
R13513 6to4_0.buff_PI_d32_2.inv_PI_d32_0.VIN.n25 6to4_0.buff_PI_d32_2.inv_PI_d32_0.VIN 0.0555
R13514 6to4_0.buff_PI_d32_2.inv_PI_d32_0.VIN.n12 6to4_0.buff_PI_d32_2.inv_PI_d32_0.VIN 0.0555
R13515 6to4_0.buff_PI_d32_2.inv_PI_d32_0.VIN.n34 6to4_0.buff_PI_d32_2.inv_PI_d32_0.VIN 0.0555
R13516 6to4_0.buff_PI_d32_2.inv_PI_d32_0.VIN.n17 6to4_0.buff_PI_d32_2.inv_PI_d32_0.VIN 0.0555
R13517 6to4_0.buff_PI_d32_2.inv_PI_d32_0.VIN.n15 6to4_0.buff_PI_d32_2.inv_PI_d32_0.VIN 0.0555
R13518 6to4_0.buff_PI_d32_2.inv_PI_d32_0.VIN.n22 6to4_0.buff_PI_d32_2.inv_PI_d32_0.VIN 0.0555
R13519 6to4_0.buff_PI_d32_2.inv_PI_d32_0.VIN.n20 6to4_0.buff_PI_d32_2.inv_PI_d32_0.VIN 0.0555
R13520 6to4_0.buff_PI_d32_2.inv_PI_d32_0.VIN.n62 6to4_0.buff_PI_d32_2.inv_PI_d32_0.VIN 0.0555
R13521 6to4_0.buff_PI_d32_2.inv_PI_d32_0.VIN.n67 6to4_0.buff_PI_d32_2.inv_PI_d32_0.VIN 0.0555
R13522 6to4_0.buff_PI_d32_2.inv_PI_d32_0.VIN.n39 6to4_0.buff_PI_d32_2.inv_PI_d32_0.VIN 0.0555
R13523 6to4_0.buff_PI_d32_2.inv_PI_d32_0.VIN 6to4_0.buff_PI_d32_2.inv_PI_d32_0.VIN.n52 0.0401484
R13524 6to4_0.buff_PI_d32_2.inv_PI_d32_0.VIN 6to4_0.buff_PI_d32_2.inv_PI_d32_0.VIN.n91 0.034875
R13525 6to4_0.buff_PI_d32_2.inv_PI_d32_0.VIN 6to4_0.buff_PI_d32_2.inv_PI_d32_0.VIN.n85 0.034875
R13526 6to4_0.buff_PI_d32_2.inv_PI_d32_0.VIN 6to4_0.buff_PI_d32_2.inv_PI_d32_0.VIN.n79 0.034875
R13527 6to4_0.buff_PI_d32_2.inv_PI_d32_0.VIN 6to4_0.buff_PI_d32_2.inv_PI_d32_0.VIN.n73 0.034875
R13528 6to4_0.buff_PI_d32_2.inv_PI_d32_0.VIN 6to4_0.buff_PI_d32_2.inv_PI_d32_0.VIN.n117 0.034875
R13529 6to4_0.buff_PI_d32_2.inv_PI_d32_0.VIN 6to4_0.buff_PI_d32_2.inv_PI_d32_0.VIN.n111 0.034875
R13530 6to4_0.buff_PI_d32_2.inv_PI_d32_0.VIN 6to4_0.buff_PI_d32_2.inv_PI_d32_0.VIN.n105 0.034875
R13531 6to4_0.buff_PI_d32_2.inv_PI_d32_0.VIN 6to4_0.buff_PI_d32_2.inv_PI_d32_0.VIN.n99 0.034875
R13532 6to4_0.buff_PI_d32_2.inv_PI_d32_0.VIN.n51 6to4_0.buff_PI_d32_2.inv_PI_d32_0.VIN 0.0196304
R13533 6to4_0.buff_PI_d32_2.inv_PI_d32_0.VIN.n52 6to4_0.buff_PI_d32_2.inv_PI_d32_0.VIN.n51 0.0196304
R13534 6to4_0.buff_PI_d32_2.inv_PI_d32_0.VIN.n0 6to4_0.buff_PI_d32_2.inv_PI_d32_0.VIN 0.0115
R13535 6to4_0.buff_PI_d32_2.inv_PI_d32_0.VIN.n41 6to4_0.buff_PI_d32_2.inv_PI_d32_0.VIN 0.0115
R13536 6to4_0.buff_PI_d32_2.inv_PI_d32_0.VIN.n54 6to4_0.buff_PI_d32_2.inv_PI_d32_0.VIN 0.0115
R13537 6to4_0.buff_PI_d32_2.inv_PI_d32_0.VIN.n44 6to4_0.buff_PI_d32_2.inv_PI_d32_0.VIN 0.0115
R13538 6to4_0.buff_PI_d32_2.inv_PI_d32_0.VIN.n46 6to4_0.buff_PI_d32_2.inv_PI_d32_0.VIN 0.0115
R13539 6to4_0.buff_PI_d32_2.inv_PI_d32_0.VIN.n2 6to4_0.buff_PI_d32_2.inv_PI_d32_0.VIN 0.0115
R13540 6to4_0.buff_PI_d32_2.inv_PI_d32_0.VIN.n26 6to4_0.buff_PI_d32_2.inv_PI_d32_0.VIN 0.0115
R13541 6to4_0.buff_PI_d32_2.inv_PI_d32_0.VIN.n13 6to4_0.buff_PI_d32_2.inv_PI_d32_0.VIN 0.0115
R13542 6to4_0.buff_PI_d32_2.inv_PI_d32_0.VIN.n36 6to4_0.buff_PI_d32_2.inv_PI_d32_0.VIN 0.0115
R13543 6to4_0.buff_PI_d32_2.inv_PI_d32_0.VIN.n18 6to4_0.buff_PI_d32_2.inv_PI_d32_0.VIN 0.0115
R13544 6to4_0.buff_PI_d32_2.inv_PI_d32_0.VIN.n10 6to4_0.buff_PI_d32_2.inv_PI_d32_0.VIN 0.0115
R13545 6to4_0.buff_PI_d32_2.inv_PI_d32_0.VIN.n23 6to4_0.buff_PI_d32_2.inv_PI_d32_0.VIN 0.0115
R13546 6to4_0.buff_PI_d32_2.inv_PI_d32_0.VIN.n6 6to4_0.buff_PI_d32_2.inv_PI_d32_0.VIN 0.0115
R13547 6to4_0.buff_PI_d32_2.inv_PI_d32_0.VIN.n64 6to4_0.buff_PI_d32_2.inv_PI_d32_0.VIN 0.0115
R13548 6to4_0.buff_PI_d32_2.inv_PI_d32_0.VIN.n69 6to4_0.buff_PI_d32_2.inv_PI_d32_0.VIN 0.0115
R13549 6to4_0.buff_PI_d32_2.inv_PI_d32_0.VIN.n38 6to4_0.buff_PI_d32_2.inv_PI_d32_0.VIN 0.0115
R13550 6to4_0.buff_PI_d32_2.inv_PI_d32_0.VIN 6to4_0.buff_PI_d32_2.inv_PI_d32_0.VIN.n95 0.00469048
R13551 PH270.n46 PH270.t21 17.6089
R13552 PH270.n49 PH270.t9 17.6089
R13553 PH270.n52 PH270.t13 17.6089
R13554 PH270.n55 PH270.t11 17.6089
R13555 PH270.n58 PH270.t10 17.6089
R13556 PH270.n61 PH270.t17 17.6089
R13557 PH270.n64 PH270.t0 17.6089
R13558 PH270.n67 PH270.t20 17.6089
R13559 PH270.n23 PH270.t4 17.6089
R13560 PH270.n26 PH270.t23 17.6089
R13561 PH270.n29 PH270.t24 17.6089
R13562 PH270.n32 PH270.t14 17.6089
R13563 PH270.n35 PH270.t3 17.6089
R13564 PH270.n38 PH270.t26 17.6089
R13565 PH270.n41 PH270.t16 17.6089
R13566 PH270.n44 PH270.t28 17.6089
R13567 PH270.n0 PH270.t19 17.6089
R13568 PH270.n3 PH270.t8 17.6089
R13569 PH270.n6 PH270.t6 17.6089
R13570 PH270.n9 PH270.t25 17.6089
R13571 PH270.n12 PH270.t18 17.6089
R13572 PH270.n15 PH270.t30 17.6089
R13573 PH270.n18 PH270.t1 17.6089
R13574 PH270.n21 PH270.t15 17.6089
R13575 PH270.n70 PH270.t12 17.6089
R13576 PH270.n73 PH270.t27 17.6089
R13577 PH270.n76 PH270.t2 17.6089
R13578 PH270.n82 PH270.t29 17.6089
R13579 PH270.n85 PH270.t5 17.6089
R13580 PH270.n88 PH270.t22 17.6089
R13581 PH270.n91 PH270.t7 17.6089
R13582 PH270.n79 PH270.t31 17.6089
R13583 PH270 PH270.t52 17.5436
R13584 PH270 PH270.t70 17.5436
R13585 PH270 PH270.t81 17.5436
R13586 PH270 PH270.t32 17.5436
R13587 PH270.n68 PH270.t46 17.2136
R13588 PH270.n66 PH270.t83 17.2136
R13589 PH270.n65 PH270.t92 17.2136
R13590 PH270.n63 PH270.t65 17.2136
R13591 PH270.n62 PH270.t50 17.2136
R13592 PH270.n60 PH270.t90 17.2136
R13593 PH270.n59 PH270.t51 17.2136
R13594 PH270.n57 PH270.t34 17.2136
R13595 PH270.n56 PH270.t60 17.2136
R13596 PH270.n54 PH270.t63 17.2136
R13597 PH270.n53 PH270.t77 17.2136
R13598 PH270.n51 PH270.t36 17.2136
R13599 PH270.n50 PH270.t38 17.2136
R13600 PH270.n48 PH270.t75 17.2136
R13601 PH270.n47 PH270.t85 17.2136
R13602 PH270.n45 PH270.t64 17.2136
R13603 PH270.n43 PH270.t91 17.2136
R13604 PH270.n42 PH270.t49 17.2136
R13605 PH270.n40 PH270.t40 17.2136
R13606 PH270.n39 PH270.t66 17.2136
R13607 PH270.n37 PH270.t42 17.2136
R13608 PH270.n36 PH270.t68 17.2136
R13609 PH270.n34 PH270.t53 17.2136
R13610 PH270.n33 PH270.t76 17.2136
R13611 PH270.n31 PH270.t78 17.2136
R13612 PH270.n30 PH270.t89 17.2136
R13613 PH270.n28 PH270.t57 17.2136
R13614 PH270.n27 PH270.t39 17.2136
R13615 PH270.n25 PH270.t87 17.2136
R13616 PH270.n24 PH270.t95 17.2136
R13617 PH270.n22 PH270.t41 17.2136
R13618 PH270.n20 PH270.t43 17.2136
R13619 PH270.n19 PH270.t61 17.2136
R13620 PH270.n17 PH270.t55 17.2136
R13621 PH270.n16 PH270.t37 17.2136
R13622 PH270.n14 PH270.t56 17.2136
R13623 PH270.n13 PH270.t79 17.2136
R13624 PH270.n11 PH270.t69 17.2136
R13625 PH270.n10 PH270.t86 17.2136
R13626 PH270.n8 PH270.t88 17.2136
R13627 PH270.n7 PH270.t33 17.2136
R13628 PH270.n5 PH270.t72 17.2136
R13629 PH270.n4 PH270.t54 17.2136
R13630 PH270.n2 PH270.t93 17.2136
R13631 PH270.n1 PH270.t48 17.2136
R13632 PH270.n69 PH270.t71 17.2136
R13633 PH270.n90 PH270.t73 17.2136
R13634 PH270.n89 PH270.t84 17.2136
R13635 PH270.n87 PH270.t47 17.2136
R13636 PH270.n86 PH270.t67 17.2136
R13637 PH270.n84 PH270.t82 17.2136
R13638 PH270.n83 PH270.t94 17.2136
R13639 PH270.n81 PH270.t59 17.2136
R13640 PH270.n80 PH270.t44 17.2136
R13641 PH270.n78 PH270.t45 17.2136
R13642 PH270.n77 PH270.t62 17.2136
R13643 PH270.n75 PH270.t35 17.2136
R13644 PH270.n74 PH270.t80 17.2136
R13645 PH270.n72 PH270.t58 17.2136
R13646 PH270.n71 PH270.t74 17.2136
R13647 PH270.n69 PH270 5.34328
R13648 PH270 PH270.n68 5.12956
R13649 PH270 PH270.n45 5.12956
R13650 PH270 PH270.n22 5.12956
R13651 PH270.n63 PH270.n62 1.41675
R13652 PH270.n57 PH270.n56 1.41675
R13653 PH270.n51 PH270.n50 1.41675
R13654 PH270.n40 PH270.n39 1.41675
R13655 PH270.n34 PH270.n33 1.41675
R13656 PH270.n28 PH270.n27 1.41675
R13657 PH270.n17 PH270.n16 1.41675
R13658 PH270.n11 PH270.n10 1.41675
R13659 PH270.n5 PH270.n4 1.41675
R13660 PH270.n87 PH270.n86 1.41675
R13661 PH270.n81 PH270.n80 1.41675
R13662 PH270.n75 PH270.n74 1.41675
R13663 PH270.n66 PH270.n65 0.633
R13664 PH270.n60 PH270.n59 0.633
R13665 PH270.n54 PH270.n53 0.633
R13666 PH270.n48 PH270.n47 0.633
R13667 PH270.n43 PH270.n42 0.633
R13668 PH270.n37 PH270.n36 0.633
R13669 PH270.n31 PH270.n30 0.633
R13670 PH270.n25 PH270.n24 0.633
R13671 PH270.n20 PH270.n19 0.633
R13672 PH270.n14 PH270.n13 0.633
R13673 PH270.n8 PH270.n7 0.633
R13674 PH270.n2 PH270.n1 0.633
R13675 PH270.n90 PH270.n89 0.633
R13676 PH270.n84 PH270.n83 0.633
R13677 PH270.n78 PH270.n77 0.633
R13678 PH270.n72 PH270.n71 0.633
R13679 PH270.n65 PH270.n64 0.392375
R13680 PH270.n59 PH270.n58 0.392375
R13681 PH270.n53 PH270.n52 0.392375
R13682 PH270.n47 PH270.n46 0.392375
R13683 PH270.n42 PH270.n41 0.392375
R13684 PH270.n36 PH270.n35 0.392375
R13685 PH270.n30 PH270.n29 0.392375
R13686 PH270.n24 PH270.n23 0.392375
R13687 PH270.n19 PH270.n18 0.392375
R13688 PH270.n13 PH270.n12 0.392375
R13689 PH270.n7 PH270.n6 0.392375
R13690 PH270.n1 PH270.n0 0.392375
R13691 PH270.n89 PH270.n88 0.392375
R13692 PH270.n83 PH270.n82 0.392375
R13693 PH270.n77 PH270.n76 0.392375
R13694 PH270.n71 PH270.n70 0.392375
R13695 PH270.n67 PH270 0.358
R13696 PH270.n61 PH270 0.358
R13697 PH270.n55 PH270 0.358
R13698 PH270.n49 PH270 0.358
R13699 PH270.n44 PH270 0.358
R13700 PH270.n38 PH270 0.358
R13701 PH270.n32 PH270 0.358
R13702 PH270.n26 PH270 0.358
R13703 PH270.n21 PH270 0.358
R13704 PH270.n15 PH270 0.358
R13705 PH270.n9 PH270 0.358
R13706 PH270.n3 PH270 0.358
R13707 PH270.n91 PH270 0.358
R13708 PH270.n85 PH270 0.358
R13709 PH270.n79 PH270 0.358
R13710 PH270.n73 PH270 0.358
R13711 PH270 PH270.n63 0.3305
R13712 PH270.n62 PH270 0.3305
R13713 PH270 PH270.n57 0.3305
R13714 PH270 PH270.n51 0.3305
R13715 PH270.n50 PH270 0.3305
R13716 PH270 PH270.n40 0.3305
R13717 PH270.n39 PH270 0.3305
R13718 PH270 PH270.n34 0.3305
R13719 PH270 PH270.n28 0.3305
R13720 PH270.n27 PH270 0.3305
R13721 PH270 PH270.n17 0.3305
R13722 PH270.n16 PH270 0.3305
R13723 PH270 PH270.n11 0.3305
R13724 PH270 PH270.n5 0.3305
R13725 PH270.n4 PH270 0.3305
R13726 PH270 PH270.n87 0.3305
R13727 PH270.n86 PH270 0.3305
R13728 PH270 PH270.n81 0.3305
R13729 PH270 PH270.n75 0.3305
R13730 PH270.n74 PH270 0.3305
R13731 PH270.n68 PH270 0.113938
R13732 PH270.n56 PH270 0.113938
R13733 PH270.n45 PH270 0.113938
R13734 PH270.n33 PH270 0.113938
R13735 PH270.n22 PH270 0.113938
R13736 PH270.n10 PH270 0.113938
R13737 PH270 PH270.n69 0.113938
R13738 PH270.n80 PH270 0.113938
R13739 PH270 PH270.n67 0.062375
R13740 PH270.n64 PH270 0.062375
R13741 PH270 PH270.n61 0.062375
R13742 PH270.n58 PH270 0.062375
R13743 PH270 PH270.n55 0.062375
R13744 PH270.n52 PH270 0.062375
R13745 PH270 PH270.n49 0.062375
R13746 PH270.n46 PH270 0.062375
R13747 PH270 PH270.n44 0.062375
R13748 PH270.n41 PH270 0.062375
R13749 PH270 PH270.n38 0.062375
R13750 PH270.n35 PH270 0.062375
R13751 PH270 PH270.n32 0.062375
R13752 PH270.n29 PH270 0.062375
R13753 PH270 PH270.n26 0.062375
R13754 PH270.n23 PH270 0.062375
R13755 PH270 PH270.n21 0.062375
R13756 PH270.n18 PH270 0.062375
R13757 PH270 PH270.n15 0.062375
R13758 PH270.n12 PH270 0.062375
R13759 PH270 PH270.n9 0.062375
R13760 PH270.n6 PH270 0.062375
R13761 PH270 PH270.n3 0.062375
R13762 PH270.n0 PH270 0.062375
R13763 PH270 PH270.n91 0.062375
R13764 PH270.n88 PH270 0.062375
R13765 PH270 PH270.n85 0.062375
R13766 PH270.n82 PH270 0.062375
R13767 PH270 PH270.n79 0.062375
R13768 PH270.n76 PH270 0.062375
R13769 PH270 PH270.n73 0.062375
R13770 PH270.n70 PH270 0.062375
R13771 PH270 PH270.n66 0.034875
R13772 PH270 PH270.n60 0.034875
R13773 PH270 PH270.n54 0.034875
R13774 PH270 PH270.n48 0.034875
R13775 PH270 PH270.n43 0.034875
R13776 PH270 PH270.n37 0.034875
R13777 PH270 PH270.n31 0.034875
R13778 PH270 PH270.n25 0.034875
R13779 PH270 PH270.n20 0.034875
R13780 PH270 PH270.n14 0.034875
R13781 PH270 PH270.n8 0.034875
R13782 PH270 PH270.n2 0.034875
R13783 PH270 PH270.n90 0.034875
R13784 PH270 PH270.n84 0.034875
R13785 PH270 PH270.n78 0.034875
R13786 PH270 PH270.n72 0.034875
R13787 6to4_0.buff_PI_d32_3.buff_PI_d16$1_0.inv_PI_d4$1_0.VOUT.n19 6to4_0.buff_PI_d32_3.buff_PI_d16$1_0.inv_PI_d4$1_0.VOUT.t1 17.6089
R13788 6to4_0.buff_PI_d32_3.buff_PI_d16$1_0.inv_PI_d4$1_0.VOUT.n22 6to4_0.buff_PI_d32_3.buff_PI_d16$1_0.inv_PI_d4$1_0.VOUT.t0 17.6089
R13789 6to4_0.buff_PI_d32_3.buff_PI_d16$1_0.inv_PI_d4$1_0.VOUT.n25 6to4_0.buff_PI_d32_3.buff_PI_d16$1_0.inv_PI_d4$1_0.VOUT.t2 17.6089
R13790 6to4_0.buff_PI_d32_3.buff_PI_d16$1_0.inv_PI_d4$1_0.VOUT.n16 6to4_0.buff_PI_d32_3.buff_PI_d16$1_0.inv_PI_d4$1_0.VOUT.t3 17.6089
R13791 6to4_0.buff_PI_d32_3.buff_PI_d16$1_0.inv_PI_d4$1_0.VOUT 6to4_0.buff_PI_d32_3.buff_PI_d16$1_0.inv_PI_d4$1_0.VOUT.t9 17.5436
R13792 6to4_0.buff_PI_d32_3.buff_PI_d16$1_0.inv_PI_d4$1_0.VOUT.n15 6to4_0.buff_PI_d32_3.buff_PI_d16$1_0.inv_PI_d4$1_0.VOUT.t5 17.2136
R13793 6to4_0.buff_PI_d32_3.buff_PI_d16$1_0.inv_PI_d4$1_0.VOUT.n24 6to4_0.buff_PI_d32_3.buff_PI_d16$1_0.inv_PI_d4$1_0.VOUT.t8 17.2136
R13794 6to4_0.buff_PI_d32_3.buff_PI_d16$1_0.inv_PI_d4$1_0.VOUT.n23 6to4_0.buff_PI_d32_3.buff_PI_d16$1_0.inv_PI_d4$1_0.VOUT.t4 17.2136
R13795 6to4_0.buff_PI_d32_3.buff_PI_d16$1_0.inv_PI_d4$1_0.VOUT.n21 6to4_0.buff_PI_d32_3.buff_PI_d16$1_0.inv_PI_d4$1_0.VOUT.t7 17.2136
R13796 6to4_0.buff_PI_d32_3.buff_PI_d16$1_0.inv_PI_d4$1_0.VOUT.n20 6to4_0.buff_PI_d32_3.buff_PI_d16$1_0.inv_PI_d4$1_0.VOUT.t10 17.2136
R13797 6to4_0.buff_PI_d32_3.buff_PI_d16$1_0.inv_PI_d4$1_0.VOUT.n18 6to4_0.buff_PI_d32_3.buff_PI_d16$1_0.inv_PI_d4$1_0.VOUT.t6 17.2136
R13798 6to4_0.buff_PI_d32_3.buff_PI_d16$1_0.inv_PI_d4$1_0.VOUT.n17 6to4_0.buff_PI_d32_3.buff_PI_d16$1_0.inv_PI_d4$1_0.VOUT.t11 17.2136
R13799 6to4_0.buff_PI_d32_3.buff_PI_d16$1_0.inv_PI_d4$1_0.VOUT.n0 6to4_0.buff_PI_d32_3.buff_PI_d16$1_0.inv_PI_d4$1_0.VOUT.t12 15.0005
R13800 6to4_0.buff_PI_d32_3.buff_PI_d16$1_0.inv_PI_d4$1_0.VOUT.n1 6to4_0.buff_PI_d32_3.buff_PI_d16$1_0.inv_PI_d4$1_0.VOUT.t17 15.0005
R13801 6to4_0.buff_PI_d32_3.buff_PI_d16$1_0.inv_PI_d4$1_0.VOUT.n3 6to4_0.buff_PI_d32_3.buff_PI_d16$1_0.inv_PI_d4$1_0.VOUT.t13 15.0005
R13802 6to4_0.buff_PI_d32_3.buff_PI_d16$1_0.inv_PI_d4$1_0.VOUT.n5 6to4_0.buff_PI_d32_3.buff_PI_d16$1_0.inv_PI_d4$1_0.VOUT.t16 15.0005
R13803 6to4_0.buff_PI_d32_3.buff_PI_d16$1_0.inv_PI_d4$1_0.VOUT.n7 6to4_0.buff_PI_d32_3.buff_PI_d16$1_0.inv_PI_d4$1_0.VOUT.t15 15.0005
R13804 6to4_0.buff_PI_d32_3.buff_PI_d16$1_0.inv_PI_d4$1_0.VOUT.n9 6to4_0.buff_PI_d32_3.buff_PI_d16$1_0.inv_PI_d4$1_0.VOUT.t19 15.0005
R13805 6to4_0.buff_PI_d32_3.buff_PI_d16$1_0.inv_PI_d4$1_0.VOUT.n11 6to4_0.buff_PI_d32_3.buff_PI_d16$1_0.inv_PI_d4$1_0.VOUT.t14 15.0005
R13806 6to4_0.buff_PI_d32_3.buff_PI_d16$1_0.inv_PI_d4$1_0.VOUT.n13 6to4_0.buff_PI_d32_3.buff_PI_d16$1_0.inv_PI_d4$1_0.VOUT.t18 15.0005
R13807 6to4_0.buff_PI_d32_3.buff_PI_d16$1_0.inv_PI_d4$1_0.VOUT.n2 6to4_0.buff_PI_d32_3.buff_PI_d16$1_0.inv_PI_d4$1_0.VOUT.n0 10.3469
R13808 6to4_0.buff_PI_d32_3.buff_PI_d16$1_0.inv_PI_d4$1_0.VOUT.n14 6to4_0.buff_PI_d32_3.buff_PI_d16$1_0.inv_PI_d4$1_0.VOUT.n13 9.0005
R13809 6to4_0.buff_PI_d32_3.buff_PI_d16$1_0.inv_PI_d4$1_0.VOUT.n12 6to4_0.buff_PI_d32_3.buff_PI_d16$1_0.inv_PI_d4$1_0.VOUT.n11 9.0005
R13810 6to4_0.buff_PI_d32_3.buff_PI_d16$1_0.inv_PI_d4$1_0.VOUT.n10 6to4_0.buff_PI_d32_3.buff_PI_d16$1_0.inv_PI_d4$1_0.VOUT.n9 9.0005
R13811 6to4_0.buff_PI_d32_3.buff_PI_d16$1_0.inv_PI_d4$1_0.VOUT.n8 6to4_0.buff_PI_d32_3.buff_PI_d16$1_0.inv_PI_d4$1_0.VOUT.n7 9.0005
R13812 6to4_0.buff_PI_d32_3.buff_PI_d16$1_0.inv_PI_d4$1_0.VOUT.n6 6to4_0.buff_PI_d32_3.buff_PI_d16$1_0.inv_PI_d4$1_0.VOUT.n5 9.0005
R13813 6to4_0.buff_PI_d32_3.buff_PI_d16$1_0.inv_PI_d4$1_0.VOUT.n4 6to4_0.buff_PI_d32_3.buff_PI_d16$1_0.inv_PI_d4$1_0.VOUT.n3 9.0005
R13814 6to4_0.buff_PI_d32_3.buff_PI_d16$1_0.inv_PI_d4$1_0.VOUT.n2 6to4_0.buff_PI_d32_3.buff_PI_d16$1_0.inv_PI_d4$1_0.VOUT.n1 9.0005
R13815 6to4_0.buff_PI_d32_3.buff_PI_d16$1_0.inv_PI_d4$1_0.VOUT.n15 6to4_0.buff_PI_d32_3.buff_PI_d16$1_0.inv_PI_d4$1_0.VOUT.n14 7.25305
R13816 6to4_0.buff_PI_d32_3.buff_PI_d16$1_0.inv_PI_d4$1_0.VOUT.n21 6to4_0.buff_PI_d32_3.buff_PI_d16$1_0.inv_PI_d4$1_0.VOUT.n20 1.41675
R13817 6to4_0.buff_PI_d32_3.buff_PI_d16$1_0.inv_PI_d4$1_0.VOUT.n14 6to4_0.buff_PI_d32_3.buff_PI_d16$1_0.inv_PI_d4$1_0.VOUT.n12 1.3469
R13818 6to4_0.buff_PI_d32_3.buff_PI_d16$1_0.inv_PI_d4$1_0.VOUT.n10 6to4_0.buff_PI_d32_3.buff_PI_d16$1_0.inv_PI_d4$1_0.VOUT.n8 1.3469
R13819 6to4_0.buff_PI_d32_3.buff_PI_d16$1_0.inv_PI_d4$1_0.VOUT.n6 6to4_0.buff_PI_d32_3.buff_PI_d16$1_0.inv_PI_d4$1_0.VOUT.n4 1.3469
R13820 6to4_0.buff_PI_d32_3.buff_PI_d16$1_0.inv_PI_d4$1_0.VOUT.n12 6to4_0.buff_PI_d32_3.buff_PI_d16$1_0.inv_PI_d4$1_0.VOUT.n10 0.9685
R13821 6to4_0.buff_PI_d32_3.buff_PI_d16$1_0.inv_PI_d4$1_0.VOUT.n8 6to4_0.buff_PI_d32_3.buff_PI_d16$1_0.inv_PI_d4$1_0.VOUT.n6 0.9685
R13822 6to4_0.buff_PI_d32_3.buff_PI_d16$1_0.inv_PI_d4$1_0.VOUT.n4 6to4_0.buff_PI_d32_3.buff_PI_d16$1_0.inv_PI_d4$1_0.VOUT.n2 0.9685
R13823 6to4_0.buff_PI_d32_3.buff_PI_d16$1_0.inv_PI_d4$1_0.VOUT.n24 6to4_0.buff_PI_d32_3.buff_PI_d16$1_0.inv_PI_d4$1_0.VOUT.n23 0.633
R13824 6to4_0.buff_PI_d32_3.buff_PI_d16$1_0.inv_PI_d4$1_0.VOUT.n18 6to4_0.buff_PI_d32_3.buff_PI_d16$1_0.inv_PI_d4$1_0.VOUT.n17 0.633
R13825 6to4_0.buff_PI_d32_3.buff_PI_d16$1_0.inv_PI_d4$1_0.VOUT.n23 6to4_0.buff_PI_d32_3.buff_PI_d16$1_0.inv_PI_d4$1_0.VOUT.n22 0.392375
R13826 6to4_0.buff_PI_d32_3.buff_PI_d16$1_0.inv_PI_d4$1_0.VOUT.n17 6to4_0.buff_PI_d32_3.buff_PI_d16$1_0.inv_PI_d4$1_0.VOUT.n16 0.392375
R13827 6to4_0.buff_PI_d32_3.buff_PI_d16$1_0.inv_PI_d4$1_0.VOUT.n25 6to4_0.buff_PI_d32_3.buff_PI_d16$1_0.inv_PI_d4$1_0.VOUT 0.358
R13828 6to4_0.buff_PI_d32_3.buff_PI_d16$1_0.inv_PI_d4$1_0.VOUT.n19 6to4_0.buff_PI_d32_3.buff_PI_d16$1_0.inv_PI_d4$1_0.VOUT 0.358
R13829 6to4_0.buff_PI_d32_3.buff_PI_d16$1_0.inv_PI_d4$1_0.VOUT 6to4_0.buff_PI_d32_3.buff_PI_d16$1_0.inv_PI_d4$1_0.VOUT.n21 0.3305
R13830 6to4_0.buff_PI_d32_3.buff_PI_d16$1_0.inv_PI_d4$1_0.VOUT.n20 6to4_0.buff_PI_d32_3.buff_PI_d16$1_0.inv_PI_d4$1_0.VOUT 0.3305
R13831 6to4_0.buff_PI_d32_3.buff_PI_d16$1_0.inv_PI_d4$1_0.VOUT 6to4_0.buff_PI_d32_3.buff_PI_d16$1_0.inv_PI_d4$1_0.VOUT.n15 0.113938
R13832 6to4_0.buff_PI_d32_3.buff_PI_d16$1_0.inv_PI_d4$1_0.VOUT 6to4_0.buff_PI_d32_3.buff_PI_d16$1_0.inv_PI_d4$1_0.VOUT.n25 0.062375
R13833 6to4_0.buff_PI_d32_3.buff_PI_d16$1_0.inv_PI_d4$1_0.VOUT.n22 6to4_0.buff_PI_d32_3.buff_PI_d16$1_0.inv_PI_d4$1_0.VOUT 0.062375
R13834 6to4_0.buff_PI_d32_3.buff_PI_d16$1_0.inv_PI_d4$1_0.VOUT 6to4_0.buff_PI_d32_3.buff_PI_d16$1_0.inv_PI_d4$1_0.VOUT.n19 0.062375
R13835 6to4_0.buff_PI_d32_3.buff_PI_d16$1_0.inv_PI_d4$1_0.VOUT.n16 6to4_0.buff_PI_d32_3.buff_PI_d16$1_0.inv_PI_d4$1_0.VOUT 0.062375
R13836 6to4_0.buff_PI_d32_3.buff_PI_d16$1_0.inv_PI_d4$1_0.VOUT.n1 6to4_0.buff_PI_d32_3.buff_PI_d16$1_0.inv_PI_d4$1_0.VOUT 0.0555
R13837 6to4_0.buff_PI_d32_3.buff_PI_d16$1_0.inv_PI_d4$1_0.VOUT.n5 6to4_0.buff_PI_d32_3.buff_PI_d16$1_0.inv_PI_d4$1_0.VOUT 0.0555
R13838 6to4_0.buff_PI_d32_3.buff_PI_d16$1_0.inv_PI_d4$1_0.VOUT.n9 6to4_0.buff_PI_d32_3.buff_PI_d16$1_0.inv_PI_d4$1_0.VOUT 0.0555
R13839 6to4_0.buff_PI_d32_3.buff_PI_d16$1_0.inv_PI_d4$1_0.VOUT.n13 6to4_0.buff_PI_d32_3.buff_PI_d16$1_0.inv_PI_d4$1_0.VOUT 0.0555
R13840 6to4_0.buff_PI_d32_3.buff_PI_d16$1_0.inv_PI_d4$1_0.VOUT 6to4_0.buff_PI_d32_3.buff_PI_d16$1_0.inv_PI_d4$1_0.VOUT.n24 0.034875
R13841 6to4_0.buff_PI_d32_3.buff_PI_d16$1_0.inv_PI_d4$1_0.VOUT 6to4_0.buff_PI_d32_3.buff_PI_d16$1_0.inv_PI_d4$1_0.VOUT.n18 0.034875
R13842 6to4_0.buff_PI_d32_3.buff_PI_d16$1_0.inv_PI_d4$1_0.VOUT.n0 6to4_0.buff_PI_d32_3.buff_PI_d16$1_0.inv_PI_d4$1_0.VOUT 0.0115
R13843 6to4_0.buff_PI_d32_3.buff_PI_d16$1_0.inv_PI_d4$1_0.VOUT.n3 6to4_0.buff_PI_d32_3.buff_PI_d16$1_0.inv_PI_d4$1_0.VOUT 0.0115
R13844 6to4_0.buff_PI_d32_3.buff_PI_d16$1_0.inv_PI_d4$1_0.VOUT.n7 6to4_0.buff_PI_d32_3.buff_PI_d16$1_0.inv_PI_d4$1_0.VOUT 0.0115
R13845 6to4_0.buff_PI_d32_3.buff_PI_d16$1_0.inv_PI_d4$1_0.VOUT.n11 6to4_0.buff_PI_d32_3.buff_PI_d16$1_0.inv_PI_d4$1_0.VOUT 0.0115
R13846 6to4_0.buff_PI_d32_2.buff_PI_d16$1_0.inv_PI_d4$1_0.VOUT.n16 6to4_0.buff_PI_d32_2.buff_PI_d16$1_0.inv_PI_d4$1_0.VOUT.t2 17.6089
R13847 6to4_0.buff_PI_d32_2.buff_PI_d16$1_0.inv_PI_d4$1_0.VOUT.n19 6to4_0.buff_PI_d32_2.buff_PI_d16$1_0.inv_PI_d4$1_0.VOUT.t0 17.6089
R13848 6to4_0.buff_PI_d32_2.buff_PI_d16$1_0.inv_PI_d4$1_0.VOUT.n22 6to4_0.buff_PI_d32_2.buff_PI_d16$1_0.inv_PI_d4$1_0.VOUT.t1 17.6089
R13849 6to4_0.buff_PI_d32_2.buff_PI_d16$1_0.inv_PI_d4$1_0.VOUT.n25 6to4_0.buff_PI_d32_2.buff_PI_d16$1_0.inv_PI_d4$1_0.VOUT.t3 17.6089
R13850 6to4_0.buff_PI_d32_2.buff_PI_d16$1_0.inv_PI_d4$1_0.VOUT 6to4_0.buff_PI_d32_2.buff_PI_d16$1_0.inv_PI_d4$1_0.VOUT.t5 17.5436
R13851 6to4_0.buff_PI_d32_2.buff_PI_d16$1_0.inv_PI_d4$1_0.VOUT.n15 6to4_0.buff_PI_d32_2.buff_PI_d16$1_0.inv_PI_d4$1_0.VOUT.t7 17.2136
R13852 6to4_0.buff_PI_d32_2.buff_PI_d16$1_0.inv_PI_d4$1_0.VOUT.n24 6to4_0.buff_PI_d32_2.buff_PI_d16$1_0.inv_PI_d4$1_0.VOUT.t6 17.2136
R13853 6to4_0.buff_PI_d32_2.buff_PI_d16$1_0.inv_PI_d4$1_0.VOUT.n23 6to4_0.buff_PI_d32_2.buff_PI_d16$1_0.inv_PI_d4$1_0.VOUT.t9 17.2136
R13854 6to4_0.buff_PI_d32_2.buff_PI_d16$1_0.inv_PI_d4$1_0.VOUT.n21 6to4_0.buff_PI_d32_2.buff_PI_d16$1_0.inv_PI_d4$1_0.VOUT.t4 17.2136
R13855 6to4_0.buff_PI_d32_2.buff_PI_d16$1_0.inv_PI_d4$1_0.VOUT.n20 6to4_0.buff_PI_d32_2.buff_PI_d16$1_0.inv_PI_d4$1_0.VOUT.t10 17.2136
R13856 6to4_0.buff_PI_d32_2.buff_PI_d16$1_0.inv_PI_d4$1_0.VOUT.n18 6to4_0.buff_PI_d32_2.buff_PI_d16$1_0.inv_PI_d4$1_0.VOUT.t8 17.2136
R13857 6to4_0.buff_PI_d32_2.buff_PI_d16$1_0.inv_PI_d4$1_0.VOUT.n17 6to4_0.buff_PI_d32_2.buff_PI_d16$1_0.inv_PI_d4$1_0.VOUT.t11 17.2136
R13858 6to4_0.buff_PI_d32_2.buff_PI_d16$1_0.inv_PI_d4$1_0.VOUT.n0 6to4_0.buff_PI_d32_2.buff_PI_d16$1_0.inv_PI_d4$1_0.VOUT.t16 15.0005
R13859 6to4_0.buff_PI_d32_2.buff_PI_d16$1_0.inv_PI_d4$1_0.VOUT.n1 6to4_0.buff_PI_d32_2.buff_PI_d16$1_0.inv_PI_d4$1_0.VOUT.t12 15.0005
R13860 6to4_0.buff_PI_d32_2.buff_PI_d16$1_0.inv_PI_d4$1_0.VOUT.n3 6to4_0.buff_PI_d32_2.buff_PI_d16$1_0.inv_PI_d4$1_0.VOUT.t13 15.0005
R13861 6to4_0.buff_PI_d32_2.buff_PI_d16$1_0.inv_PI_d4$1_0.VOUT.n5 6to4_0.buff_PI_d32_2.buff_PI_d16$1_0.inv_PI_d4$1_0.VOUT.t14 15.0005
R13862 6to4_0.buff_PI_d32_2.buff_PI_d16$1_0.inv_PI_d4$1_0.VOUT.n7 6to4_0.buff_PI_d32_2.buff_PI_d16$1_0.inv_PI_d4$1_0.VOUT.t19 15.0005
R13863 6to4_0.buff_PI_d32_2.buff_PI_d16$1_0.inv_PI_d4$1_0.VOUT.n9 6to4_0.buff_PI_d32_2.buff_PI_d16$1_0.inv_PI_d4$1_0.VOUT.t15 15.0005
R13864 6to4_0.buff_PI_d32_2.buff_PI_d16$1_0.inv_PI_d4$1_0.VOUT.n11 6to4_0.buff_PI_d32_2.buff_PI_d16$1_0.inv_PI_d4$1_0.VOUT.t17 15.0005
R13865 6to4_0.buff_PI_d32_2.buff_PI_d16$1_0.inv_PI_d4$1_0.VOUT.n13 6to4_0.buff_PI_d32_2.buff_PI_d16$1_0.inv_PI_d4$1_0.VOUT.t18 15.0005
R13866 6to4_0.buff_PI_d32_2.buff_PI_d16$1_0.inv_PI_d4$1_0.VOUT.n2 6to4_0.buff_PI_d32_2.buff_PI_d16$1_0.inv_PI_d4$1_0.VOUT.n0 10.3469
R13867 6to4_0.buff_PI_d32_2.buff_PI_d16$1_0.inv_PI_d4$1_0.VOUT.n14 6to4_0.buff_PI_d32_2.buff_PI_d16$1_0.inv_PI_d4$1_0.VOUT.n13 9.0005
R13868 6to4_0.buff_PI_d32_2.buff_PI_d16$1_0.inv_PI_d4$1_0.VOUT.n12 6to4_0.buff_PI_d32_2.buff_PI_d16$1_0.inv_PI_d4$1_0.VOUT.n11 9.0005
R13869 6to4_0.buff_PI_d32_2.buff_PI_d16$1_0.inv_PI_d4$1_0.VOUT.n10 6to4_0.buff_PI_d32_2.buff_PI_d16$1_0.inv_PI_d4$1_0.VOUT.n9 9.0005
R13870 6to4_0.buff_PI_d32_2.buff_PI_d16$1_0.inv_PI_d4$1_0.VOUT.n8 6to4_0.buff_PI_d32_2.buff_PI_d16$1_0.inv_PI_d4$1_0.VOUT.n7 9.0005
R13871 6to4_0.buff_PI_d32_2.buff_PI_d16$1_0.inv_PI_d4$1_0.VOUT.n6 6to4_0.buff_PI_d32_2.buff_PI_d16$1_0.inv_PI_d4$1_0.VOUT.n5 9.0005
R13872 6to4_0.buff_PI_d32_2.buff_PI_d16$1_0.inv_PI_d4$1_0.VOUT.n4 6to4_0.buff_PI_d32_2.buff_PI_d16$1_0.inv_PI_d4$1_0.VOUT.n3 9.0005
R13873 6to4_0.buff_PI_d32_2.buff_PI_d16$1_0.inv_PI_d4$1_0.VOUT.n2 6to4_0.buff_PI_d32_2.buff_PI_d16$1_0.inv_PI_d4$1_0.VOUT.n1 9.0005
R13874 6to4_0.buff_PI_d32_2.buff_PI_d16$1_0.inv_PI_d4$1_0.VOUT.n15 6to4_0.buff_PI_d32_2.buff_PI_d16$1_0.inv_PI_d4$1_0.VOUT.n14 7.25305
R13875 6to4_0.buff_PI_d32_2.buff_PI_d16$1_0.inv_PI_d4$1_0.VOUT.n21 6to4_0.buff_PI_d32_2.buff_PI_d16$1_0.inv_PI_d4$1_0.VOUT.n20 1.41675
R13876 6to4_0.buff_PI_d32_2.buff_PI_d16$1_0.inv_PI_d4$1_0.VOUT.n14 6to4_0.buff_PI_d32_2.buff_PI_d16$1_0.inv_PI_d4$1_0.VOUT.n12 1.3469
R13877 6to4_0.buff_PI_d32_2.buff_PI_d16$1_0.inv_PI_d4$1_0.VOUT.n10 6to4_0.buff_PI_d32_2.buff_PI_d16$1_0.inv_PI_d4$1_0.VOUT.n8 1.3469
R13878 6to4_0.buff_PI_d32_2.buff_PI_d16$1_0.inv_PI_d4$1_0.VOUT.n6 6to4_0.buff_PI_d32_2.buff_PI_d16$1_0.inv_PI_d4$1_0.VOUT.n4 1.3469
R13879 6to4_0.buff_PI_d32_2.buff_PI_d16$1_0.inv_PI_d4$1_0.VOUT.n12 6to4_0.buff_PI_d32_2.buff_PI_d16$1_0.inv_PI_d4$1_0.VOUT.n10 0.9685
R13880 6to4_0.buff_PI_d32_2.buff_PI_d16$1_0.inv_PI_d4$1_0.VOUT.n8 6to4_0.buff_PI_d32_2.buff_PI_d16$1_0.inv_PI_d4$1_0.VOUT.n6 0.9685
R13881 6to4_0.buff_PI_d32_2.buff_PI_d16$1_0.inv_PI_d4$1_0.VOUT.n4 6to4_0.buff_PI_d32_2.buff_PI_d16$1_0.inv_PI_d4$1_0.VOUT.n2 0.9685
R13882 6to4_0.buff_PI_d32_2.buff_PI_d16$1_0.inv_PI_d4$1_0.VOUT.n24 6to4_0.buff_PI_d32_2.buff_PI_d16$1_0.inv_PI_d4$1_0.VOUT.n23 0.633
R13883 6to4_0.buff_PI_d32_2.buff_PI_d16$1_0.inv_PI_d4$1_0.VOUT.n18 6to4_0.buff_PI_d32_2.buff_PI_d16$1_0.inv_PI_d4$1_0.VOUT.n17 0.633
R13884 6to4_0.buff_PI_d32_2.buff_PI_d16$1_0.inv_PI_d4$1_0.VOUT.n23 6to4_0.buff_PI_d32_2.buff_PI_d16$1_0.inv_PI_d4$1_0.VOUT.n22 0.392375
R13885 6to4_0.buff_PI_d32_2.buff_PI_d16$1_0.inv_PI_d4$1_0.VOUT.n17 6to4_0.buff_PI_d32_2.buff_PI_d16$1_0.inv_PI_d4$1_0.VOUT.n16 0.392375
R13886 6to4_0.buff_PI_d32_2.buff_PI_d16$1_0.inv_PI_d4$1_0.VOUT.n25 6to4_0.buff_PI_d32_2.buff_PI_d16$1_0.inv_PI_d4$1_0.VOUT 0.358
R13887 6to4_0.buff_PI_d32_2.buff_PI_d16$1_0.inv_PI_d4$1_0.VOUT.n19 6to4_0.buff_PI_d32_2.buff_PI_d16$1_0.inv_PI_d4$1_0.VOUT 0.358
R13888 6to4_0.buff_PI_d32_2.buff_PI_d16$1_0.inv_PI_d4$1_0.VOUT 6to4_0.buff_PI_d32_2.buff_PI_d16$1_0.inv_PI_d4$1_0.VOUT.n21 0.3305
R13889 6to4_0.buff_PI_d32_2.buff_PI_d16$1_0.inv_PI_d4$1_0.VOUT.n20 6to4_0.buff_PI_d32_2.buff_PI_d16$1_0.inv_PI_d4$1_0.VOUT 0.3305
R13890 6to4_0.buff_PI_d32_2.buff_PI_d16$1_0.inv_PI_d4$1_0.VOUT 6to4_0.buff_PI_d32_2.buff_PI_d16$1_0.inv_PI_d4$1_0.VOUT.n15 0.113938
R13891 6to4_0.buff_PI_d32_2.buff_PI_d16$1_0.inv_PI_d4$1_0.VOUT 6to4_0.buff_PI_d32_2.buff_PI_d16$1_0.inv_PI_d4$1_0.VOUT.n25 0.062375
R13892 6to4_0.buff_PI_d32_2.buff_PI_d16$1_0.inv_PI_d4$1_0.VOUT.n22 6to4_0.buff_PI_d32_2.buff_PI_d16$1_0.inv_PI_d4$1_0.VOUT 0.062375
R13893 6to4_0.buff_PI_d32_2.buff_PI_d16$1_0.inv_PI_d4$1_0.VOUT 6to4_0.buff_PI_d32_2.buff_PI_d16$1_0.inv_PI_d4$1_0.VOUT.n19 0.062375
R13894 6to4_0.buff_PI_d32_2.buff_PI_d16$1_0.inv_PI_d4$1_0.VOUT.n16 6to4_0.buff_PI_d32_2.buff_PI_d16$1_0.inv_PI_d4$1_0.VOUT 0.062375
R13895 6to4_0.buff_PI_d32_2.buff_PI_d16$1_0.inv_PI_d4$1_0.VOUT.n1 6to4_0.buff_PI_d32_2.buff_PI_d16$1_0.inv_PI_d4$1_0.VOUT 0.0555
R13896 6to4_0.buff_PI_d32_2.buff_PI_d16$1_0.inv_PI_d4$1_0.VOUT.n5 6to4_0.buff_PI_d32_2.buff_PI_d16$1_0.inv_PI_d4$1_0.VOUT 0.0555
R13897 6to4_0.buff_PI_d32_2.buff_PI_d16$1_0.inv_PI_d4$1_0.VOUT.n9 6to4_0.buff_PI_d32_2.buff_PI_d16$1_0.inv_PI_d4$1_0.VOUT 0.0555
R13898 6to4_0.buff_PI_d32_2.buff_PI_d16$1_0.inv_PI_d4$1_0.VOUT.n13 6to4_0.buff_PI_d32_2.buff_PI_d16$1_0.inv_PI_d4$1_0.VOUT 0.0555
R13899 6to4_0.buff_PI_d32_2.buff_PI_d16$1_0.inv_PI_d4$1_0.VOUT 6to4_0.buff_PI_d32_2.buff_PI_d16$1_0.inv_PI_d4$1_0.VOUT.n24 0.034875
R13900 6to4_0.buff_PI_d32_2.buff_PI_d16$1_0.inv_PI_d4$1_0.VOUT 6to4_0.buff_PI_d32_2.buff_PI_d16$1_0.inv_PI_d4$1_0.VOUT.n18 0.034875
R13901 6to4_0.buff_PI_d32_2.buff_PI_d16$1_0.inv_PI_d4$1_0.VOUT.n0 6to4_0.buff_PI_d32_2.buff_PI_d16$1_0.inv_PI_d4$1_0.VOUT 0.0115
R13902 6to4_0.buff_PI_d32_2.buff_PI_d16$1_0.inv_PI_d4$1_0.VOUT.n3 6to4_0.buff_PI_d32_2.buff_PI_d16$1_0.inv_PI_d4$1_0.VOUT 0.0115
R13903 6to4_0.buff_PI_d32_2.buff_PI_d16$1_0.inv_PI_d4$1_0.VOUT.n7 6to4_0.buff_PI_d32_2.buff_PI_d16$1_0.inv_PI_d4$1_0.VOUT 0.0115
R13904 6to4_0.buff_PI_d32_2.buff_PI_d16$1_0.inv_PI_d4$1_0.VOUT.n11 6to4_0.buff_PI_d32_2.buff_PI_d16$1_0.inv_PI_d4$1_0.VOUT 0.0115
R13905 PH0.n0 PH0.t0 17.6089
R13906 PH0.n3 PH0.t19 17.6089
R13907 PH0.n6 PH0.t18 17.6089
R13908 PH0.n9 PH0.t30 17.6089
R13909 PH0.n12 PH0.t24 17.6089
R13910 PH0.n15 PH0.t10 17.6089
R13911 PH0.n18 PH0.t13 17.6089
R13912 PH0.n21 PH0.t22 17.6089
R13913 PH0.n23 PH0.t15 17.6089
R13914 PH0.n26 PH0.t1 17.6089
R13915 PH0.n29 PH0.t5 17.6089
R13916 PH0.n32 PH0.t4 17.6089
R13917 PH0.n35 PH0.t3 17.6089
R13918 PH0.n38 PH0.t11 17.6089
R13919 PH0.n41 PH0.t23 17.6089
R13920 PH0.n44 PH0.t12 17.6089
R13921 PH0.n46 PH0.t28 17.6089
R13922 PH0.n49 PH0.t20 17.6089
R13923 PH0.n52 PH0.t2 17.6089
R13924 PH0.n55 PH0.t16 17.6089
R13925 PH0.n58 PH0.t21 17.6089
R13926 PH0.n61 PH0.t9 17.6089
R13927 PH0.n64 PH0.t26 17.6089
R13928 PH0.n67 PH0.t27 17.6089
R13929 PH0.n70 PH0.t7 17.6089
R13930 PH0.n73 PH0.t8 17.6089
R13931 PH0.n76 PH0.t14 17.6089
R13932 PH0.n79 PH0.t25 17.6089
R13933 PH0.n82 PH0.t29 17.6089
R13934 PH0.n88 PH0.t31 17.6089
R13935 PH0.n91 PH0.t6 17.6089
R13936 PH0.n85 PH0.t17 17.6089
R13937 PH0 PH0.t44 17.5436
R13938 PH0 PH0.t45 17.5436
R13939 PH0 PH0.t32 17.5436
R13940 PH0 PH0.t52 17.5436
R13941 PH0.n22 PH0.t68 17.2136
R13942 PH0.n20 PH0.t69 17.2136
R13943 PH0.n19 PH0.t82 17.2136
R13944 PH0.n17 PH0.t35 17.2136
R13945 PH0.n16 PH0.t65 17.2136
R13946 PH0.n14 PH0.t80 17.2136
R13947 PH0.n13 PH0.t90 17.2136
R13948 PH0.n11 PH0.t54 17.2136
R13949 PH0.n10 PH0.t56 17.2136
R13950 PH0.n8 PH0.t33 17.2136
R13951 PH0.n7 PH0.t58 17.2136
R13952 PH0.n5 PH0.t85 17.2136
R13953 PH0.n4 PH0.t78 17.2136
R13954 PH0.n2 PH0.t51 17.2136
R13955 PH0.n1 PH0.t72 17.2136
R13956 PH0.n45 PH0.t34 17.2136
R13957 PH0.n43 PH0.t81 17.2136
R13958 PH0.n42 PH0.t89 17.2136
R13959 PH0.n40 PH0.t62 17.2136
R13960 PH0.n39 PH0.t39 17.2136
R13961 PH0.n37 PH0.t87 17.2136
R13962 PH0.n36 PH0.t41 17.2136
R13963 PH0.n34 PH0.t74 17.2136
R13964 PH0.n33 PH0.t57 17.2136
R13965 PH0.n31 PH0.t59 17.2136
R13966 PH0.n30 PH0.t76 17.2136
R13967 PH0.n28 PH0.t47 17.2136
R13968 PH0.n27 PH0.t86 17.2136
R13969 PH0.n25 PH0.t73 17.2136
R13970 PH0.n24 PH0.t83 17.2136
R13971 PH0.n68 PH0.t75 17.2136
R13972 PH0.n66 PH0.t66 17.2136
R13973 PH0.n65 PH0.t43 17.2136
R13974 PH0.n63 PH0.t64 17.2136
R13975 PH0.n62 PH0.t42 17.2136
R13976 PH0.n60 PH0.t55 17.2136
R13977 PH0.n59 PH0.t95 17.2136
R13978 PH0.n57 PH0.t53 17.2136
R13979 PH0.n56 PH0.t84 17.2136
R13980 PH0.n54 PH0.t91 17.2136
R13981 PH0.n53 PH0.t94 17.2136
R13982 PH0.n51 PH0.t46 17.2136
R13983 PH0.n50 PH0.t67 17.2136
R13984 PH0.n48 PH0.t88 17.2136
R13985 PH0.n47 PH0.t92 17.2136
R13986 PH0.n69 PH0.t38 17.2136
R13987 PH0.n90 PH0.t77 17.2136
R13988 PH0.n89 PH0.t61 17.2136
R13989 PH0.n87 PH0.t37 17.2136
R13990 PH0.n86 PH0.t60 17.2136
R13991 PH0.n84 PH0.t71 17.2136
R13992 PH0.n83 PH0.t50 17.2136
R13993 PH0.n81 PH0.t70 17.2136
R13994 PH0.n80 PH0.t49 17.2136
R13995 PH0.n78 PH0.t36 17.2136
R13996 PH0.n77 PH0.t48 17.2136
R13997 PH0.n75 PH0.t63 17.2136
R13998 PH0.n74 PH0.t79 17.2136
R13999 PH0.n72 PH0.t93 17.2136
R14000 PH0.n71 PH0.t40 17.2136
R14001 PH0 PH0.n22 5.38309
R14002 PH0 PH0.n45 5.12956
R14003 PH0 PH0.n68 5.12956
R14004 PH0.n69 PH0 5.12956
R14005 PH0.n17 PH0.n16 1.41675
R14006 PH0.n11 PH0.n10 1.41675
R14007 PH0.n5 PH0.n4 1.41675
R14008 PH0.n40 PH0.n39 1.41675
R14009 PH0.n34 PH0.n33 1.41675
R14010 PH0.n28 PH0.n27 1.41675
R14011 PH0.n63 PH0.n62 1.41675
R14012 PH0.n57 PH0.n56 1.41675
R14013 PH0.n51 PH0.n50 1.41675
R14014 PH0.n87 PH0.n86 1.41675
R14015 PH0.n81 PH0.n80 1.41675
R14016 PH0.n75 PH0.n74 1.41675
R14017 PH0.n20 PH0.n19 0.633
R14018 PH0.n14 PH0.n13 0.633
R14019 PH0.n8 PH0.n7 0.633
R14020 PH0.n2 PH0.n1 0.633
R14021 PH0.n43 PH0.n42 0.633
R14022 PH0.n37 PH0.n36 0.633
R14023 PH0.n31 PH0.n30 0.633
R14024 PH0.n25 PH0.n24 0.633
R14025 PH0.n66 PH0.n65 0.633
R14026 PH0.n60 PH0.n59 0.633
R14027 PH0.n54 PH0.n53 0.633
R14028 PH0.n48 PH0.n47 0.633
R14029 PH0.n90 PH0.n89 0.633
R14030 PH0.n84 PH0.n83 0.633
R14031 PH0.n78 PH0.n77 0.633
R14032 PH0.n72 PH0.n71 0.633
R14033 PH0.n19 PH0.n18 0.392375
R14034 PH0.n13 PH0.n12 0.392375
R14035 PH0.n7 PH0.n6 0.392375
R14036 PH0.n1 PH0.n0 0.392375
R14037 PH0.n42 PH0.n41 0.392375
R14038 PH0.n36 PH0.n35 0.392375
R14039 PH0.n30 PH0.n29 0.392375
R14040 PH0.n24 PH0.n23 0.392375
R14041 PH0.n65 PH0.n64 0.392375
R14042 PH0.n59 PH0.n58 0.392375
R14043 PH0.n53 PH0.n52 0.392375
R14044 PH0.n47 PH0.n46 0.392375
R14045 PH0.n89 PH0.n88 0.392375
R14046 PH0.n83 PH0.n82 0.392375
R14047 PH0.n77 PH0.n76 0.392375
R14048 PH0.n71 PH0.n70 0.392375
R14049 PH0.n21 PH0 0.358
R14050 PH0.n15 PH0 0.358
R14051 PH0.n9 PH0 0.358
R14052 PH0.n3 PH0 0.358
R14053 PH0.n44 PH0 0.358
R14054 PH0.n38 PH0 0.358
R14055 PH0.n32 PH0 0.358
R14056 PH0.n26 PH0 0.358
R14057 PH0.n67 PH0 0.358
R14058 PH0.n61 PH0 0.358
R14059 PH0.n55 PH0 0.358
R14060 PH0.n49 PH0 0.358
R14061 PH0.n91 PH0 0.358
R14062 PH0.n85 PH0 0.358
R14063 PH0.n79 PH0 0.358
R14064 PH0.n73 PH0 0.358
R14065 PH0 PH0.n17 0.3305
R14066 PH0.n16 PH0 0.3305
R14067 PH0 PH0.n11 0.3305
R14068 PH0 PH0.n5 0.3305
R14069 PH0.n4 PH0 0.3305
R14070 PH0 PH0.n40 0.3305
R14071 PH0.n39 PH0 0.3305
R14072 PH0 PH0.n34 0.3305
R14073 PH0 PH0.n28 0.3305
R14074 PH0.n27 PH0 0.3305
R14075 PH0 PH0.n63 0.3305
R14076 PH0.n62 PH0 0.3305
R14077 PH0 PH0.n57 0.3305
R14078 PH0 PH0.n51 0.3305
R14079 PH0.n50 PH0 0.3305
R14080 PH0 PH0.n87 0.3305
R14081 PH0.n86 PH0 0.3305
R14082 PH0 PH0.n81 0.3305
R14083 PH0 PH0.n75 0.3305
R14084 PH0.n74 PH0 0.3305
R14085 PH0.n22 PH0 0.113938
R14086 PH0.n10 PH0 0.113938
R14087 PH0.n45 PH0 0.113938
R14088 PH0.n33 PH0 0.113938
R14089 PH0.n68 PH0 0.113938
R14090 PH0.n56 PH0 0.113938
R14091 PH0 PH0.n69 0.113938
R14092 PH0.n80 PH0 0.113938
R14093 PH0 PH0.n21 0.062375
R14094 PH0.n18 PH0 0.062375
R14095 PH0 PH0.n15 0.062375
R14096 PH0.n12 PH0 0.062375
R14097 PH0 PH0.n9 0.062375
R14098 PH0.n6 PH0 0.062375
R14099 PH0 PH0.n3 0.062375
R14100 PH0.n0 PH0 0.062375
R14101 PH0 PH0.n44 0.062375
R14102 PH0.n41 PH0 0.062375
R14103 PH0 PH0.n38 0.062375
R14104 PH0.n35 PH0 0.062375
R14105 PH0 PH0.n32 0.062375
R14106 PH0.n29 PH0 0.062375
R14107 PH0 PH0.n26 0.062375
R14108 PH0.n23 PH0 0.062375
R14109 PH0 PH0.n67 0.062375
R14110 PH0.n64 PH0 0.062375
R14111 PH0 PH0.n61 0.062375
R14112 PH0.n58 PH0 0.062375
R14113 PH0 PH0.n55 0.062375
R14114 PH0.n52 PH0 0.062375
R14115 PH0 PH0.n49 0.062375
R14116 PH0.n46 PH0 0.062375
R14117 PH0 PH0.n91 0.062375
R14118 PH0.n88 PH0 0.062375
R14119 PH0 PH0.n85 0.062375
R14120 PH0.n82 PH0 0.062375
R14121 PH0 PH0.n79 0.062375
R14122 PH0.n76 PH0 0.062375
R14123 PH0 PH0.n73 0.062375
R14124 PH0.n70 PH0 0.062375
R14125 PH0 PH0.n20 0.034875
R14126 PH0 PH0.n14 0.034875
R14127 PH0 PH0.n8 0.034875
R14128 PH0 PH0.n2 0.034875
R14129 PH0 PH0.n43 0.034875
R14130 PH0 PH0.n37 0.034875
R14131 PH0 PH0.n31 0.034875
R14132 PH0 PH0.n25 0.034875
R14133 PH0 PH0.n66 0.034875
R14134 PH0 PH0.n60 0.034875
R14135 PH0 PH0.n54 0.034875
R14136 PH0 PH0.n48 0.034875
R14137 PH0 PH0.n90 0.034875
R14138 PH0 PH0.n84 0.034875
R14139 PH0 PH0.n78 0.034875
R14140 PH0 PH0.n72 0.034875
R14141 6ph_rosc_0.psdiff_0.buff_d8$1_1.VIN.n28 6ph_rosc_0.psdiff_0.buff_d8$1_1.VIN.n27 20.4895
R14142 6ph_rosc_0.psdiff_0.buff_d8$1_1.VIN.n21 6ph_rosc_0.psdiff_0.buff_d8$1_1.VIN.n20 18.6537
R14143 6ph_rosc_0.psdiff_0.buff_d8$1_1.VIN.n13 6ph_rosc_0.psdiff_0.buff_d8$1_1.VIN.t5 17.3511
R14144 6ph_rosc_0.psdiff_0.buff_d8$1_1.VIN.n11 6ph_rosc_0.psdiff_0.buff_d8$1_1.VIN.t1 17.3511
R14145 6ph_rosc_0.psdiff_0.buff_d8$1_1.VIN.n9 6ph_rosc_0.psdiff_0.buff_d8$1_1.VIN.t4 17.3511
R14146 6ph_rosc_0.psdiff_0.buff_d8$1_1.VIN.n6 6ph_rosc_0.psdiff_0.buff_d8$1_1.VIN.t28 17.3511
R14147 6ph_rosc_0.psdiff_0.buff_d8$1_1.VIN.n4 6ph_rosc_0.psdiff_0.buff_d8$1_1.VIN.t31 17.3511
R14148 6ph_rosc_0.psdiff_0.buff_d8$1_1.VIN.n26 6ph_rosc_0.psdiff_0.buff_d8$1_1.VIN.t21 17.3511
R14149 6ph_rosc_0.psdiff_0.buff_d8$1_1.VIN.n0 6ph_rosc_0.psdiff_0.buff_d8$1_1.VIN.t25 17.3511
R14150 6ph_rosc_0.psdiff_0.buff_d8$1_1.VIN.n2 6ph_rosc_0.psdiff_0.buff_d8$1_1.VIN.t20 17.3511
R14151 6ph_rosc_0.psdiff_0.buff_d8$1_1.VIN.n8 6ph_rosc_0.psdiff_0.buff_d8$1_1.VIN.t8 17.3511
R14152 6ph_rosc_0.psdiff_0.buff_d8$1_1.VIN.n15 6ph_rosc_0.psdiff_0.buff_d8$1_1.VIN.t7 17.3511
R14153 6ph_rosc_0.psdiff_0.buff_d8$1_1.VIN.n23 6ph_rosc_0.psdiff_0.buff_d8$1_1.VIN.t11 17.2171
R14154 6ph_rosc_0.psdiff_0.buff_d8$1_1.VIN.n14 6ph_rosc_0.psdiff_0.buff_d8$1_1.VIN.t14 17.0005
R14155 6ph_rosc_0.psdiff_0.buff_d8$1_1.VIN.n13 6ph_rosc_0.psdiff_0.buff_d8$1_1.VIN.t2 17.0005
R14156 6ph_rosc_0.psdiff_0.buff_d8$1_1.VIN.n12 6ph_rosc_0.psdiff_0.buff_d8$1_1.VIN.t13 17.0005
R14157 6ph_rosc_0.psdiff_0.buff_d8$1_1.VIN.n11 6ph_rosc_0.psdiff_0.buff_d8$1_1.VIN.t0 17.0005
R14158 6ph_rosc_0.psdiff_0.buff_d8$1_1.VIN.n10 6ph_rosc_0.psdiff_0.buff_d8$1_1.VIN.t15 17.0005
R14159 6ph_rosc_0.psdiff_0.buff_d8$1_1.VIN.n9 6ph_rosc_0.psdiff_0.buff_d8$1_1.VIN.t3 17.0005
R14160 6ph_rosc_0.psdiff_0.buff_d8$1_1.VIN.n6 6ph_rosc_0.psdiff_0.buff_d8$1_1.VIN.t23 17.0005
R14161 6ph_rosc_0.psdiff_0.buff_d8$1_1.VIN.n7 6ph_rosc_0.psdiff_0.buff_d8$1_1.VIN.t27 17.0005
R14162 6ph_rosc_0.psdiff_0.buff_d8$1_1.VIN.n4 6ph_rosc_0.psdiff_0.buff_d8$1_1.VIN.t17 17.0005
R14163 6ph_rosc_0.psdiff_0.buff_d8$1_1.VIN.n5 6ph_rosc_0.psdiff_0.buff_d8$1_1.VIN.t30 17.0005
R14164 6ph_rosc_0.psdiff_0.buff_d8$1_1.VIN.n26 6ph_rosc_0.psdiff_0.buff_d8$1_1.VIN.t24 17.0005
R14165 6ph_rosc_0.psdiff_0.buff_d8$1_1.VIN.n27 6ph_rosc_0.psdiff_0.buff_d8$1_1.VIN.t19 17.0005
R14166 6ph_rosc_0.psdiff_0.buff_d8$1_1.VIN.n0 6ph_rosc_0.psdiff_0.buff_d8$1_1.VIN.t29 17.0005
R14167 6ph_rosc_0.psdiff_0.buff_d8$1_1.VIN.n1 6ph_rosc_0.psdiff_0.buff_d8$1_1.VIN.t22 17.0005
R14168 6ph_rosc_0.psdiff_0.buff_d8$1_1.VIN.n2 6ph_rosc_0.psdiff_0.buff_d8$1_1.VIN.t26 17.0005
R14169 6ph_rosc_0.psdiff_0.buff_d8$1_1.VIN.n3 6ph_rosc_0.psdiff_0.buff_d8$1_1.VIN.t18 17.0005
R14170 6ph_rosc_0.psdiff_0.buff_d8$1_1.VIN.n21 6ph_rosc_0.psdiff_0.buff_d8$1_1.VIN.t10 17.0005
R14171 6ph_rosc_0.psdiff_0.buff_d8$1_1.VIN.n8 6ph_rosc_0.psdiff_0.buff_d8$1_1.VIN.t6 17.0005
R14172 6ph_rosc_0.psdiff_0.buff_d8$1_1.VIN.n20 6ph_rosc_0.psdiff_0.buff_d8$1_1.VIN.t12 17.0005
R14173 6ph_rosc_0.psdiff_0.buff_d8$1_1.VIN.n16 6ph_rosc_0.psdiff_0.buff_d8$1_1.VIN.t16 17.0005
R14174 6ph_rosc_0.psdiff_0.buff_d8$1_1.VIN.n15 6ph_rosc_0.psdiff_0.buff_d8$1_1.VIN.t9 17.0005
R14175 6ph_rosc_0.psdiff_0.buff_d8$1_1.VIN.n28 6ph_rosc_0.psdiff_0.buff_d8$1_1.VIN.t32 15.0005
R14176 6ph_rosc_0.psdiff_0.buff_d8$1_1.VIN.n17 6ph_rosc_0.psdiff_0.buff_d8$1_1.VIN.n16 0.997375
R14177 6ph_rosc_0.psdiff_0.buff_d8$1_1.VIN.n27 6ph_rosc_0.psdiff_0.buff_d8$1_1.VIN.n25 0.965015
R14178 6ph_rosc_0.psdiff_0.buff_d8$1_1.VIN.n20 6ph_rosc_0.psdiff_0.buff_d8$1_1.VIN.n19 0.965015
R14179 6ph_rosc_0.psdiff_0.buff_d8$1_1.VIN.n23 6ph_rosc_0.psdiff_0.buff_d8$1_1.VIN.n22 0.78425
R14180 6ph_rosc_0.psdiff_0.buff_d8$1_1.VIN.n24 6ph_rosc_0.psdiff_0.buff_d8$1_1.VIN.n23 0.78425
R14181 6ph_rosc_0.psdiff_0.buff_d8$1_1.VIN.n25 6ph_rosc_0.psdiff_0.buff_d8$1_1.VIN.n24 0.78425
R14182 6ph_rosc_0.psdiff_0.buff_d8$1_1.VIN.n18 6ph_rosc_0.psdiff_0.buff_d8$1_1.VIN.n17 0.78425
R14183 6ph_rosc_0.psdiff_0.buff_d8$1_1.VIN.n19 6ph_rosc_0.psdiff_0.buff_d8$1_1.VIN.n18 0.78425
R14184 6ph_rosc_0.psdiff_0.buff_d8$1_1.VIN.n14 6ph_rosc_0.psdiff_0.buff_d8$1_1.VIN.n13 0.622687
R14185 6ph_rosc_0.psdiff_0.buff_d8$1_1.VIN.n12 6ph_rosc_0.psdiff_0.buff_d8$1_1.VIN.n11 0.622687
R14186 6ph_rosc_0.psdiff_0.buff_d8$1_1.VIN.n10 6ph_rosc_0.psdiff_0.buff_d8$1_1.VIN.n9 0.622687
R14187 6ph_rosc_0.psdiff_0.buff_d8$1_1.VIN.n16 6ph_rosc_0.psdiff_0.buff_d8$1_1.VIN.n15 0.622687
R14188 6ph_rosc_0.psdiff_0.buff_d8$1_1.VIN.n20 6ph_rosc_0.psdiff_0.buff_d8$1_1.VIN.n8 0.590328
R14189 6ph_rosc_0.psdiff_0.buff_d8$1_1.VIN.n7 6ph_rosc_0.psdiff_0.buff_d8$1_1.VIN.n6 0.351125
R14190 6ph_rosc_0.psdiff_0.buff_d8$1_1.VIN.n5 6ph_rosc_0.psdiff_0.buff_d8$1_1.VIN.n4 0.351125
R14191 6ph_rosc_0.psdiff_0.buff_d8$1_1.VIN.n1 6ph_rosc_0.psdiff_0.buff_d8$1_1.VIN.n0 0.351125
R14192 6ph_rosc_0.psdiff_0.buff_d8$1_1.VIN.n3 6ph_rosc_0.psdiff_0.buff_d8$1_1.VIN.n2 0.351125
R14193 6ph_rosc_0.psdiff_0.buff_d8$1_1.VIN.n27 6ph_rosc_0.psdiff_0.buff_d8$1_1.VIN.n26 0.318765
R14194 6ph_rosc_0.psdiff_0.buff_d8$1_1.VIN.n17 6ph_rosc_0.psdiff_0.buff_d8$1_1.VIN.n14 0.213625
R14195 6ph_rosc_0.psdiff_0.buff_d8$1_1.VIN.n18 6ph_rosc_0.psdiff_0.buff_d8$1_1.VIN.n12 0.213625
R14196 6ph_rosc_0.psdiff_0.buff_d8$1_1.VIN.n19 6ph_rosc_0.psdiff_0.buff_d8$1_1.VIN.n10 0.213625
R14197 6ph_rosc_0.psdiff_0.buff_d8$1_1.VIN.n22 6ph_rosc_0.psdiff_0.buff_d8$1_1.VIN.n7 0.213625
R14198 6ph_rosc_0.psdiff_0.buff_d8$1_1.VIN.n23 6ph_rosc_0.psdiff_0.buff_d8$1_1.VIN.n5 0.213625
R14199 6ph_rosc_0.psdiff_0.buff_d8$1_1.VIN.n25 6ph_rosc_0.psdiff_0.buff_d8$1_1.VIN.n1 0.213625
R14200 6ph_rosc_0.psdiff_0.buff_d8$1_1.VIN.n24 6ph_rosc_0.psdiff_0.buff_d8$1_1.VIN.n3 0.213625
R14201 6ph_rosc_0.psdiff_0.buff_d8$1_1.VIN.n22 6ph_rosc_0.psdiff_0.buff_d8$1_1.VIN.n21 0.184703
R14202 6ph_rosc_0.psdiff_0.buff_d8$1_1.inv$3_0.VIN 6ph_rosc_0.psdiff_0.buff_d8$1_1.VIN.n28 0.0151667
R14203 6to4_0.buff_PI_d32_2.buff_PI_d16$1_0.inv_PI_d8$1_0.VOUT.n35 6to4_0.buff_PI_d32_2.buff_PI_d16$1_0.inv_PI_d8$1_0.VOUT.t2 17.6089
R14204 6to4_0.buff_PI_d32_2.buff_PI_d16$1_0.inv_PI_d8$1_0.VOUT.n38 6to4_0.buff_PI_d32_2.buff_PI_d16$1_0.inv_PI_d8$1_0.VOUT.t1 17.6089
R14205 6to4_0.buff_PI_d32_2.buff_PI_d16$1_0.inv_PI_d8$1_0.VOUT.n44 6to4_0.buff_PI_d32_2.buff_PI_d16$1_0.inv_PI_d8$1_0.VOUT.t5 17.6089
R14206 6to4_0.buff_PI_d32_2.buff_PI_d16$1_0.inv_PI_d8$1_0.VOUT.n47 6to4_0.buff_PI_d32_2.buff_PI_d16$1_0.inv_PI_d8$1_0.VOUT.t3 17.6089
R14207 6to4_0.buff_PI_d32_2.buff_PI_d16$1_0.inv_PI_d8$1_0.VOUT.n50 6to4_0.buff_PI_d32_2.buff_PI_d16$1_0.inv_PI_d8$1_0.VOUT.t6 17.6089
R14208 6to4_0.buff_PI_d32_2.buff_PI_d16$1_0.inv_PI_d8$1_0.VOUT.n53 6to4_0.buff_PI_d32_2.buff_PI_d16$1_0.inv_PI_d8$1_0.VOUT.t0 17.6089
R14209 6to4_0.buff_PI_d32_2.buff_PI_d16$1_0.inv_PI_d8$1_0.VOUT.n56 6to4_0.buff_PI_d32_2.buff_PI_d16$1_0.inv_PI_d8$1_0.VOUT.t4 17.6089
R14210 6to4_0.buff_PI_d32_2.buff_PI_d16$1_0.inv_PI_d8$1_0.VOUT.n41 6to4_0.buff_PI_d32_2.buff_PI_d16$1_0.inv_PI_d8$1_0.VOUT.t7 17.6089
R14211 6to4_0.buff_PI_d32_2.buff_PI_d16$1_0.inv_PI_d8$1_0.inv_PI_d4$1_1.inv_PI_d2$1_1.inv_PI$1_1.VOUT 6to4_0.buff_PI_d32_2.buff_PI_d16$1_0.inv_PI_d8$1_0.VOUT.t15 17.5436
R14212 6to4_0.buff_PI_d32_2.buff_PI_d16$1_0.inv_PI_d8$1_0.VOUT.n34 6to4_0.buff_PI_d32_2.buff_PI_d16$1_0.inv_PI_d8$1_0.VOUT.t12 17.2136
R14213 6to4_0.buff_PI_d32_2.buff_PI_d16$1_0.inv_PI_d8$1_0.VOUT.n55 6to4_0.buff_PI_d32_2.buff_PI_d16$1_0.inv_PI_d8$1_0.VOUT.t10 17.2136
R14214 6to4_0.buff_PI_d32_2.buff_PI_d16$1_0.inv_PI_d8$1_0.VOUT.n54 6to4_0.buff_PI_d32_2.buff_PI_d16$1_0.inv_PI_d8$1_0.VOUT.t18 17.2136
R14215 6to4_0.buff_PI_d32_2.buff_PI_d16$1_0.inv_PI_d8$1_0.VOUT.n52 6to4_0.buff_PI_d32_2.buff_PI_d16$1_0.inv_PI_d8$1_0.VOUT.t11 17.2136
R14216 6to4_0.buff_PI_d32_2.buff_PI_d16$1_0.inv_PI_d8$1_0.VOUT.n51 6to4_0.buff_PI_d32_2.buff_PI_d16$1_0.inv_PI_d8$1_0.VOUT.t20 17.2136
R14217 6to4_0.buff_PI_d32_2.buff_PI_d16$1_0.inv_PI_d8$1_0.VOUT.n49 6to4_0.buff_PI_d32_2.buff_PI_d16$1_0.inv_PI_d8$1_0.VOUT.t14 17.2136
R14218 6to4_0.buff_PI_d32_2.buff_PI_d16$1_0.inv_PI_d8$1_0.VOUT.n48 6to4_0.buff_PI_d32_2.buff_PI_d16$1_0.inv_PI_d8$1_0.VOUT.t21 17.2136
R14219 6to4_0.buff_PI_d32_2.buff_PI_d16$1_0.inv_PI_d8$1_0.VOUT.n46 6to4_0.buff_PI_d32_2.buff_PI_d16$1_0.inv_PI_d8$1_0.VOUT.t8 17.2136
R14220 6to4_0.buff_PI_d32_2.buff_PI_d16$1_0.inv_PI_d8$1_0.VOUT.n45 6to4_0.buff_PI_d32_2.buff_PI_d16$1_0.inv_PI_d8$1_0.VOUT.t16 17.2136
R14221 6to4_0.buff_PI_d32_2.buff_PI_d16$1_0.inv_PI_d8$1_0.VOUT.n43 6to4_0.buff_PI_d32_2.buff_PI_d16$1_0.inv_PI_d8$1_0.VOUT.t23 17.2136
R14222 6to4_0.buff_PI_d32_2.buff_PI_d16$1_0.inv_PI_d8$1_0.VOUT.n42 6to4_0.buff_PI_d32_2.buff_PI_d16$1_0.inv_PI_d8$1_0.VOUT.t9 17.2136
R14223 6to4_0.buff_PI_d32_2.buff_PI_d16$1_0.inv_PI_d8$1_0.VOUT.n40 6to4_0.buff_PI_d32_2.buff_PI_d16$1_0.inv_PI_d8$1_0.VOUT.t17 17.2136
R14224 6to4_0.buff_PI_d32_2.buff_PI_d16$1_0.inv_PI_d8$1_0.VOUT.n39 6to4_0.buff_PI_d32_2.buff_PI_d16$1_0.inv_PI_d8$1_0.VOUT.t19 17.2136
R14225 6to4_0.buff_PI_d32_2.buff_PI_d16$1_0.inv_PI_d8$1_0.VOUT.n37 6to4_0.buff_PI_d32_2.buff_PI_d16$1_0.inv_PI_d8$1_0.VOUT.t22 17.2136
R14226 6to4_0.buff_PI_d32_2.buff_PI_d16$1_0.inv_PI_d8$1_0.VOUT.n36 6to4_0.buff_PI_d32_2.buff_PI_d16$1_0.inv_PI_d8$1_0.VOUT.t13 17.2136
R14227 6to4_0.buff_PI_d32_2.buff_PI_d16$1_0.inv_PI_d8$1_0.VOUT.n31 6to4_0.buff_PI_d32_2.buff_PI_d16$1_0.inv_PI_d8$1_0.VOUT.t24 15.0005
R14228 6to4_0.buff_PI_d32_2.buff_PI_d16$1_0.inv_PI_d8$1_0.VOUT.n27 6to4_0.buff_PI_d32_2.buff_PI_d16$1_0.inv_PI_d8$1_0.VOUT.t29 15.0005
R14229 6to4_0.buff_PI_d32_2.buff_PI_d16$1_0.inv_PI_d8$1_0.VOUT.n25 6to4_0.buff_PI_d32_2.buff_PI_d16$1_0.inv_PI_d8$1_0.VOUT.t37 15.0005
R14230 6to4_0.buff_PI_d32_2.buff_PI_d16$1_0.inv_PI_d8$1_0.VOUT.n21 6to4_0.buff_PI_d32_2.buff_PI_d16$1_0.inv_PI_d8$1_0.VOUT.t38 15.0005
R14231 6to4_0.buff_PI_d32_2.buff_PI_d16$1_0.inv_PI_d8$1_0.VOUT.n19 6to4_0.buff_PI_d32_2.buff_PI_d16$1_0.inv_PI_d8$1_0.VOUT.t34 15.0005
R14232 6to4_0.buff_PI_d32_2.buff_PI_d16$1_0.inv_PI_d8$1_0.VOUT.n10 6to4_0.buff_PI_d32_2.buff_PI_d16$1_0.inv_PI_d8$1_0.VOUT.t33 15.0005
R14233 6to4_0.buff_PI_d32_2.buff_PI_d16$1_0.inv_PI_d8$1_0.VOUT.n9 6to4_0.buff_PI_d32_2.buff_PI_d16$1_0.inv_PI_d8$1_0.VOUT.t31 15.0005
R14234 6to4_0.buff_PI_d32_2.buff_PI_d16$1_0.inv_PI_d8$1_0.VOUT.n15 6to4_0.buff_PI_d32_2.buff_PI_d16$1_0.inv_PI_d8$1_0.VOUT.t27 15.0005
R14235 6to4_0.buff_PI_d32_2.buff_PI_d16$1_0.inv_PI_d8$1_0.VOUT.n14 6to4_0.buff_PI_d32_2.buff_PI_d16$1_0.inv_PI_d8$1_0.VOUT.t39 15.0005
R14236 6to4_0.buff_PI_d32_2.buff_PI_d16$1_0.inv_PI_d8$1_0.VOUT.n5 6to4_0.buff_PI_d32_2.buff_PI_d16$1_0.inv_PI_d8$1_0.VOUT.t28 15.0005
R14237 6to4_0.buff_PI_d32_2.buff_PI_d16$1_0.inv_PI_d8$1_0.VOUT.n12 6to4_0.buff_PI_d32_2.buff_PI_d16$1_0.inv_PI_d8$1_0.VOUT.t25 15.0005
R14238 6to4_0.buff_PI_d32_2.buff_PI_d16$1_0.inv_PI_d8$1_0.VOUT.n0 6to4_0.buff_PI_d32_2.buff_PI_d16$1_0.inv_PI_d8$1_0.VOUT.t26 15.0005
R14239 6to4_0.buff_PI_d32_2.buff_PI_d16$1_0.inv_PI_d8$1_0.VOUT.n7 6to4_0.buff_PI_d32_2.buff_PI_d16$1_0.inv_PI_d8$1_0.VOUT.t32 15.0005
R14240 6to4_0.buff_PI_d32_2.buff_PI_d16$1_0.inv_PI_d8$1_0.VOUT.n2 6to4_0.buff_PI_d32_2.buff_PI_d16$1_0.inv_PI_d8$1_0.VOUT.t36 15.0005
R14241 6to4_0.buff_PI_d32_2.buff_PI_d16$1_0.inv_PI_d8$1_0.VOUT.n3 6to4_0.buff_PI_d32_2.buff_PI_d16$1_0.inv_PI_d8$1_0.VOUT.t35 15.0005
R14242 6to4_0.buff_PI_d32_2.buff_PI_d16$1_0.inv_PI_d8$1_0.VOUT.n33 6to4_0.buff_PI_d32_2.buff_PI_d16$1_0.inv_PI_d8$1_0.VOUT.t30 15.0005
R14243 6to4_0.buff_PI_d32_2.buff_PI_d16$1_0.inv_PI_d8$1_0.VOUT.n11 6to4_0.buff_PI_d32_2.buff_PI_d16$1_0.inv_PI_d8$1_0.VOUT.n9 10.3469
R14244 6to4_0.buff_PI_d32_2.buff_PI_d16$1_0.inv_PI_d8$1_0.VOUT.n16 6to4_0.buff_PI_d32_2.buff_PI_d16$1_0.inv_PI_d8$1_0.VOUT.n14 10.3469
R14245 6to4_0.buff_PI_d32_2.buff_PI_d16$1_0.inv_PI_d8$1_0.VOUT.n4 6to4_0.buff_PI_d32_2.buff_PI_d16$1_0.inv_PI_d8$1_0.VOUT.n2 10.3469
R14246 6to4_0.buff_PI_d32_2.buff_PI_d16$1_0.inv_PI_d8$1_0.VOUT.n33 6to4_0.buff_PI_d32_2.buff_PI_d16$1_0.inv_PI_d8$1_0.VOUT.n32 10.3469
R14247 6to4_0.buff_PI_d32_2.buff_PI_d16$1_0.inv_PI_d8$1_0.VOUT.n11 6to4_0.buff_PI_d32_2.buff_PI_d16$1_0.inv_PI_d8$1_0.VOUT.n10 9.0005
R14248 6to4_0.buff_PI_d32_2.buff_PI_d16$1_0.inv_PI_d8$1_0.VOUT.n13 6to4_0.buff_PI_d32_2.buff_PI_d16$1_0.inv_PI_d8$1_0.VOUT.n12 9.0005
R14249 6to4_0.buff_PI_d32_2.buff_PI_d16$1_0.inv_PI_d8$1_0.VOUT.n6 6to4_0.buff_PI_d32_2.buff_PI_d16$1_0.inv_PI_d8$1_0.VOUT.n5 9.0005
R14250 6to4_0.buff_PI_d32_2.buff_PI_d16$1_0.inv_PI_d8$1_0.VOUT.n16 6to4_0.buff_PI_d32_2.buff_PI_d16$1_0.inv_PI_d8$1_0.VOUT.n15 9.0005
R14251 6to4_0.buff_PI_d32_2.buff_PI_d16$1_0.inv_PI_d8$1_0.VOUT.n8 6to4_0.buff_PI_d32_2.buff_PI_d16$1_0.inv_PI_d8$1_0.VOUT.n7 9.0005
R14252 6to4_0.buff_PI_d32_2.buff_PI_d16$1_0.inv_PI_d8$1_0.VOUT.n1 6to4_0.buff_PI_d32_2.buff_PI_d16$1_0.inv_PI_d8$1_0.VOUT.n0 9.0005
R14253 6to4_0.buff_PI_d32_2.buff_PI_d16$1_0.inv_PI_d8$1_0.VOUT.n20 6to4_0.buff_PI_d32_2.buff_PI_d16$1_0.inv_PI_d8$1_0.VOUT.n19 9.0005
R14254 6to4_0.buff_PI_d32_2.buff_PI_d16$1_0.inv_PI_d8$1_0.VOUT.n22 6to4_0.buff_PI_d32_2.buff_PI_d16$1_0.inv_PI_d8$1_0.VOUT.n21 9.0005
R14255 6to4_0.buff_PI_d32_2.buff_PI_d16$1_0.inv_PI_d8$1_0.VOUT.n4 6to4_0.buff_PI_d32_2.buff_PI_d16$1_0.inv_PI_d8$1_0.VOUT.n3 9.0005
R14256 6to4_0.buff_PI_d32_2.buff_PI_d16$1_0.inv_PI_d8$1_0.VOUT.n26 6to4_0.buff_PI_d32_2.buff_PI_d16$1_0.inv_PI_d8$1_0.VOUT.n25 9.0005
R14257 6to4_0.buff_PI_d32_2.buff_PI_d16$1_0.inv_PI_d8$1_0.VOUT.n28 6to4_0.buff_PI_d32_2.buff_PI_d16$1_0.inv_PI_d8$1_0.VOUT.n27 9.0005
R14258 6to4_0.buff_PI_d32_2.buff_PI_d16$1_0.inv_PI_d8$1_0.VOUT.n32 6to4_0.buff_PI_d32_2.buff_PI_d16$1_0.inv_PI_d8$1_0.VOUT.n31 9.0005
R14259 6to4_0.buff_PI_d32_2.buff_PI_d16$1_0.inv_PI_d8$1_0.VOUT.n34 6to4_0.buff_PI_d32_2.buff_PI_d16$1_0.inv_PI_d16$1_0.inv_PI_d8$1_1.inv_PI_d4$1_1.inv_PI_d2$1_1.inv_PI$1_1.VIN 1.53363
R14260 6to4_0.buff_PI_d32_2.buff_PI_d16$1_0.inv_PI_d8$1_0.VOUT.n52 6to4_0.buff_PI_d32_2.buff_PI_d16$1_0.inv_PI_d8$1_0.VOUT.n51 1.41675
R14261 6to4_0.buff_PI_d32_2.buff_PI_d16$1_0.inv_PI_d8$1_0.VOUT.n46 6to4_0.buff_PI_d32_2.buff_PI_d16$1_0.inv_PI_d8$1_0.VOUT.n45 1.41675
R14262 6to4_0.buff_PI_d32_2.buff_PI_d16$1_0.inv_PI_d8$1_0.VOUT.n40 6to4_0.buff_PI_d32_2.buff_PI_d16$1_0.inv_PI_d8$1_0.VOUT.n39 1.41675
R14263 6to4_0.buff_PI_d32_2.buff_PI_d16$1_0.inv_PI_d8$1_0.VOUT.n13 6to4_0.buff_PI_d32_2.buff_PI_d16$1_0.inv_PI_d8$1_0.VOUT.n6 1.3469
R14264 6to4_0.buff_PI_d32_2.buff_PI_d16$1_0.inv_PI_d8$1_0.VOUT.n8 6to4_0.buff_PI_d32_2.buff_PI_d16$1_0.inv_PI_d8$1_0.VOUT.n1 1.3469
R14265 6to4_0.buff_PI_d32_2.buff_PI_d16$1_0.inv_PI_d8$1_0.VOUT.n22 6to4_0.buff_PI_d32_2.buff_PI_d16$1_0.inv_PI_d8$1_0.VOUT.n20 1.3469
R14266 6to4_0.buff_PI_d32_2.buff_PI_d16$1_0.inv_PI_d8$1_0.VOUT.n28 6to4_0.buff_PI_d32_2.buff_PI_d16$1_0.inv_PI_d8$1_0.VOUT.n26 1.3469
R14267 6to4_0.buff_PI_d32_2.buff_PI_d16$1_0.inv_PI_d8$1_0.VOUT.n18 6to4_0.buff_PI_d32_2.buff_PI_d16$1_0.inv_PI_d8$1_0.VOUT.n17 0.67839
R14268 6to4_0.buff_PI_d32_2.buff_PI_d16$1_0.inv_PI_d8$1_0.VOUT.n24 6to4_0.buff_PI_d32_2.buff_PI_d16$1_0.inv_PI_d8$1_0.VOUT.n23 0.67839
R14269 6to4_0.buff_PI_d32_2.buff_PI_d16$1_0.inv_PI_d8$1_0.VOUT.n55 6to4_0.buff_PI_d32_2.buff_PI_d16$1_0.inv_PI_d8$1_0.VOUT.n54 0.633
R14270 6to4_0.buff_PI_d32_2.buff_PI_d16$1_0.inv_PI_d8$1_0.VOUT.n49 6to4_0.buff_PI_d32_2.buff_PI_d16$1_0.inv_PI_d8$1_0.VOUT.n48 0.633
R14271 6to4_0.buff_PI_d32_2.buff_PI_d16$1_0.inv_PI_d8$1_0.VOUT.n43 6to4_0.buff_PI_d32_2.buff_PI_d16$1_0.inv_PI_d8$1_0.VOUT.n42 0.633
R14272 6to4_0.buff_PI_d32_2.buff_PI_d16$1_0.inv_PI_d8$1_0.VOUT.n37 6to4_0.buff_PI_d32_2.buff_PI_d16$1_0.inv_PI_d8$1_0.VOUT.n36 0.633
R14273 6to4_0.buff_PI_d32_2.buff_PI_d16$1_0.inv_PI_d8$1_0.VOUT.n54 6to4_0.buff_PI_d32_2.buff_PI_d16$1_0.inv_PI_d8$1_0.VOUT.n53 0.392375
R14274 6to4_0.buff_PI_d32_2.buff_PI_d16$1_0.inv_PI_d8$1_0.VOUT.n48 6to4_0.buff_PI_d32_2.buff_PI_d16$1_0.inv_PI_d8$1_0.VOUT.n47 0.392375
R14275 6to4_0.buff_PI_d32_2.buff_PI_d16$1_0.inv_PI_d8$1_0.VOUT.n42 6to4_0.buff_PI_d32_2.buff_PI_d16$1_0.inv_PI_d8$1_0.VOUT.n41 0.392375
R14276 6to4_0.buff_PI_d32_2.buff_PI_d16$1_0.inv_PI_d8$1_0.VOUT.n36 6to4_0.buff_PI_d32_2.buff_PI_d16$1_0.inv_PI_d8$1_0.VOUT.n35 0.392375
R14277 6to4_0.buff_PI_d32_2.buff_PI_d16$1_0.inv_PI_d8$1_0.VOUT.n18 6to4_0.buff_PI_d32_2.buff_PI_d16$1_0.inv_PI_d8$1_0.VOUT.n11 0.3855
R14278 6to4_0.buff_PI_d32_2.buff_PI_d16$1_0.inv_PI_d8$1_0.VOUT.n24 6to4_0.buff_PI_d32_2.buff_PI_d16$1_0.inv_PI_d8$1_0.VOUT.n6 0.3855
R14279 6to4_0.buff_PI_d32_2.buff_PI_d16$1_0.inv_PI_d8$1_0.VOUT.n17 6to4_0.buff_PI_d32_2.buff_PI_d16$1_0.inv_PI_d8$1_0.VOUT.n16 0.3855
R14280 6to4_0.buff_PI_d32_2.buff_PI_d16$1_0.inv_PI_d8$1_0.VOUT.n30 6to4_0.buff_PI_d32_2.buff_PI_d16$1_0.inv_PI_d8$1_0.VOUT.n1 0.3855
R14281 6to4_0.buff_PI_d32_2.buff_PI_d16$1_0.inv_PI_d8$1_0.VOUT.n23 6to4_0.buff_PI_d32_2.buff_PI_d16$1_0.inv_PI_d8$1_0.VOUT.n22 0.3855
R14282 6to4_0.buff_PI_d32_2.buff_PI_d16$1_0.inv_PI_d8$1_0.VOUT.n29 6to4_0.buff_PI_d32_2.buff_PI_d16$1_0.inv_PI_d8$1_0.VOUT.n28 0.3855
R14283 6to4_0.buff_PI_d32_2.buff_PI_d16$1_0.inv_PI_d8$1_0.VOUT.n17 6to4_0.buff_PI_d32_2.buff_PI_d16$1_0.inv_PI_d8$1_0.VOUT.n13 0.3833
R14284 6to4_0.buff_PI_d32_2.buff_PI_d16$1_0.inv_PI_d8$1_0.VOUT.n23 6to4_0.buff_PI_d32_2.buff_PI_d16$1_0.inv_PI_d8$1_0.VOUT.n8 0.3833
R14285 6to4_0.buff_PI_d32_2.buff_PI_d16$1_0.inv_PI_d8$1_0.VOUT.n20 6to4_0.buff_PI_d32_2.buff_PI_d16$1_0.inv_PI_d8$1_0.VOUT.n18 0.3833
R14286 6to4_0.buff_PI_d32_2.buff_PI_d16$1_0.inv_PI_d8$1_0.VOUT.n29 6to4_0.buff_PI_d32_2.buff_PI_d16$1_0.inv_PI_d8$1_0.VOUT.n4 0.3833
R14287 6to4_0.buff_PI_d32_2.buff_PI_d16$1_0.inv_PI_d8$1_0.VOUT.n26 6to4_0.buff_PI_d32_2.buff_PI_d16$1_0.inv_PI_d8$1_0.VOUT.n24 0.3833
R14288 6to4_0.buff_PI_d32_2.buff_PI_d16$1_0.inv_PI_d8$1_0.VOUT.n32 6to4_0.buff_PI_d32_2.buff_PI_d16$1_0.inv_PI_d8$1_0.VOUT.n30 0.3833
R14289 6to4_0.buff_PI_d32_2.buff_PI_d16$1_0.inv_PI_d8$1_0.VOUT.n56 6to4_0.buff_PI_d32_2.buff_PI_d16$1_0.inv_PI_d8$1_0.inv_PI_d4$1_0.inv_PI_d2$1_0.VOUT 0.358
R14290 6to4_0.buff_PI_d32_2.buff_PI_d16$1_0.inv_PI_d8$1_0.VOUT.n50 6to4_0.buff_PI_d32_2.buff_PI_d16$1_0.inv_PI_d8$1_0.inv_PI_d4$1_0.inv_PI_d2$1_1.VOUT 0.358
R14291 6to4_0.buff_PI_d32_2.buff_PI_d16$1_0.inv_PI_d8$1_0.VOUT.n44 6to4_0.buff_PI_d32_2.buff_PI_d16$1_0.inv_PI_d8$1_0.inv_PI_d4$1_1.inv_PI_d2$1_0.VOUT 0.358
R14292 6to4_0.buff_PI_d32_2.buff_PI_d16$1_0.inv_PI_d8$1_0.VOUT.n38 6to4_0.buff_PI_d32_2.buff_PI_d16$1_0.inv_PI_d8$1_0.inv_PI_d4$1_1.inv_PI_d2$1_1.VOUT 0.358
R14293 6to4_0.buff_PI_d32_2.buff_PI_d16$1_0.inv_PI_d8$1_0.inv_PI_d4$1_0.inv_PI_d2$1_0.inv_PI$1_1.VOUT 6to4_0.buff_PI_d32_2.buff_PI_d16$1_0.inv_PI_d8$1_0.VOUT.n52 0.3305
R14294 6to4_0.buff_PI_d32_2.buff_PI_d16$1_0.inv_PI_d8$1_0.VOUT.n51 6to4_0.buff_PI_d32_2.buff_PI_d16$1_0.inv_PI_d8$1_0.inv_PI_d4$1_0.inv_PI_d2$1_1.inv_PI$1_0.VOUT 0.3305
R14295 6to4_0.buff_PI_d32_2.buff_PI_d16$1_0.inv_PI_d8$1_0.inv_PI_d4$1_0.inv_PI_d2$1_1.inv_PI$1_1.VOUT 6to4_0.buff_PI_d32_2.buff_PI_d16$1_0.inv_PI_d8$1_0.VOUT.n46 0.3305
R14296 6to4_0.buff_PI_d32_2.buff_PI_d16$1_0.inv_PI_d8$1_0.inv_PI_d4$1_1.inv_PI_d2$1_0.inv_PI$1_1.VOUT 6to4_0.buff_PI_d32_2.buff_PI_d16$1_0.inv_PI_d8$1_0.VOUT.n40 0.3305
R14297 6to4_0.buff_PI_d32_2.buff_PI_d16$1_0.inv_PI_d8$1_0.VOUT.n39 6to4_0.buff_PI_d32_2.buff_PI_d16$1_0.inv_PI_d8$1_0.inv_PI_d4$1_1.inv_PI_d2$1_1.inv_PI$1_0.VOUT 0.3305
R14298 6to4_0.buff_PI_d32_2.buff_PI_d16$1_0.inv_PI_d8$1_0.inv_PI_d4$1_0.VOUT 6to4_0.buff_PI_d32_2.buff_PI_d16$1_0.inv_PI_d8$1_0.inv_PI_d4$1_0.inv_PI_d2$1_0.inv_PI$1_0.VOUT 0.217062
R14299 6to4_0.buff_PI_d32_2.buff_PI_d16$1_0.inv_PI_d8$1_0.inv_PI_d4$1_1.VOUT 6to4_0.buff_PI_d32_2.buff_PI_d16$1_0.inv_PI_d8$1_0.inv_PI_d4$1_1.inv_PI_d2$1_0.inv_PI$1_0.VOUT 0.217062
R14300 6to4_0.buff_PI_d32_2.buff_PI_d16$1_0.inv_PI_d8$1_0.inv_PI_d4$1_0.VOUT 6to4_0.buff_PI_d32_2.buff_PI_d16$1_0.inv_PI_d8$1_0.VOUT.n34 0.113938
R14301 6to4_0.buff_PI_d32_2.buff_PI_d16$1_0.inv_PI_d8$1_0.VOUT.n45 6to4_0.buff_PI_d32_2.buff_PI_d16$1_0.inv_PI_d8$1_0.inv_PI_d4$1_1.VOUT 0.113938
R14302 6to4_0.buff_PI_d32_2.buff_PI_d16$1_0.inv_PI_d16$1_0.VIN 6to4_0.buff_PI_d32_2.buff_PI_d16$1_0.inv_PI_d8$1_0.VOUT.n29 0.0662582
R14303 6to4_0.buff_PI_d32_2.buff_PI_d16$1_0.inv_PI_d8$1_0.inv_PI_d4$1_0.inv_PI_d2$1_0.inv_PI$1_0.VOUT 6to4_0.buff_PI_d32_2.buff_PI_d16$1_0.inv_PI_d8$1_0.VOUT.n56 0.062375
R14304 6to4_0.buff_PI_d32_2.buff_PI_d16$1_0.inv_PI_d8$1_0.VOUT.n53 6to4_0.buff_PI_d32_2.buff_PI_d16$1_0.inv_PI_d8$1_0.inv_PI_d4$1_0.inv_PI_d2$1_0.inv_PI$1_1.VOUT 0.062375
R14305 6to4_0.buff_PI_d32_2.buff_PI_d16$1_0.inv_PI_d8$1_0.inv_PI_d4$1_0.inv_PI_d2$1_1.inv_PI$1_0.VOUT 6to4_0.buff_PI_d32_2.buff_PI_d16$1_0.inv_PI_d8$1_0.VOUT.n50 0.062375
R14306 6to4_0.buff_PI_d32_2.buff_PI_d16$1_0.inv_PI_d8$1_0.VOUT.n47 6to4_0.buff_PI_d32_2.buff_PI_d16$1_0.inv_PI_d8$1_0.inv_PI_d4$1_0.inv_PI_d2$1_1.inv_PI$1_1.VOUT 0.062375
R14307 6to4_0.buff_PI_d32_2.buff_PI_d16$1_0.inv_PI_d8$1_0.inv_PI_d4$1_1.inv_PI_d2$1_0.inv_PI$1_0.VOUT 6to4_0.buff_PI_d32_2.buff_PI_d16$1_0.inv_PI_d8$1_0.VOUT.n44 0.062375
R14308 6to4_0.buff_PI_d32_2.buff_PI_d16$1_0.inv_PI_d8$1_0.VOUT.n41 6to4_0.buff_PI_d32_2.buff_PI_d16$1_0.inv_PI_d8$1_0.inv_PI_d4$1_1.inv_PI_d2$1_0.inv_PI$1_1.VOUT 0.062375
R14309 6to4_0.buff_PI_d32_2.buff_PI_d16$1_0.inv_PI_d8$1_0.inv_PI_d4$1_1.inv_PI_d2$1_1.inv_PI$1_0.VOUT 6to4_0.buff_PI_d32_2.buff_PI_d16$1_0.inv_PI_d8$1_0.VOUT.n38 0.062375
R14310 6to4_0.buff_PI_d32_2.buff_PI_d16$1_0.inv_PI_d8$1_0.VOUT.n35 6to4_0.buff_PI_d32_2.buff_PI_d16$1_0.inv_PI_d8$1_0.inv_PI_d4$1_1.inv_PI_d2$1_1.inv_PI$1_1.VOUT 0.062375
R14311 6to4_0.buff_PI_d32_2.buff_PI_d16$1_0.inv_PI_d8$1_0.VOUT.n30 6to4_0.buff_PI_d32_2.buff_PI_d16$1_0.inv_PI_d16$1_0.VIN 0.059489
R14312 6to4_0.buff_PI_d32_2.buff_PI_d16$1_0.inv_PI_d8$1_0.VOUT.n31 6to4_0.buff_PI_d32_2.buff_PI_d16$1_0.inv_PI_d16$1_0.inv_PI_d8$1_1.inv_PI_d4$1_1.inv_PI_d2$1_1.inv_PI$1_0.VIN 0.0555
R14313 6to4_0.buff_PI_d32_2.buff_PI_d16$1_0.inv_PI_d8$1_0.VOUT.n25 6to4_0.buff_PI_d32_2.buff_PI_d16$1_0.inv_PI_d16$1_0.inv_PI_d8$1_0.inv_PI_d4$1_1.inv_PI_d2$1_0.inv_PI$1_0.VIN 0.0555
R14314 6to4_0.buff_PI_d32_2.buff_PI_d16$1_0.inv_PI_d8$1_0.VOUT.n19 6to4_0.buff_PI_d32_2.buff_PI_d16$1_0.inv_PI_d16$1_0.inv_PI_d8$1_1.inv_PI_d4$1_0.inv_PI_d2$1_1.inv_PI$1_0.VIN 0.0555
R14315 6to4_0.buff_PI_d32_2.buff_PI_d16$1_0.inv_PI_d8$1_0.VOUT.n9 6to4_0.buff_PI_d32_2.buff_PI_d16$1_0.inv_PI_d16$1_0.inv_PI_d8$1_1.inv_PI_d4$1_0.inv_PI_d2$1_0.inv_PI$1_0.VIN 0.0555
R14316 6to4_0.buff_PI_d32_2.buff_PI_d16$1_0.inv_PI_d8$1_0.VOUT.n14 6to4_0.buff_PI_d32_2.buff_PI_d16$1_0.inv_PI_d16$1_0.inv_PI_d8$1_0.inv_PI_d4$1_0.inv_PI_d2$1_0.inv_PI$1_0.VIN 0.0555
R14317 6to4_0.buff_PI_d32_2.buff_PI_d16$1_0.inv_PI_d8$1_0.VOUT.n12 6to4_0.buff_PI_d32_2.buff_PI_d16$1_0.inv_PI_d16$1_0.inv_PI_d8$1_0.inv_PI_d4$1_0.inv_PI_d2$1_1.inv_PI$1_0.VIN 0.0555
R14318 6to4_0.buff_PI_d32_2.buff_PI_d16$1_0.inv_PI_d8$1_0.VOUT.n7 6to4_0.buff_PI_d32_2.buff_PI_d16$1_0.inv_PI_d16$1_0.inv_PI_d8$1_1.inv_PI_d4$1_1.inv_PI_d2$1_0.inv_PI$1_0.VIN 0.0555
R14319 6to4_0.buff_PI_d32_2.buff_PI_d16$1_0.inv_PI_d8$1_0.VOUT.n3 6to4_0.buff_PI_d32_2.buff_PI_d16$1_0.inv_PI_d16$1_0.inv_PI_d8$1_0.inv_PI_d4$1_1.inv_PI_d2$1_1.inv_PI$1_0.VIN 0.0555
R14320 6to4_0.buff_PI_d32_2.buff_PI_d16$1_0.inv_PI_d16$1_0.inv_PI_d8$1_0.inv_PI_d4$1_1.inv_PI_d2$1_0.VIN 6to4_0.buff_PI_d32_2.buff_PI_d16$1_0.inv_PI_d16$1_0.inv_PI_d8$1_0.inv_PI_d4$1_1.inv_PI_d2$1_0.inv_PI$1_1.VIN 0.0445
R14321 6to4_0.buff_PI_d32_2.buff_PI_d16$1_0.inv_PI_d16$1_0.inv_PI_d8$1_1.inv_PI_d4$1_0.inv_PI_d2$1_0.VIN 6to4_0.buff_PI_d32_2.buff_PI_d16$1_0.inv_PI_d16$1_0.inv_PI_d8$1_1.inv_PI_d4$1_0.inv_PI_d2$1_0.inv_PI$1_1.VIN 0.0445
R14322 6to4_0.buff_PI_d32_2.buff_PI_d16$1_0.inv_PI_d16$1_0.inv_PI_d8$1_0.inv_PI_d4$1_0.inv_PI_d2$1_0.VIN 6to4_0.buff_PI_d32_2.buff_PI_d16$1_0.inv_PI_d16$1_0.inv_PI_d8$1_0.inv_PI_d4$1_0.inv_PI_d2$1_0.inv_PI$1_1.VIN 0.0445
R14323 6to4_0.buff_PI_d32_2.buff_PI_d16$1_0.inv_PI_d16$1_0.inv_PI_d8$1_1.inv_PI_d4$1_1.inv_PI_d2$1_0.VIN 6to4_0.buff_PI_d32_2.buff_PI_d16$1_0.inv_PI_d16$1_0.inv_PI_d8$1_1.inv_PI_d4$1_1.inv_PI_d2$1_0.inv_PI$1_1.VIN 0.0445
R14324 6to4_0.buff_PI_d32_2.buff_PI_d16$1_0.inv_PI_d16$1_0.inv_PI_d8$1_1.inv_PI_d4$1_0.VIN 6to4_0.buff_PI_d32_2.buff_PI_d16$1_0.inv_PI_d16$1_0.inv_PI_d8$1_1.inv_PI_d4$1_0.inv_PI_d2$1_1.inv_PI$1_1.VIN 0.0371667
R14325 6to4_0.buff_PI_d32_2.buff_PI_d16$1_0.inv_PI_d16$1_0.inv_PI_d8$1_0.inv_PI_d4$1_0.VIN 6to4_0.buff_PI_d32_2.buff_PI_d16$1_0.inv_PI_d16$1_0.inv_PI_d8$1_0.inv_PI_d4$1_0.inv_PI_d2$1_1.inv_PI$1_1.VIN 0.0371667
R14326 6to4_0.buff_PI_d32_2.buff_PI_d16$1_0.inv_PI_d16$1_0.inv_PI_d8$1_0.inv_PI_d4$1_1.VIN 6to4_0.buff_PI_d32_2.buff_PI_d16$1_0.inv_PI_d16$1_0.inv_PI_d8$1_0.inv_PI_d4$1_1.inv_PI_d2$1_1.inv_PI$1_1.VIN 0.0371667
R14327 6to4_0.buff_PI_d32_2.buff_PI_d16$1_0.inv_PI_d16$1_0.inv_PI_d8$1_1.inv_PI_d4$1_1.inv_PI_d2$1_1.inv_PI$1_1.VIN 6to4_0.buff_PI_d32_2.buff_PI_d16$1_0.inv_PI_d16$1_0.inv_PI_d8$1_1.inv_PI_d4$1_1.VIN 0.0371667
R14328 6to4_0.buff_PI_d32_2.buff_PI_d16$1_0.inv_PI_d8$1_0.inv_PI_d4$1_0.inv_PI_d2$1_0.VOUT 6to4_0.buff_PI_d32_2.buff_PI_d16$1_0.inv_PI_d8$1_0.VOUT.n55 0.034875
R14329 6to4_0.buff_PI_d32_2.buff_PI_d16$1_0.inv_PI_d8$1_0.inv_PI_d4$1_0.inv_PI_d2$1_1.VOUT 6to4_0.buff_PI_d32_2.buff_PI_d16$1_0.inv_PI_d8$1_0.VOUT.n49 0.034875
R14330 6to4_0.buff_PI_d32_2.buff_PI_d16$1_0.inv_PI_d8$1_0.inv_PI_d4$1_1.inv_PI_d2$1_0.VOUT 6to4_0.buff_PI_d32_2.buff_PI_d16$1_0.inv_PI_d8$1_0.VOUT.n43 0.034875
R14331 6to4_0.buff_PI_d32_2.buff_PI_d16$1_0.inv_PI_d8$1_0.inv_PI_d4$1_1.inv_PI_d2$1_1.VOUT 6to4_0.buff_PI_d32_2.buff_PI_d16$1_0.inv_PI_d8$1_0.VOUT.n37 0.034875
R14332 6to4_0.buff_PI_d32_2.buff_PI_d16$1_0.inv_PI_d8$1_0.VOUT.n27 6to4_0.buff_PI_d32_2.buff_PI_d16$1_0.inv_PI_d16$1_0.inv_PI_d8$1_0.inv_PI_d4$1_1.inv_PI_d2$1_0.VIN 0.0115
R14333 6to4_0.buff_PI_d32_2.buff_PI_d16$1_0.inv_PI_d8$1_0.VOUT.n21 6to4_0.buff_PI_d32_2.buff_PI_d16$1_0.inv_PI_d16$1_0.inv_PI_d8$1_1.inv_PI_d4$1_0.inv_PI_d2$1_1.VIN 0.0115
R14334 6to4_0.buff_PI_d32_2.buff_PI_d16$1_0.inv_PI_d8$1_0.VOUT.n10 6to4_0.buff_PI_d32_2.buff_PI_d16$1_0.inv_PI_d16$1_0.inv_PI_d8$1_1.inv_PI_d4$1_0.inv_PI_d2$1_0.VIN 0.0115
R14335 6to4_0.buff_PI_d32_2.buff_PI_d16$1_0.inv_PI_d8$1_0.VOUT.n15 6to4_0.buff_PI_d32_2.buff_PI_d16$1_0.inv_PI_d16$1_0.inv_PI_d8$1_0.inv_PI_d4$1_0.inv_PI_d2$1_0.VIN 0.0115
R14336 6to4_0.buff_PI_d32_2.buff_PI_d16$1_0.inv_PI_d8$1_0.VOUT.n5 6to4_0.buff_PI_d32_2.buff_PI_d16$1_0.inv_PI_d16$1_0.inv_PI_d8$1_0.inv_PI_d4$1_0.inv_PI_d2$1_1.VIN 0.0115
R14337 6to4_0.buff_PI_d32_2.buff_PI_d16$1_0.inv_PI_d8$1_0.VOUT.n0 6to4_0.buff_PI_d32_2.buff_PI_d16$1_0.inv_PI_d16$1_0.inv_PI_d8$1_1.inv_PI_d4$1_1.inv_PI_d2$1_0.VIN 0.0115
R14338 6to4_0.buff_PI_d32_2.buff_PI_d16$1_0.inv_PI_d8$1_0.VOUT.n2 6to4_0.buff_PI_d32_2.buff_PI_d16$1_0.inv_PI_d16$1_0.inv_PI_d8$1_0.inv_PI_d4$1_1.inv_PI_d2$1_1.VIN 0.0115
R14339 6to4_0.buff_PI_d32_2.buff_PI_d16$1_0.inv_PI_d16$1_0.inv_PI_d8$1_1.inv_PI_d4$1_1.inv_PI_d2$1_1.VIN 6to4_0.buff_PI_d32_2.buff_PI_d16$1_0.inv_PI_d8$1_0.VOUT.n33 0.0115
R14340 6to4_0.buff_PI_d32_2.buff_PI_d16$1_0.inv_PI_d16$1_0.inv_PI_d8$1_1.inv_PI_d4$1_0.inv_PI_d2$1_1.VIN 6to4_0.buff_PI_d32_2.buff_PI_d16$1_0.inv_PI_d16$1_0.inv_PI_d8$1_1.inv_PI_d4$1_0.VIN 0.00783333
R14341 6to4_0.buff_PI_d32_2.buff_PI_d16$1_0.inv_PI_d16$1_0.inv_PI_d8$1_0.inv_PI_d4$1_0.inv_PI_d2$1_1.VIN 6to4_0.buff_PI_d32_2.buff_PI_d16$1_0.inv_PI_d16$1_0.inv_PI_d8$1_0.inv_PI_d4$1_0.VIN 0.00783333
R14342 6to4_0.buff_PI_d32_2.buff_PI_d16$1_0.inv_PI_d16$1_0.inv_PI_d8$1_0.inv_PI_d4$1_1.inv_PI_d2$1_1.VIN 6to4_0.buff_PI_d32_2.buff_PI_d16$1_0.inv_PI_d16$1_0.inv_PI_d8$1_0.inv_PI_d4$1_1.VIN 0.00783333
R14343 6to4_0.buff_PI_d32_2.buff_PI_d16$1_0.inv_PI_d16$1_0.inv_PI_d8$1_1.inv_PI_d4$1_1.VIN 6to4_0.buff_PI_d32_2.buff_PI_d16$1_0.inv_PI_d16$1_0.inv_PI_d8$1_1.inv_PI_d4$1_1.inv_PI_d2$1_1.VIN 0.00783333
R14344 6to4_0.buff_PI_d32_2.inv_PI_d16$1_0.VIN.n36 6to4_0.buff_PI_d32_2.inv_PI_d16$1_0.VIN.t1 17.6089
R14345 6to4_0.buff_PI_d32_2.inv_PI_d16$1_0.VIN.n39 6to4_0.buff_PI_d32_2.inv_PI_d16$1_0.VIN.t0 17.6089
R14346 6to4_0.buff_PI_d32_2.inv_PI_d16$1_0.VIN.n42 6to4_0.buff_PI_d32_2.inv_PI_d16$1_0.VIN.t15 17.6089
R14347 6to4_0.buff_PI_d32_2.inv_PI_d16$1_0.VIN.n45 6to4_0.buff_PI_d32_2.inv_PI_d16$1_0.VIN.t4 17.6089
R14348 6to4_0.buff_PI_d32_2.inv_PI_d16$1_0.VIN.n48 6to4_0.buff_PI_d32_2.inv_PI_d16$1_0.VIN.t6 17.6089
R14349 6to4_0.buff_PI_d32_2.inv_PI_d16$1_0.VIN.n51 6to4_0.buff_PI_d32_2.inv_PI_d16$1_0.VIN.t10 17.6089
R14350 6to4_0.buff_PI_d32_2.inv_PI_d16$1_0.VIN.n54 6to4_0.buff_PI_d32_2.inv_PI_d16$1_0.VIN.t9 17.6089
R14351 6to4_0.buff_PI_d32_2.inv_PI_d16$1_0.VIN.n57 6to4_0.buff_PI_d32_2.inv_PI_d16$1_0.VIN.t5 17.6089
R14352 6to4_0.buff_PI_d32_2.inv_PI_d16$1_0.VIN.n62 6to4_0.buff_PI_d32_2.inv_PI_d16$1_0.VIN.t8 17.6089
R14353 6to4_0.buff_PI_d32_2.inv_PI_d16$1_0.VIN.n65 6to4_0.buff_PI_d32_2.inv_PI_d16$1_0.VIN.t7 17.6089
R14354 6to4_0.buff_PI_d32_2.inv_PI_d16$1_0.VIN.n68 6to4_0.buff_PI_d32_2.inv_PI_d16$1_0.VIN.t3 17.6089
R14355 6to4_0.buff_PI_d32_2.inv_PI_d16$1_0.VIN.n71 6to4_0.buff_PI_d32_2.inv_PI_d16$1_0.VIN.t2 17.6089
R14356 6to4_0.buff_PI_d32_2.inv_PI_d16$1_0.VIN.n74 6to4_0.buff_PI_d32_2.inv_PI_d16$1_0.VIN.t12 17.6089
R14357 6to4_0.buff_PI_d32_2.inv_PI_d16$1_0.VIN.n80 6to4_0.buff_PI_d32_2.inv_PI_d16$1_0.VIN.t13 17.6089
R14358 6to4_0.buff_PI_d32_2.inv_PI_d16$1_0.VIN.n83 6to4_0.buff_PI_d32_2.inv_PI_d16$1_0.VIN.t11 17.6089
R14359 6to4_0.buff_PI_d32_2.inv_PI_d16$1_0.VIN.n77 6to4_0.buff_PI_d32_2.inv_PI_d16$1_0.VIN.t14 17.6089
R14360 6to4_0.buff_PI_d32_2.inv_PI_d16$1_0.VIN 6to4_0.buff_PI_d32_2.inv_PI_d16$1_0.VIN.t32 17.5436
R14361 6to4_0.buff_PI_d32_2.inv_PI_d16$1_0.VIN 6to4_0.buff_PI_d32_2.inv_PI_d16$1_0.VIN.t18 17.5436
R14362 6to4_0.buff_PI_d32_2.inv_PI_d16$1_0.VIN.n58 6to4_0.buff_PI_d32_2.inv_PI_d16$1_0.VIN.t38 17.2136
R14363 6to4_0.buff_PI_d32_2.inv_PI_d16$1_0.VIN.n56 6to4_0.buff_PI_d32_2.inv_PI_d16$1_0.VIN.t44 17.2136
R14364 6to4_0.buff_PI_d32_2.inv_PI_d16$1_0.VIN.n55 6to4_0.buff_PI_d32_2.inv_PI_d16$1_0.VIN.t20 17.2136
R14365 6to4_0.buff_PI_d32_2.inv_PI_d16$1_0.VIN.n53 6to4_0.buff_PI_d32_2.inv_PI_d16$1_0.VIN.t41 17.2136
R14366 6to4_0.buff_PI_d32_2.inv_PI_d16$1_0.VIN.n52 6to4_0.buff_PI_d32_2.inv_PI_d16$1_0.VIN.t22 17.2136
R14367 6to4_0.buff_PI_d32_2.inv_PI_d16$1_0.VIN.n50 6to4_0.buff_PI_d32_2.inv_PI_d16$1_0.VIN.t23 17.2136
R14368 6to4_0.buff_PI_d32_2.inv_PI_d16$1_0.VIN.n49 6to4_0.buff_PI_d32_2.inv_PI_d16$1_0.VIN.t39 17.2136
R14369 6to4_0.buff_PI_d32_2.inv_PI_d16$1_0.VIN.n47 6to4_0.buff_PI_d32_2.inv_PI_d16$1_0.VIN.t24 17.2136
R14370 6to4_0.buff_PI_d32_2.inv_PI_d16$1_0.VIN.n46 6to4_0.buff_PI_d32_2.inv_PI_d16$1_0.VIN.t25 17.2136
R14371 6to4_0.buff_PI_d32_2.inv_PI_d16$1_0.VIN.n44 6to4_0.buff_PI_d32_2.inv_PI_d16$1_0.VIN.t35 17.2136
R14372 6to4_0.buff_PI_d32_2.inv_PI_d16$1_0.VIN.n43 6to4_0.buff_PI_d32_2.inv_PI_d16$1_0.VIN.t47 17.2136
R14373 6to4_0.buff_PI_d32_2.inv_PI_d16$1_0.VIN.n41 6to4_0.buff_PI_d32_2.inv_PI_d16$1_0.VIN.t26 17.2136
R14374 6to4_0.buff_PI_d32_2.inv_PI_d16$1_0.VIN.n40 6to4_0.buff_PI_d32_2.inv_PI_d16$1_0.VIN.t30 17.2136
R14375 6to4_0.buff_PI_d32_2.inv_PI_d16$1_0.VIN.n38 6to4_0.buff_PI_d32_2.inv_PI_d16$1_0.VIN.t40 17.2136
R14376 6to4_0.buff_PI_d32_2.inv_PI_d16$1_0.VIN.n37 6to4_0.buff_PI_d32_2.inv_PI_d16$1_0.VIN.t46 17.2136
R14377 6to4_0.buff_PI_d32_2.inv_PI_d16$1_0.VIN.n61 6to4_0.buff_PI_d32_2.inv_PI_d16$1_0.VIN.t19 17.2136
R14378 6to4_0.buff_PI_d32_2.inv_PI_d16$1_0.VIN.n82 6to4_0.buff_PI_d32_2.inv_PI_d16$1_0.VIN.t16 17.2136
R14379 6to4_0.buff_PI_d32_2.inv_PI_d16$1_0.VIN.n81 6to4_0.buff_PI_d32_2.inv_PI_d16$1_0.VIN.t29 17.2136
R14380 6to4_0.buff_PI_d32_2.inv_PI_d16$1_0.VIN.n79 6to4_0.buff_PI_d32_2.inv_PI_d16$1_0.VIN.t17 17.2136
R14381 6to4_0.buff_PI_d32_2.inv_PI_d16$1_0.VIN.n78 6to4_0.buff_PI_d32_2.inv_PI_d16$1_0.VIN.t31 17.2136
R14382 6to4_0.buff_PI_d32_2.inv_PI_d16$1_0.VIN.n76 6to4_0.buff_PI_d32_2.inv_PI_d16$1_0.VIN.t33 17.2136
R14383 6to4_0.buff_PI_d32_2.inv_PI_d16$1_0.VIN.n75 6to4_0.buff_PI_d32_2.inv_PI_d16$1_0.VIN.t43 17.2136
R14384 6to4_0.buff_PI_d32_2.inv_PI_d16$1_0.VIN.n73 6to4_0.buff_PI_d32_2.inv_PI_d16$1_0.VIN.t34 17.2136
R14385 6to4_0.buff_PI_d32_2.inv_PI_d16$1_0.VIN.n72 6to4_0.buff_PI_d32_2.inv_PI_d16$1_0.VIN.t36 17.2136
R14386 6to4_0.buff_PI_d32_2.inv_PI_d16$1_0.VIN.n70 6to4_0.buff_PI_d32_2.inv_PI_d16$1_0.VIN.t42 17.2136
R14387 6to4_0.buff_PI_d32_2.inv_PI_d16$1_0.VIN.n69 6to4_0.buff_PI_d32_2.inv_PI_d16$1_0.VIN.t27 17.2136
R14388 6to4_0.buff_PI_d32_2.inv_PI_d16$1_0.VIN.n67 6to4_0.buff_PI_d32_2.inv_PI_d16$1_0.VIN.t37 17.2136
R14389 6to4_0.buff_PI_d32_2.inv_PI_d16$1_0.VIN.n66 6to4_0.buff_PI_d32_2.inv_PI_d16$1_0.VIN.t28 17.2136
R14390 6to4_0.buff_PI_d32_2.inv_PI_d16$1_0.VIN.n64 6to4_0.buff_PI_d32_2.inv_PI_d16$1_0.VIN.t45 17.2136
R14391 6to4_0.buff_PI_d32_2.inv_PI_d16$1_0.VIN.n63 6to4_0.buff_PI_d32_2.inv_PI_d16$1_0.VIN.t21 17.2136
R14392 6to4_0.buff_PI_d32_2.inv_PI_d16$1_0.VIN.n0 6to4_0.buff_PI_d32_2.inv_PI_d16$1_0.VIN.t53 15.0005
R14393 6to4_0.buff_PI_d32_2.inv_PI_d16$1_0.VIN.n28 6to4_0.buff_PI_d32_2.inv_PI_d16$1_0.VIN.t50 15.0005
R14394 6to4_0.buff_PI_d32_2.inv_PI_d16$1_0.VIN.n2 6to4_0.buff_PI_d32_2.inv_PI_d16$1_0.VIN.t52 15.0005
R14395 6to4_0.buff_PI_d32_2.inv_PI_d16$1_0.VIN.n20 6to4_0.buff_PI_d32_2.inv_PI_d16$1_0.VIN.t56 15.0005
R14396 6to4_0.buff_PI_d32_2.inv_PI_d16$1_0.VIN.n4 6to4_0.buff_PI_d32_2.inv_PI_d16$1_0.VIN.t63 15.0005
R14397 6to4_0.buff_PI_d32_2.inv_PI_d16$1_0.VIN.n12 6to4_0.buff_PI_d32_2.inv_PI_d16$1_0.VIN.t48 15.0005
R14398 6to4_0.buff_PI_d32_2.inv_PI_d16$1_0.VIN.n10 6to4_0.buff_PI_d32_2.inv_PI_d16$1_0.VIN.t49 15.0005
R14399 6to4_0.buff_PI_d32_2.inv_PI_d16$1_0.VIN.n9 6to4_0.buff_PI_d32_2.inv_PI_d16$1_0.VIN.t58 15.0005
R14400 6to4_0.buff_PI_d32_2.inv_PI_d16$1_0.VIN.n7 6to4_0.buff_PI_d32_2.inv_PI_d16$1_0.VIN.t55 15.0005
R14401 6to4_0.buff_PI_d32_2.inv_PI_d16$1_0.VIN.n6 6to4_0.buff_PI_d32_2.inv_PI_d16$1_0.VIN.t59 15.0005
R14402 6to4_0.buff_PI_d32_2.inv_PI_d16$1_0.VIN.n18 6to4_0.buff_PI_d32_2.inv_PI_d16$1_0.VIN.t57 15.0005
R14403 6to4_0.buff_PI_d32_2.inv_PI_d16$1_0.VIN.n16 6to4_0.buff_PI_d32_2.inv_PI_d16$1_0.VIN.t62 15.0005
R14404 6to4_0.buff_PI_d32_2.inv_PI_d16$1_0.VIN.n26 6to4_0.buff_PI_d32_2.inv_PI_d16$1_0.VIN.t60 15.0005
R14405 6to4_0.buff_PI_d32_2.inv_PI_d16$1_0.VIN.n24 6to4_0.buff_PI_d32_2.inv_PI_d16$1_0.VIN.t54 15.0005
R14406 6to4_0.buff_PI_d32_2.inv_PI_d16$1_0.VIN.n34 6to4_0.buff_PI_d32_2.inv_PI_d16$1_0.VIN.t61 15.0005
R14407 6to4_0.buff_PI_d32_2.inv_PI_d16$1_0.VIN.n32 6to4_0.buff_PI_d32_2.inv_PI_d16$1_0.VIN.t51 15.0005
R14408 6to4_0.buff_PI_d32_2.inv_PI_d16$1_0.VIN.n11 6to4_0.buff_PI_d32_2.inv_PI_d16$1_0.VIN.n9 10.3469
R14409 6to4_0.buff_PI_d32_2.inv_PI_d16$1_0.VIN.n8 6to4_0.buff_PI_d32_2.inv_PI_d16$1_0.VIN.n6 10.3469
R14410 6to4_0.buff_PI_d32_2.inv_PI_d16$1_0.VIN.n11 6to4_0.buff_PI_d32_2.inv_PI_d16$1_0.VIN.n10 9.0005
R14411 6to4_0.buff_PI_d32_2.inv_PI_d16$1_0.VIN.n17 6to4_0.buff_PI_d32_2.inv_PI_d16$1_0.VIN.n16 9.0005
R14412 6to4_0.buff_PI_d32_2.inv_PI_d16$1_0.VIN.n19 6to4_0.buff_PI_d32_2.inv_PI_d16$1_0.VIN.n18 9.0005
R14413 6to4_0.buff_PI_d32_2.inv_PI_d16$1_0.VIN.n8 6to4_0.buff_PI_d32_2.inv_PI_d16$1_0.VIN.n7 9.0005
R14414 6to4_0.buff_PI_d32_2.inv_PI_d16$1_0.VIN.n25 6to4_0.buff_PI_d32_2.inv_PI_d16$1_0.VIN.n24 9.0005
R14415 6to4_0.buff_PI_d32_2.inv_PI_d16$1_0.VIN.n27 6to4_0.buff_PI_d32_2.inv_PI_d16$1_0.VIN.n26 9.0005
R14416 6to4_0.buff_PI_d32_2.inv_PI_d16$1_0.VIN.n13 6to4_0.buff_PI_d32_2.inv_PI_d16$1_0.VIN.n12 9.0005
R14417 6to4_0.buff_PI_d32_2.inv_PI_d16$1_0.VIN.n5 6to4_0.buff_PI_d32_2.inv_PI_d16$1_0.VIN.n4 9.0005
R14418 6to4_0.buff_PI_d32_2.inv_PI_d16$1_0.VIN.n33 6to4_0.buff_PI_d32_2.inv_PI_d16$1_0.VIN.n32 9.0005
R14419 6to4_0.buff_PI_d32_2.inv_PI_d16$1_0.VIN.n35 6to4_0.buff_PI_d32_2.inv_PI_d16$1_0.VIN.n34 9.0005
R14420 6to4_0.buff_PI_d32_2.inv_PI_d16$1_0.VIN.n21 6to4_0.buff_PI_d32_2.inv_PI_d16$1_0.VIN.n20 9.0005
R14421 6to4_0.buff_PI_d32_2.inv_PI_d16$1_0.VIN.n3 6to4_0.buff_PI_d32_2.inv_PI_d16$1_0.VIN.n2 9.0005
R14422 6to4_0.buff_PI_d32_2.inv_PI_d16$1_0.VIN.n29 6to4_0.buff_PI_d32_2.inv_PI_d16$1_0.VIN.n28 9.0005
R14423 6to4_0.buff_PI_d32_2.inv_PI_d16$1_0.VIN.n1 6to4_0.buff_PI_d32_2.inv_PI_d16$1_0.VIN.n0 9.0005
R14424 6to4_0.buff_PI_d32_2.inv_PI_d16$1_0.VIN.n59 6to4_0.buff_PI_d32_2.inv_PI_d16$1_0.VIN.n58 5.12956
R14425 6to4_0.buff_PI_d32_2.inv_PI_d16$1_0.VIN.n61 6to4_0.buff_PI_d32_2.inv_PI_d16$1_0.VIN 5.12956
R14426 6to4_0.buff_PI_d32_2.inv_PI_d16$1_0.VIN.n53 6to4_0.buff_PI_d32_2.inv_PI_d16$1_0.VIN.n52 1.41675
R14427 6to4_0.buff_PI_d32_2.inv_PI_d16$1_0.VIN.n47 6to4_0.buff_PI_d32_2.inv_PI_d16$1_0.VIN.n46 1.41675
R14428 6to4_0.buff_PI_d32_2.inv_PI_d16$1_0.VIN.n41 6to4_0.buff_PI_d32_2.inv_PI_d16$1_0.VIN.n40 1.41675
R14429 6to4_0.buff_PI_d32_2.inv_PI_d16$1_0.VIN.n79 6to4_0.buff_PI_d32_2.inv_PI_d16$1_0.VIN.n78 1.41675
R14430 6to4_0.buff_PI_d32_2.inv_PI_d16$1_0.VIN.n73 6to4_0.buff_PI_d32_2.inv_PI_d16$1_0.VIN.n72 1.41675
R14431 6to4_0.buff_PI_d32_2.inv_PI_d16$1_0.VIN.n67 6to4_0.buff_PI_d32_2.inv_PI_d16$1_0.VIN.n66 1.41675
R14432 6to4_0.buff_PI_d32_2.inv_PI_d16$1_0.VIN.n19 6to4_0.buff_PI_d32_2.inv_PI_d16$1_0.VIN.n17 1.3469
R14433 6to4_0.buff_PI_d32_2.inv_PI_d16$1_0.VIN.n27 6to4_0.buff_PI_d32_2.inv_PI_d16$1_0.VIN.n25 1.3469
R14434 6to4_0.buff_PI_d32_2.inv_PI_d16$1_0.VIN.n13 6to4_0.buff_PI_d32_2.inv_PI_d16$1_0.VIN.n5 1.3469
R14435 6to4_0.buff_PI_d32_2.inv_PI_d16$1_0.VIN.n35 6to4_0.buff_PI_d32_2.inv_PI_d16$1_0.VIN.n33 1.3469
R14436 6to4_0.buff_PI_d32_2.inv_PI_d16$1_0.VIN.n21 6to4_0.buff_PI_d32_2.inv_PI_d16$1_0.VIN.n3 1.3469
R14437 6to4_0.buff_PI_d32_2.inv_PI_d16$1_0.VIN.n29 6to4_0.buff_PI_d32_2.inv_PI_d16$1_0.VIN.n1 1.3469
R14438 6to4_0.buff_PI_d32_2.inv_PI_d16$1_0.VIN.n60 6to4_0.buff_PI_d32_2.inv_PI_d16$1_0.VIN 1.0984
R14439 6to4_0.buff_PI_d32_2.inv_PI_d16$1_0.VIN.n15 6to4_0.buff_PI_d32_2.inv_PI_d16$1_0.VIN.n14 0.67839
R14440 6to4_0.buff_PI_d32_2.inv_PI_d16$1_0.VIN.n23 6to4_0.buff_PI_d32_2.inv_PI_d16$1_0.VIN.n22 0.67839
R14441 6to4_0.buff_PI_d32_2.inv_PI_d16$1_0.VIN.n56 6to4_0.buff_PI_d32_2.inv_PI_d16$1_0.VIN.n55 0.633
R14442 6to4_0.buff_PI_d32_2.inv_PI_d16$1_0.VIN.n50 6to4_0.buff_PI_d32_2.inv_PI_d16$1_0.VIN.n49 0.633
R14443 6to4_0.buff_PI_d32_2.inv_PI_d16$1_0.VIN.n44 6to4_0.buff_PI_d32_2.inv_PI_d16$1_0.VIN.n43 0.633
R14444 6to4_0.buff_PI_d32_2.inv_PI_d16$1_0.VIN.n38 6to4_0.buff_PI_d32_2.inv_PI_d16$1_0.VIN.n37 0.633
R14445 6to4_0.buff_PI_d32_2.inv_PI_d16$1_0.VIN.n82 6to4_0.buff_PI_d32_2.inv_PI_d16$1_0.VIN.n81 0.633
R14446 6to4_0.buff_PI_d32_2.inv_PI_d16$1_0.VIN.n76 6to4_0.buff_PI_d32_2.inv_PI_d16$1_0.VIN.n75 0.633
R14447 6to4_0.buff_PI_d32_2.inv_PI_d16$1_0.VIN.n70 6to4_0.buff_PI_d32_2.inv_PI_d16$1_0.VIN.n69 0.633
R14448 6to4_0.buff_PI_d32_2.inv_PI_d16$1_0.VIN.n64 6to4_0.buff_PI_d32_2.inv_PI_d16$1_0.VIN.n63 0.633
R14449 6to4_0.buff_PI_d32_2.inv_PI_d16$1_0.VIN.n59 6to4_0.buff_PI_d32_2.inv_PI_d16$1_0.VIN.n35 0.587691
R14450 6to4_0.buff_PI_d32_2.inv_PI_d16$1_0.VIN.n60 6to4_0.buff_PI_d32_2.inv_PI_d16$1_0.VIN.n1 0.5835
R14451 6to4_0.buff_PI_d32_2.inv_PI_d16$1_0.VIN.n55 6to4_0.buff_PI_d32_2.inv_PI_d16$1_0.VIN.n54 0.392375
R14452 6to4_0.buff_PI_d32_2.inv_PI_d16$1_0.VIN.n49 6to4_0.buff_PI_d32_2.inv_PI_d16$1_0.VIN.n48 0.392375
R14453 6to4_0.buff_PI_d32_2.inv_PI_d16$1_0.VIN.n43 6to4_0.buff_PI_d32_2.inv_PI_d16$1_0.VIN.n42 0.392375
R14454 6to4_0.buff_PI_d32_2.inv_PI_d16$1_0.VIN.n37 6to4_0.buff_PI_d32_2.inv_PI_d16$1_0.VIN.n36 0.392375
R14455 6to4_0.buff_PI_d32_2.inv_PI_d16$1_0.VIN.n81 6to4_0.buff_PI_d32_2.inv_PI_d16$1_0.VIN.n80 0.392375
R14456 6to4_0.buff_PI_d32_2.inv_PI_d16$1_0.VIN.n75 6to4_0.buff_PI_d32_2.inv_PI_d16$1_0.VIN.n74 0.392375
R14457 6to4_0.buff_PI_d32_2.inv_PI_d16$1_0.VIN.n69 6to4_0.buff_PI_d32_2.inv_PI_d16$1_0.VIN.n68 0.392375
R14458 6to4_0.buff_PI_d32_2.inv_PI_d16$1_0.VIN.n63 6to4_0.buff_PI_d32_2.inv_PI_d16$1_0.VIN.n62 0.392375
R14459 6to4_0.buff_PI_d32_2.inv_PI_d16$1_0.VIN.n14 6to4_0.buff_PI_d32_2.inv_PI_d16$1_0.VIN.n11 0.3855
R14460 6to4_0.buff_PI_d32_2.inv_PI_d16$1_0.VIN.n22 6to4_0.buff_PI_d32_2.inv_PI_d16$1_0.VIN.n19 0.3855
R14461 6to4_0.buff_PI_d32_2.inv_PI_d16$1_0.VIN.n15 6to4_0.buff_PI_d32_2.inv_PI_d16$1_0.VIN.n8 0.3855
R14462 6to4_0.buff_PI_d32_2.inv_PI_d16$1_0.VIN.n30 6to4_0.buff_PI_d32_2.inv_PI_d16$1_0.VIN.n27 0.3855
R14463 6to4_0.buff_PI_d32_2.inv_PI_d16$1_0.VIN.n23 6to4_0.buff_PI_d32_2.inv_PI_d16$1_0.VIN.n5 0.3855
R14464 6to4_0.buff_PI_d32_2.inv_PI_d16$1_0.VIN.n31 6to4_0.buff_PI_d32_2.inv_PI_d16$1_0.VIN.n3 0.3855
R14465 6to4_0.buff_PI_d32_2.inv_PI_d16$1_0.VIN.n17 6to4_0.buff_PI_d32_2.inv_PI_d16$1_0.VIN.n15 0.3833
R14466 6to4_0.buff_PI_d32_2.inv_PI_d16$1_0.VIN.n25 6to4_0.buff_PI_d32_2.inv_PI_d16$1_0.VIN.n23 0.3833
R14467 6to4_0.buff_PI_d32_2.inv_PI_d16$1_0.VIN.n14 6to4_0.buff_PI_d32_2.inv_PI_d16$1_0.VIN.n13 0.3833
R14468 6to4_0.buff_PI_d32_2.inv_PI_d16$1_0.VIN.n33 6to4_0.buff_PI_d32_2.inv_PI_d16$1_0.VIN.n31 0.3833
R14469 6to4_0.buff_PI_d32_2.inv_PI_d16$1_0.VIN.n22 6to4_0.buff_PI_d32_2.inv_PI_d16$1_0.VIN.n21 0.3833
R14470 6to4_0.buff_PI_d32_2.inv_PI_d16$1_0.VIN.n30 6to4_0.buff_PI_d32_2.inv_PI_d16$1_0.VIN.n29 0.3833
R14471 6to4_0.buff_PI_d32_2.inv_PI_d16$1_0.VIN.n57 6to4_0.buff_PI_d32_2.inv_PI_d16$1_0.VIN 0.358
R14472 6to4_0.buff_PI_d32_2.inv_PI_d16$1_0.VIN.n51 6to4_0.buff_PI_d32_2.inv_PI_d16$1_0.VIN 0.358
R14473 6to4_0.buff_PI_d32_2.inv_PI_d16$1_0.VIN.n45 6to4_0.buff_PI_d32_2.inv_PI_d16$1_0.VIN 0.358
R14474 6to4_0.buff_PI_d32_2.inv_PI_d16$1_0.VIN.n39 6to4_0.buff_PI_d32_2.inv_PI_d16$1_0.VIN 0.358
R14475 6to4_0.buff_PI_d32_2.inv_PI_d16$1_0.VIN.n83 6to4_0.buff_PI_d32_2.inv_PI_d16$1_0.VIN 0.358
R14476 6to4_0.buff_PI_d32_2.inv_PI_d16$1_0.VIN.n77 6to4_0.buff_PI_d32_2.inv_PI_d16$1_0.VIN 0.358
R14477 6to4_0.buff_PI_d32_2.inv_PI_d16$1_0.VIN.n71 6to4_0.buff_PI_d32_2.inv_PI_d16$1_0.VIN 0.358
R14478 6to4_0.buff_PI_d32_2.inv_PI_d16$1_0.VIN.n65 6to4_0.buff_PI_d32_2.inv_PI_d16$1_0.VIN 0.358
R14479 6to4_0.buff_PI_d32_2.inv_PI_d16$1_0.VIN 6to4_0.buff_PI_d32_2.inv_PI_d16$1_0.VIN.n53 0.3305
R14480 6to4_0.buff_PI_d32_2.inv_PI_d16$1_0.VIN.n52 6to4_0.buff_PI_d32_2.inv_PI_d16$1_0.VIN 0.3305
R14481 6to4_0.buff_PI_d32_2.inv_PI_d16$1_0.VIN 6to4_0.buff_PI_d32_2.inv_PI_d16$1_0.VIN.n47 0.3305
R14482 6to4_0.buff_PI_d32_2.inv_PI_d16$1_0.VIN 6to4_0.buff_PI_d32_2.inv_PI_d16$1_0.VIN.n41 0.3305
R14483 6to4_0.buff_PI_d32_2.inv_PI_d16$1_0.VIN.n40 6to4_0.buff_PI_d32_2.inv_PI_d16$1_0.VIN 0.3305
R14484 6to4_0.buff_PI_d32_2.inv_PI_d16$1_0.VIN 6to4_0.buff_PI_d32_2.inv_PI_d16$1_0.VIN.n79 0.3305
R14485 6to4_0.buff_PI_d32_2.inv_PI_d16$1_0.VIN.n78 6to4_0.buff_PI_d32_2.inv_PI_d16$1_0.VIN 0.3305
R14486 6to4_0.buff_PI_d32_2.inv_PI_d16$1_0.VIN 6to4_0.buff_PI_d32_2.inv_PI_d16$1_0.VIN.n73 0.3305
R14487 6to4_0.buff_PI_d32_2.inv_PI_d16$1_0.VIN 6to4_0.buff_PI_d32_2.inv_PI_d16$1_0.VIN.n67 0.3305
R14488 6to4_0.buff_PI_d32_2.inv_PI_d16$1_0.VIN.n66 6to4_0.buff_PI_d32_2.inv_PI_d16$1_0.VIN 0.3305
R14489 6to4_0.buff_PI_d32_2.inv_PI_d16$1_0.VIN 6to4_0.buff_PI_d32_2.inv_PI_d16$1_0.VIN.n59 0.239357
R14490 6to4_0.buff_PI_d32_2.inv_PI_d16$1_0.VIN.n58 6to4_0.buff_PI_d32_2.inv_PI_d16$1_0.VIN 0.113938
R14491 6to4_0.buff_PI_d32_2.inv_PI_d16$1_0.VIN.n46 6to4_0.buff_PI_d32_2.inv_PI_d16$1_0.VIN 0.113938
R14492 6to4_0.buff_PI_d32_2.inv_PI_d16$1_0.VIN 6to4_0.buff_PI_d32_2.inv_PI_d16$1_0.VIN.n61 0.113938
R14493 6to4_0.buff_PI_d32_2.inv_PI_d16$1_0.VIN.n72 6to4_0.buff_PI_d32_2.inv_PI_d16$1_0.VIN 0.113938
R14494 6to4_0.buff_PI_d32_2.inv_PI_d16$1_0.VIN 6to4_0.buff_PI_d32_2.inv_PI_d16$1_0.VIN.n30 0.0662582
R14495 6to4_0.buff_PI_d32_2.inv_PI_d16$1_0.VIN 6to4_0.buff_PI_d32_2.inv_PI_d16$1_0.VIN.n57 0.062375
R14496 6to4_0.buff_PI_d32_2.inv_PI_d16$1_0.VIN.n54 6to4_0.buff_PI_d32_2.inv_PI_d16$1_0.VIN 0.062375
R14497 6to4_0.buff_PI_d32_2.inv_PI_d16$1_0.VIN 6to4_0.buff_PI_d32_2.inv_PI_d16$1_0.VIN.n51 0.062375
R14498 6to4_0.buff_PI_d32_2.inv_PI_d16$1_0.VIN.n48 6to4_0.buff_PI_d32_2.inv_PI_d16$1_0.VIN 0.062375
R14499 6to4_0.buff_PI_d32_2.inv_PI_d16$1_0.VIN 6to4_0.buff_PI_d32_2.inv_PI_d16$1_0.VIN.n45 0.062375
R14500 6to4_0.buff_PI_d32_2.inv_PI_d16$1_0.VIN.n42 6to4_0.buff_PI_d32_2.inv_PI_d16$1_0.VIN 0.062375
R14501 6to4_0.buff_PI_d32_2.inv_PI_d16$1_0.VIN 6to4_0.buff_PI_d32_2.inv_PI_d16$1_0.VIN.n39 0.062375
R14502 6to4_0.buff_PI_d32_2.inv_PI_d16$1_0.VIN.n36 6to4_0.buff_PI_d32_2.inv_PI_d16$1_0.VIN 0.062375
R14503 6to4_0.buff_PI_d32_2.inv_PI_d16$1_0.VIN 6to4_0.buff_PI_d32_2.inv_PI_d16$1_0.VIN.n83 0.062375
R14504 6to4_0.buff_PI_d32_2.inv_PI_d16$1_0.VIN.n80 6to4_0.buff_PI_d32_2.inv_PI_d16$1_0.VIN 0.062375
R14505 6to4_0.buff_PI_d32_2.inv_PI_d16$1_0.VIN 6to4_0.buff_PI_d32_2.inv_PI_d16$1_0.VIN.n77 0.062375
R14506 6to4_0.buff_PI_d32_2.inv_PI_d16$1_0.VIN.n74 6to4_0.buff_PI_d32_2.inv_PI_d16$1_0.VIN 0.062375
R14507 6to4_0.buff_PI_d32_2.inv_PI_d16$1_0.VIN 6to4_0.buff_PI_d32_2.inv_PI_d16$1_0.VIN.n71 0.062375
R14508 6to4_0.buff_PI_d32_2.inv_PI_d16$1_0.VIN.n68 6to4_0.buff_PI_d32_2.inv_PI_d16$1_0.VIN 0.062375
R14509 6to4_0.buff_PI_d32_2.inv_PI_d16$1_0.VIN 6to4_0.buff_PI_d32_2.inv_PI_d16$1_0.VIN.n65 0.062375
R14510 6to4_0.buff_PI_d32_2.inv_PI_d16$1_0.VIN.n62 6to4_0.buff_PI_d32_2.inv_PI_d16$1_0.VIN 0.062375
R14511 6to4_0.buff_PI_d32_2.inv_PI_d16$1_0.VIN.n31 6to4_0.buff_PI_d32_2.inv_PI_d16$1_0.VIN 0.059489
R14512 6to4_0.buff_PI_d32_2.inv_PI_d16$1_0.VIN.n28 6to4_0.buff_PI_d32_2.inv_PI_d16$1_0.VIN 0.0555
R14513 6to4_0.buff_PI_d32_2.inv_PI_d16$1_0.VIN.n20 6to4_0.buff_PI_d32_2.inv_PI_d16$1_0.VIN 0.0555
R14514 6to4_0.buff_PI_d32_2.inv_PI_d16$1_0.VIN.n12 6to4_0.buff_PI_d32_2.inv_PI_d16$1_0.VIN 0.0555
R14515 6to4_0.buff_PI_d32_2.inv_PI_d16$1_0.VIN.n9 6to4_0.buff_PI_d32_2.inv_PI_d16$1_0.VIN 0.0555
R14516 6to4_0.buff_PI_d32_2.inv_PI_d16$1_0.VIN.n6 6to4_0.buff_PI_d32_2.inv_PI_d16$1_0.VIN 0.0555
R14517 6to4_0.buff_PI_d32_2.inv_PI_d16$1_0.VIN.n16 6to4_0.buff_PI_d32_2.inv_PI_d16$1_0.VIN 0.0555
R14518 6to4_0.buff_PI_d32_2.inv_PI_d16$1_0.VIN.n24 6to4_0.buff_PI_d32_2.inv_PI_d16$1_0.VIN 0.0555
R14519 6to4_0.buff_PI_d32_2.inv_PI_d16$1_0.VIN.n32 6to4_0.buff_PI_d32_2.inv_PI_d16$1_0.VIN 0.0555
R14520 6to4_0.buff_PI_d32_2.inv_PI_d16$1_0.VIN 6to4_0.buff_PI_d32_2.inv_PI_d16$1_0.VIN.n56 0.034875
R14521 6to4_0.buff_PI_d32_2.inv_PI_d16$1_0.VIN 6to4_0.buff_PI_d32_2.inv_PI_d16$1_0.VIN.n50 0.034875
R14522 6to4_0.buff_PI_d32_2.inv_PI_d16$1_0.VIN 6to4_0.buff_PI_d32_2.inv_PI_d16$1_0.VIN.n44 0.034875
R14523 6to4_0.buff_PI_d32_2.inv_PI_d16$1_0.VIN 6to4_0.buff_PI_d32_2.inv_PI_d16$1_0.VIN.n38 0.034875
R14524 6to4_0.buff_PI_d32_2.inv_PI_d16$1_0.VIN 6to4_0.buff_PI_d32_2.inv_PI_d16$1_0.VIN.n82 0.034875
R14525 6to4_0.buff_PI_d32_2.inv_PI_d16$1_0.VIN 6to4_0.buff_PI_d32_2.inv_PI_d16$1_0.VIN.n76 0.034875
R14526 6to4_0.buff_PI_d32_2.inv_PI_d16$1_0.VIN 6to4_0.buff_PI_d32_2.inv_PI_d16$1_0.VIN.n70 0.034875
R14527 6to4_0.buff_PI_d32_2.inv_PI_d16$1_0.VIN 6to4_0.buff_PI_d32_2.inv_PI_d16$1_0.VIN.n64 0.034875
R14528 6to4_0.buff_PI_d32_2.inv_PI_d16$1_0.VIN.n0 6to4_0.buff_PI_d32_2.inv_PI_d16$1_0.VIN 0.0115
R14529 6to4_0.buff_PI_d32_2.inv_PI_d16$1_0.VIN.n2 6to4_0.buff_PI_d32_2.inv_PI_d16$1_0.VIN 0.0115
R14530 6to4_0.buff_PI_d32_2.inv_PI_d16$1_0.VIN.n4 6to4_0.buff_PI_d32_2.inv_PI_d16$1_0.VIN 0.0115
R14531 6to4_0.buff_PI_d32_2.inv_PI_d16$1_0.VIN.n10 6to4_0.buff_PI_d32_2.inv_PI_d16$1_0.VIN 0.0115
R14532 6to4_0.buff_PI_d32_2.inv_PI_d16$1_0.VIN.n7 6to4_0.buff_PI_d32_2.inv_PI_d16$1_0.VIN 0.0115
R14533 6to4_0.buff_PI_d32_2.inv_PI_d16$1_0.VIN.n18 6to4_0.buff_PI_d32_2.inv_PI_d16$1_0.VIN 0.0115
R14534 6to4_0.buff_PI_d32_2.inv_PI_d16$1_0.VIN.n26 6to4_0.buff_PI_d32_2.inv_PI_d16$1_0.VIN 0.0115
R14535 6to4_0.buff_PI_d32_2.inv_PI_d16$1_0.VIN.n34 6to4_0.buff_PI_d32_2.inv_PI_d16$1_0.VIN 0.0115
R14536 6to4_0.buff_PI_d32_2.inv_PI_d16$1_0.VIN 6to4_0.buff_PI_d32_2.inv_PI_d16$1_0.VIN.n60 0.00469048
R14537 6to4_0.buff_PI_d32_0.inv_PI_d16$1_0.VIN.n36 6to4_0.buff_PI_d32_0.inv_PI_d16$1_0.VIN.t3 17.6089
R14538 6to4_0.buff_PI_d32_0.inv_PI_d16$1_0.VIN.n39 6to4_0.buff_PI_d32_0.inv_PI_d16$1_0.VIN.t30 17.6089
R14539 6to4_0.buff_PI_d32_0.inv_PI_d16$1_0.VIN.n42 6to4_0.buff_PI_d32_0.inv_PI_d16$1_0.VIN.t36 17.6089
R14540 6to4_0.buff_PI_d32_0.inv_PI_d16$1_0.VIN.n45 6to4_0.buff_PI_d32_0.inv_PI_d16$1_0.VIN.t15 17.6089
R14541 6to4_0.buff_PI_d32_0.inv_PI_d16$1_0.VIN.n48 6to4_0.buff_PI_d32_0.inv_PI_d16$1_0.VIN.t6 17.6089
R14542 6to4_0.buff_PI_d32_0.inv_PI_d16$1_0.VIN.n51 6to4_0.buff_PI_d32_0.inv_PI_d16$1_0.VIN.t42 17.6089
R14543 6to4_0.buff_PI_d32_0.inv_PI_d16$1_0.VIN.n54 6to4_0.buff_PI_d32_0.inv_PI_d16$1_0.VIN.t21 17.6089
R14544 6to4_0.buff_PI_d32_0.inv_PI_d16$1_0.VIN.n57 6to4_0.buff_PI_d32_0.inv_PI_d16$1_0.VIN.t9 17.6089
R14545 6to4_0.buff_PI_d32_0.inv_PI_d16$1_0.VIN.n62 6to4_0.buff_PI_d32_0.inv_PI_d16$1_0.VIN.t45 17.6089
R14546 6to4_0.buff_PI_d32_0.inv_PI_d16$1_0.VIN.n65 6to4_0.buff_PI_d32_0.inv_PI_d16$1_0.VIN.t24 17.6089
R14547 6to4_0.buff_PI_d32_0.inv_PI_d16$1_0.VIN.n71 6to4_0.buff_PI_d32_0.inv_PI_d16$1_0.VIN.t27 17.6089
R14548 6to4_0.buff_PI_d32_0.inv_PI_d16$1_0.VIN.n74 6to4_0.buff_PI_d32_0.inv_PI_d16$1_0.VIN.t33 17.6089
R14549 6to4_0.buff_PI_d32_0.inv_PI_d16$1_0.VIN.n77 6to4_0.buff_PI_d32_0.inv_PI_d16$1_0.VIN.t12 17.6089
R14550 6to4_0.buff_PI_d32_0.inv_PI_d16$1_0.VIN.n80 6to4_0.buff_PI_d32_0.inv_PI_d16$1_0.VIN.t18 17.6089
R14551 6to4_0.buff_PI_d32_0.inv_PI_d16$1_0.VIN.n83 6to4_0.buff_PI_d32_0.inv_PI_d16$1_0.VIN.t39 17.6089
R14552 6to4_0.buff_PI_d32_0.inv_PI_d16$1_0.VIN.n68 6to4_0.buff_PI_d32_0.inv_PI_d16$1_0.VIN.t0 17.6089
R14553 6to4_0.buff_PI_d32_0.inv_PI_d16$1_0.VIN 6to4_0.buff_PI_d32_0.inv_PI_d16$1_0.VIN.t4 17.5436
R14554 6to4_0.buff_PI_d32_0.inv_PI_d16$1_0.VIN 6to4_0.buff_PI_d32_0.inv_PI_d16$1_0.VIN.t46 17.5436
R14555 6to4_0.buff_PI_d32_0.inv_PI_d16$1_0.VIN.n58 6to4_0.buff_PI_d32_0.inv_PI_d16$1_0.VIN.t10 17.2136
R14556 6to4_0.buff_PI_d32_0.inv_PI_d16$1_0.VIN.n56 6to4_0.buff_PI_d32_0.inv_PI_d16$1_0.VIN.t11 17.2136
R14557 6to4_0.buff_PI_d32_0.inv_PI_d16$1_0.VIN.n55 6to4_0.buff_PI_d32_0.inv_PI_d16$1_0.VIN.t22 17.2136
R14558 6to4_0.buff_PI_d32_0.inv_PI_d16$1_0.VIN.n53 6to4_0.buff_PI_d32_0.inv_PI_d16$1_0.VIN.t23 17.2136
R14559 6to4_0.buff_PI_d32_0.inv_PI_d16$1_0.VIN.n52 6to4_0.buff_PI_d32_0.inv_PI_d16$1_0.VIN.t43 17.2136
R14560 6to4_0.buff_PI_d32_0.inv_PI_d16$1_0.VIN.n50 6to4_0.buff_PI_d32_0.inv_PI_d16$1_0.VIN.t44 17.2136
R14561 6to4_0.buff_PI_d32_0.inv_PI_d16$1_0.VIN.n49 6to4_0.buff_PI_d32_0.inv_PI_d16$1_0.VIN.t8 17.2136
R14562 6to4_0.buff_PI_d32_0.inv_PI_d16$1_0.VIN.n47 6to4_0.buff_PI_d32_0.inv_PI_d16$1_0.VIN.t7 17.2136
R14563 6to4_0.buff_PI_d32_0.inv_PI_d16$1_0.VIN.n46 6to4_0.buff_PI_d32_0.inv_PI_d16$1_0.VIN.t16 17.2136
R14564 6to4_0.buff_PI_d32_0.inv_PI_d16$1_0.VIN.n44 6to4_0.buff_PI_d32_0.inv_PI_d16$1_0.VIN.t17 17.2136
R14565 6to4_0.buff_PI_d32_0.inv_PI_d16$1_0.VIN.n43 6to4_0.buff_PI_d32_0.inv_PI_d16$1_0.VIN.t37 17.2136
R14566 6to4_0.buff_PI_d32_0.inv_PI_d16$1_0.VIN.n41 6to4_0.buff_PI_d32_0.inv_PI_d16$1_0.VIN.t38 17.2136
R14567 6to4_0.buff_PI_d32_0.inv_PI_d16$1_0.VIN.n40 6to4_0.buff_PI_d32_0.inv_PI_d16$1_0.VIN.t31 17.2136
R14568 6to4_0.buff_PI_d32_0.inv_PI_d16$1_0.VIN.n38 6to4_0.buff_PI_d32_0.inv_PI_d16$1_0.VIN.t32 17.2136
R14569 6to4_0.buff_PI_d32_0.inv_PI_d16$1_0.VIN.n37 6to4_0.buff_PI_d32_0.inv_PI_d16$1_0.VIN.t5 17.2136
R14570 6to4_0.buff_PI_d32_0.inv_PI_d16$1_0.VIN.n61 6to4_0.buff_PI_d32_0.inv_PI_d16$1_0.VIN.t41 17.2136
R14571 6to4_0.buff_PI_d32_0.inv_PI_d16$1_0.VIN.n82 6to4_0.buff_PI_d32_0.inv_PI_d16$1_0.VIN.t40 17.2136
R14572 6to4_0.buff_PI_d32_0.inv_PI_d16$1_0.VIN.n81 6to4_0.buff_PI_d32_0.inv_PI_d16$1_0.VIN.t20 17.2136
R14573 6to4_0.buff_PI_d32_0.inv_PI_d16$1_0.VIN.n79 6to4_0.buff_PI_d32_0.inv_PI_d16$1_0.VIN.t19 17.2136
R14574 6to4_0.buff_PI_d32_0.inv_PI_d16$1_0.VIN.n78 6to4_0.buff_PI_d32_0.inv_PI_d16$1_0.VIN.t13 17.2136
R14575 6to4_0.buff_PI_d32_0.inv_PI_d16$1_0.VIN.n76 6to4_0.buff_PI_d32_0.inv_PI_d16$1_0.VIN.t14 17.2136
R14576 6to4_0.buff_PI_d32_0.inv_PI_d16$1_0.VIN.n75 6to4_0.buff_PI_d32_0.inv_PI_d16$1_0.VIN.t35 17.2136
R14577 6to4_0.buff_PI_d32_0.inv_PI_d16$1_0.VIN.n73 6to4_0.buff_PI_d32_0.inv_PI_d16$1_0.VIN.t34 17.2136
R14578 6to4_0.buff_PI_d32_0.inv_PI_d16$1_0.VIN.n72 6to4_0.buff_PI_d32_0.inv_PI_d16$1_0.VIN.t28 17.2136
R14579 6to4_0.buff_PI_d32_0.inv_PI_d16$1_0.VIN.n70 6to4_0.buff_PI_d32_0.inv_PI_d16$1_0.VIN.t29 17.2136
R14580 6to4_0.buff_PI_d32_0.inv_PI_d16$1_0.VIN.n69 6to4_0.buff_PI_d32_0.inv_PI_d16$1_0.VIN.t1 17.2136
R14581 6to4_0.buff_PI_d32_0.inv_PI_d16$1_0.VIN.n67 6to4_0.buff_PI_d32_0.inv_PI_d16$1_0.VIN.t2 17.2136
R14582 6to4_0.buff_PI_d32_0.inv_PI_d16$1_0.VIN.n66 6to4_0.buff_PI_d32_0.inv_PI_d16$1_0.VIN.t25 17.2136
R14583 6to4_0.buff_PI_d32_0.inv_PI_d16$1_0.VIN.n64 6to4_0.buff_PI_d32_0.inv_PI_d16$1_0.VIN.t26 17.2136
R14584 6to4_0.buff_PI_d32_0.inv_PI_d16$1_0.VIN.n63 6to4_0.buff_PI_d32_0.inv_PI_d16$1_0.VIN.t47 17.2136
R14585 6to4_0.buff_PI_d32_0.inv_PI_d16$1_0.VIN.n0 6to4_0.buff_PI_d32_0.inv_PI_d16$1_0.VIN.t51 15.0005
R14586 6to4_0.buff_PI_d32_0.inv_PI_d16$1_0.VIN.n28 6to4_0.buff_PI_d32_0.inv_PI_d16$1_0.VIN.t62 15.0005
R14587 6to4_0.buff_PI_d32_0.inv_PI_d16$1_0.VIN.n2 6to4_0.buff_PI_d32_0.inv_PI_d16$1_0.VIN.t48 15.0005
R14588 6to4_0.buff_PI_d32_0.inv_PI_d16$1_0.VIN.n20 6to4_0.buff_PI_d32_0.inv_PI_d16$1_0.VIN.t60 15.0005
R14589 6to4_0.buff_PI_d32_0.inv_PI_d16$1_0.VIN.n4 6to4_0.buff_PI_d32_0.inv_PI_d16$1_0.VIN.t55 15.0005
R14590 6to4_0.buff_PI_d32_0.inv_PI_d16$1_0.VIN.n12 6to4_0.buff_PI_d32_0.inv_PI_d16$1_0.VIN.t57 15.0005
R14591 6to4_0.buff_PI_d32_0.inv_PI_d16$1_0.VIN.n10 6to4_0.buff_PI_d32_0.inv_PI_d16$1_0.VIN.t52 15.0005
R14592 6to4_0.buff_PI_d32_0.inv_PI_d16$1_0.VIN.n9 6to4_0.buff_PI_d32_0.inv_PI_d16$1_0.VIN.t56 15.0005
R14593 6to4_0.buff_PI_d32_0.inv_PI_d16$1_0.VIN.n7 6to4_0.buff_PI_d32_0.inv_PI_d16$1_0.VIN.t59 15.0005
R14594 6to4_0.buff_PI_d32_0.inv_PI_d16$1_0.VIN.n6 6to4_0.buff_PI_d32_0.inv_PI_d16$1_0.VIN.t53 15.0005
R14595 6to4_0.buff_PI_d32_0.inv_PI_d16$1_0.VIN.n18 6to4_0.buff_PI_d32_0.inv_PI_d16$1_0.VIN.t50 15.0005
R14596 6to4_0.buff_PI_d32_0.inv_PI_d16$1_0.VIN.n16 6to4_0.buff_PI_d32_0.inv_PI_d16$1_0.VIN.t58 15.0005
R14597 6to4_0.buff_PI_d32_0.inv_PI_d16$1_0.VIN.n26 6to4_0.buff_PI_d32_0.inv_PI_d16$1_0.VIN.t61 15.0005
R14598 6to4_0.buff_PI_d32_0.inv_PI_d16$1_0.VIN.n24 6to4_0.buff_PI_d32_0.inv_PI_d16$1_0.VIN.t49 15.0005
R14599 6to4_0.buff_PI_d32_0.inv_PI_d16$1_0.VIN.n34 6to4_0.buff_PI_d32_0.inv_PI_d16$1_0.VIN.t63 15.0005
R14600 6to4_0.buff_PI_d32_0.inv_PI_d16$1_0.VIN.n32 6to4_0.buff_PI_d32_0.inv_PI_d16$1_0.VIN.t54 15.0005
R14601 6to4_0.buff_PI_d32_0.inv_PI_d16$1_0.VIN.n11 6to4_0.buff_PI_d32_0.inv_PI_d16$1_0.VIN.n9 10.3469
R14602 6to4_0.buff_PI_d32_0.inv_PI_d16$1_0.VIN.n8 6to4_0.buff_PI_d32_0.inv_PI_d16$1_0.VIN.n6 10.3469
R14603 6to4_0.buff_PI_d32_0.inv_PI_d16$1_0.VIN.n11 6to4_0.buff_PI_d32_0.inv_PI_d16$1_0.VIN.n10 9.0005
R14604 6to4_0.buff_PI_d32_0.inv_PI_d16$1_0.VIN.n17 6to4_0.buff_PI_d32_0.inv_PI_d16$1_0.VIN.n16 9.0005
R14605 6to4_0.buff_PI_d32_0.inv_PI_d16$1_0.VIN.n19 6to4_0.buff_PI_d32_0.inv_PI_d16$1_0.VIN.n18 9.0005
R14606 6to4_0.buff_PI_d32_0.inv_PI_d16$1_0.VIN.n8 6to4_0.buff_PI_d32_0.inv_PI_d16$1_0.VIN.n7 9.0005
R14607 6to4_0.buff_PI_d32_0.inv_PI_d16$1_0.VIN.n25 6to4_0.buff_PI_d32_0.inv_PI_d16$1_0.VIN.n24 9.0005
R14608 6to4_0.buff_PI_d32_0.inv_PI_d16$1_0.VIN.n27 6to4_0.buff_PI_d32_0.inv_PI_d16$1_0.VIN.n26 9.0005
R14609 6to4_0.buff_PI_d32_0.inv_PI_d16$1_0.VIN.n13 6to4_0.buff_PI_d32_0.inv_PI_d16$1_0.VIN.n12 9.0005
R14610 6to4_0.buff_PI_d32_0.inv_PI_d16$1_0.VIN.n5 6to4_0.buff_PI_d32_0.inv_PI_d16$1_0.VIN.n4 9.0005
R14611 6to4_0.buff_PI_d32_0.inv_PI_d16$1_0.VIN.n33 6to4_0.buff_PI_d32_0.inv_PI_d16$1_0.VIN.n32 9.0005
R14612 6to4_0.buff_PI_d32_0.inv_PI_d16$1_0.VIN.n35 6to4_0.buff_PI_d32_0.inv_PI_d16$1_0.VIN.n34 9.0005
R14613 6to4_0.buff_PI_d32_0.inv_PI_d16$1_0.VIN.n21 6to4_0.buff_PI_d32_0.inv_PI_d16$1_0.VIN.n20 9.0005
R14614 6to4_0.buff_PI_d32_0.inv_PI_d16$1_0.VIN.n3 6to4_0.buff_PI_d32_0.inv_PI_d16$1_0.VIN.n2 9.0005
R14615 6to4_0.buff_PI_d32_0.inv_PI_d16$1_0.VIN.n29 6to4_0.buff_PI_d32_0.inv_PI_d16$1_0.VIN.n28 9.0005
R14616 6to4_0.buff_PI_d32_0.inv_PI_d16$1_0.VIN.n1 6to4_0.buff_PI_d32_0.inv_PI_d16$1_0.VIN.n0 9.0005
R14617 6to4_0.buff_PI_d32_0.inv_PI_d16$1_0.VIN.n59 6to4_0.buff_PI_d32_0.inv_PI_d16$1_0.VIN.n58 5.12956
R14618 6to4_0.buff_PI_d32_0.inv_PI_d16$1_0.VIN.n61 6to4_0.buff_PI_d32_0.inv_PI_d16$1_0.VIN 5.12956
R14619 6to4_0.buff_PI_d32_0.inv_PI_d16$1_0.VIN.n53 6to4_0.buff_PI_d32_0.inv_PI_d16$1_0.VIN.n52 1.41675
R14620 6to4_0.buff_PI_d32_0.inv_PI_d16$1_0.VIN.n47 6to4_0.buff_PI_d32_0.inv_PI_d16$1_0.VIN.n46 1.41675
R14621 6to4_0.buff_PI_d32_0.inv_PI_d16$1_0.VIN.n41 6to4_0.buff_PI_d32_0.inv_PI_d16$1_0.VIN.n40 1.41675
R14622 6to4_0.buff_PI_d32_0.inv_PI_d16$1_0.VIN.n79 6to4_0.buff_PI_d32_0.inv_PI_d16$1_0.VIN.n78 1.41675
R14623 6to4_0.buff_PI_d32_0.inv_PI_d16$1_0.VIN.n73 6to4_0.buff_PI_d32_0.inv_PI_d16$1_0.VIN.n72 1.41675
R14624 6to4_0.buff_PI_d32_0.inv_PI_d16$1_0.VIN.n67 6to4_0.buff_PI_d32_0.inv_PI_d16$1_0.VIN.n66 1.41675
R14625 6to4_0.buff_PI_d32_0.inv_PI_d16$1_0.VIN.n19 6to4_0.buff_PI_d32_0.inv_PI_d16$1_0.VIN.n17 1.3469
R14626 6to4_0.buff_PI_d32_0.inv_PI_d16$1_0.VIN.n27 6to4_0.buff_PI_d32_0.inv_PI_d16$1_0.VIN.n25 1.3469
R14627 6to4_0.buff_PI_d32_0.inv_PI_d16$1_0.VIN.n13 6to4_0.buff_PI_d32_0.inv_PI_d16$1_0.VIN.n5 1.3469
R14628 6to4_0.buff_PI_d32_0.inv_PI_d16$1_0.VIN.n35 6to4_0.buff_PI_d32_0.inv_PI_d16$1_0.VIN.n33 1.3469
R14629 6to4_0.buff_PI_d32_0.inv_PI_d16$1_0.VIN.n21 6to4_0.buff_PI_d32_0.inv_PI_d16$1_0.VIN.n3 1.3469
R14630 6to4_0.buff_PI_d32_0.inv_PI_d16$1_0.VIN.n29 6to4_0.buff_PI_d32_0.inv_PI_d16$1_0.VIN.n1 1.3469
R14631 6to4_0.buff_PI_d32_0.inv_PI_d16$1_0.VIN.n60 6to4_0.buff_PI_d32_0.inv_PI_d16$1_0.VIN 1.0984
R14632 6to4_0.buff_PI_d32_0.inv_PI_d16$1_0.VIN.n15 6to4_0.buff_PI_d32_0.inv_PI_d16$1_0.VIN.n14 0.67839
R14633 6to4_0.buff_PI_d32_0.inv_PI_d16$1_0.VIN.n23 6to4_0.buff_PI_d32_0.inv_PI_d16$1_0.VIN.n22 0.67839
R14634 6to4_0.buff_PI_d32_0.inv_PI_d16$1_0.VIN.n56 6to4_0.buff_PI_d32_0.inv_PI_d16$1_0.VIN.n55 0.633
R14635 6to4_0.buff_PI_d32_0.inv_PI_d16$1_0.VIN.n50 6to4_0.buff_PI_d32_0.inv_PI_d16$1_0.VIN.n49 0.633
R14636 6to4_0.buff_PI_d32_0.inv_PI_d16$1_0.VIN.n44 6to4_0.buff_PI_d32_0.inv_PI_d16$1_0.VIN.n43 0.633
R14637 6to4_0.buff_PI_d32_0.inv_PI_d16$1_0.VIN.n38 6to4_0.buff_PI_d32_0.inv_PI_d16$1_0.VIN.n37 0.633
R14638 6to4_0.buff_PI_d32_0.inv_PI_d16$1_0.VIN.n82 6to4_0.buff_PI_d32_0.inv_PI_d16$1_0.VIN.n81 0.633
R14639 6to4_0.buff_PI_d32_0.inv_PI_d16$1_0.VIN.n76 6to4_0.buff_PI_d32_0.inv_PI_d16$1_0.VIN.n75 0.633
R14640 6to4_0.buff_PI_d32_0.inv_PI_d16$1_0.VIN.n70 6to4_0.buff_PI_d32_0.inv_PI_d16$1_0.VIN.n69 0.633
R14641 6to4_0.buff_PI_d32_0.inv_PI_d16$1_0.VIN.n64 6to4_0.buff_PI_d32_0.inv_PI_d16$1_0.VIN.n63 0.633
R14642 6to4_0.buff_PI_d32_0.inv_PI_d16$1_0.VIN.n59 6to4_0.buff_PI_d32_0.inv_PI_d16$1_0.VIN.n35 0.587691
R14643 6to4_0.buff_PI_d32_0.inv_PI_d16$1_0.VIN.n60 6to4_0.buff_PI_d32_0.inv_PI_d16$1_0.VIN.n1 0.5835
R14644 6to4_0.buff_PI_d32_0.inv_PI_d16$1_0.VIN.n55 6to4_0.buff_PI_d32_0.inv_PI_d16$1_0.VIN.n54 0.392375
R14645 6to4_0.buff_PI_d32_0.inv_PI_d16$1_0.VIN.n49 6to4_0.buff_PI_d32_0.inv_PI_d16$1_0.VIN.n48 0.392375
R14646 6to4_0.buff_PI_d32_0.inv_PI_d16$1_0.VIN.n43 6to4_0.buff_PI_d32_0.inv_PI_d16$1_0.VIN.n42 0.392375
R14647 6to4_0.buff_PI_d32_0.inv_PI_d16$1_0.VIN.n37 6to4_0.buff_PI_d32_0.inv_PI_d16$1_0.VIN.n36 0.392375
R14648 6to4_0.buff_PI_d32_0.inv_PI_d16$1_0.VIN.n81 6to4_0.buff_PI_d32_0.inv_PI_d16$1_0.VIN.n80 0.392375
R14649 6to4_0.buff_PI_d32_0.inv_PI_d16$1_0.VIN.n75 6to4_0.buff_PI_d32_0.inv_PI_d16$1_0.VIN.n74 0.392375
R14650 6to4_0.buff_PI_d32_0.inv_PI_d16$1_0.VIN.n69 6to4_0.buff_PI_d32_0.inv_PI_d16$1_0.VIN.n68 0.392375
R14651 6to4_0.buff_PI_d32_0.inv_PI_d16$1_0.VIN.n63 6to4_0.buff_PI_d32_0.inv_PI_d16$1_0.VIN.n62 0.392375
R14652 6to4_0.buff_PI_d32_0.inv_PI_d16$1_0.VIN.n14 6to4_0.buff_PI_d32_0.inv_PI_d16$1_0.VIN.n11 0.3855
R14653 6to4_0.buff_PI_d32_0.inv_PI_d16$1_0.VIN.n22 6to4_0.buff_PI_d32_0.inv_PI_d16$1_0.VIN.n19 0.3855
R14654 6to4_0.buff_PI_d32_0.inv_PI_d16$1_0.VIN.n15 6to4_0.buff_PI_d32_0.inv_PI_d16$1_0.VIN.n8 0.3855
R14655 6to4_0.buff_PI_d32_0.inv_PI_d16$1_0.VIN.n30 6to4_0.buff_PI_d32_0.inv_PI_d16$1_0.VIN.n27 0.3855
R14656 6to4_0.buff_PI_d32_0.inv_PI_d16$1_0.VIN.n23 6to4_0.buff_PI_d32_0.inv_PI_d16$1_0.VIN.n5 0.3855
R14657 6to4_0.buff_PI_d32_0.inv_PI_d16$1_0.VIN.n31 6to4_0.buff_PI_d32_0.inv_PI_d16$1_0.VIN.n3 0.3855
R14658 6to4_0.buff_PI_d32_0.inv_PI_d16$1_0.VIN.n17 6to4_0.buff_PI_d32_0.inv_PI_d16$1_0.VIN.n15 0.3833
R14659 6to4_0.buff_PI_d32_0.inv_PI_d16$1_0.VIN.n25 6to4_0.buff_PI_d32_0.inv_PI_d16$1_0.VIN.n23 0.3833
R14660 6to4_0.buff_PI_d32_0.inv_PI_d16$1_0.VIN.n14 6to4_0.buff_PI_d32_0.inv_PI_d16$1_0.VIN.n13 0.3833
R14661 6to4_0.buff_PI_d32_0.inv_PI_d16$1_0.VIN.n33 6to4_0.buff_PI_d32_0.inv_PI_d16$1_0.VIN.n31 0.3833
R14662 6to4_0.buff_PI_d32_0.inv_PI_d16$1_0.VIN.n22 6to4_0.buff_PI_d32_0.inv_PI_d16$1_0.VIN.n21 0.3833
R14663 6to4_0.buff_PI_d32_0.inv_PI_d16$1_0.VIN.n30 6to4_0.buff_PI_d32_0.inv_PI_d16$1_0.VIN.n29 0.3833
R14664 6to4_0.buff_PI_d32_0.inv_PI_d16$1_0.VIN.n57 6to4_0.buff_PI_d32_0.inv_PI_d16$1_0.VIN 0.358
R14665 6to4_0.buff_PI_d32_0.inv_PI_d16$1_0.VIN.n51 6to4_0.buff_PI_d32_0.inv_PI_d16$1_0.VIN 0.358
R14666 6to4_0.buff_PI_d32_0.inv_PI_d16$1_0.VIN.n45 6to4_0.buff_PI_d32_0.inv_PI_d16$1_0.VIN 0.358
R14667 6to4_0.buff_PI_d32_0.inv_PI_d16$1_0.VIN.n39 6to4_0.buff_PI_d32_0.inv_PI_d16$1_0.VIN 0.358
R14668 6to4_0.buff_PI_d32_0.inv_PI_d16$1_0.VIN.n83 6to4_0.buff_PI_d32_0.inv_PI_d16$1_0.VIN 0.358
R14669 6to4_0.buff_PI_d32_0.inv_PI_d16$1_0.VIN.n77 6to4_0.buff_PI_d32_0.inv_PI_d16$1_0.VIN 0.358
R14670 6to4_0.buff_PI_d32_0.inv_PI_d16$1_0.VIN.n71 6to4_0.buff_PI_d32_0.inv_PI_d16$1_0.VIN 0.358
R14671 6to4_0.buff_PI_d32_0.inv_PI_d16$1_0.VIN.n65 6to4_0.buff_PI_d32_0.inv_PI_d16$1_0.VIN 0.358
R14672 6to4_0.buff_PI_d32_0.inv_PI_d16$1_0.VIN 6to4_0.buff_PI_d32_0.inv_PI_d16$1_0.VIN.n53 0.3305
R14673 6to4_0.buff_PI_d32_0.inv_PI_d16$1_0.VIN.n52 6to4_0.buff_PI_d32_0.inv_PI_d16$1_0.VIN 0.3305
R14674 6to4_0.buff_PI_d32_0.inv_PI_d16$1_0.VIN 6to4_0.buff_PI_d32_0.inv_PI_d16$1_0.VIN.n47 0.3305
R14675 6to4_0.buff_PI_d32_0.inv_PI_d16$1_0.VIN 6to4_0.buff_PI_d32_0.inv_PI_d16$1_0.VIN.n41 0.3305
R14676 6to4_0.buff_PI_d32_0.inv_PI_d16$1_0.VIN.n40 6to4_0.buff_PI_d32_0.inv_PI_d16$1_0.VIN 0.3305
R14677 6to4_0.buff_PI_d32_0.inv_PI_d16$1_0.VIN 6to4_0.buff_PI_d32_0.inv_PI_d16$1_0.VIN.n79 0.3305
R14678 6to4_0.buff_PI_d32_0.inv_PI_d16$1_0.VIN.n78 6to4_0.buff_PI_d32_0.inv_PI_d16$1_0.VIN 0.3305
R14679 6to4_0.buff_PI_d32_0.inv_PI_d16$1_0.VIN 6to4_0.buff_PI_d32_0.inv_PI_d16$1_0.VIN.n73 0.3305
R14680 6to4_0.buff_PI_d32_0.inv_PI_d16$1_0.VIN 6to4_0.buff_PI_d32_0.inv_PI_d16$1_0.VIN.n67 0.3305
R14681 6to4_0.buff_PI_d32_0.inv_PI_d16$1_0.VIN.n66 6to4_0.buff_PI_d32_0.inv_PI_d16$1_0.VIN 0.3305
R14682 6to4_0.buff_PI_d32_0.inv_PI_d16$1_0.VIN 6to4_0.buff_PI_d32_0.inv_PI_d16$1_0.VIN.n59 0.239357
R14683 6to4_0.buff_PI_d32_0.inv_PI_d16$1_0.VIN.n58 6to4_0.buff_PI_d32_0.inv_PI_d16$1_0.VIN 0.113938
R14684 6to4_0.buff_PI_d32_0.inv_PI_d16$1_0.VIN.n46 6to4_0.buff_PI_d32_0.inv_PI_d16$1_0.VIN 0.113938
R14685 6to4_0.buff_PI_d32_0.inv_PI_d16$1_0.VIN 6to4_0.buff_PI_d32_0.inv_PI_d16$1_0.VIN.n61 0.113938
R14686 6to4_0.buff_PI_d32_0.inv_PI_d16$1_0.VIN.n72 6to4_0.buff_PI_d32_0.inv_PI_d16$1_0.VIN 0.113938
R14687 6to4_0.buff_PI_d32_0.inv_PI_d16$1_0.VIN 6to4_0.buff_PI_d32_0.inv_PI_d16$1_0.VIN.n30 0.0662582
R14688 6to4_0.buff_PI_d32_0.inv_PI_d16$1_0.VIN 6to4_0.buff_PI_d32_0.inv_PI_d16$1_0.VIN.n57 0.062375
R14689 6to4_0.buff_PI_d32_0.inv_PI_d16$1_0.VIN.n54 6to4_0.buff_PI_d32_0.inv_PI_d16$1_0.VIN 0.062375
R14690 6to4_0.buff_PI_d32_0.inv_PI_d16$1_0.VIN 6to4_0.buff_PI_d32_0.inv_PI_d16$1_0.VIN.n51 0.062375
R14691 6to4_0.buff_PI_d32_0.inv_PI_d16$1_0.VIN.n48 6to4_0.buff_PI_d32_0.inv_PI_d16$1_0.VIN 0.062375
R14692 6to4_0.buff_PI_d32_0.inv_PI_d16$1_0.VIN 6to4_0.buff_PI_d32_0.inv_PI_d16$1_0.VIN.n45 0.062375
R14693 6to4_0.buff_PI_d32_0.inv_PI_d16$1_0.VIN.n42 6to4_0.buff_PI_d32_0.inv_PI_d16$1_0.VIN 0.062375
R14694 6to4_0.buff_PI_d32_0.inv_PI_d16$1_0.VIN 6to4_0.buff_PI_d32_0.inv_PI_d16$1_0.VIN.n39 0.062375
R14695 6to4_0.buff_PI_d32_0.inv_PI_d16$1_0.VIN.n36 6to4_0.buff_PI_d32_0.inv_PI_d16$1_0.VIN 0.062375
R14696 6to4_0.buff_PI_d32_0.inv_PI_d16$1_0.VIN 6to4_0.buff_PI_d32_0.inv_PI_d16$1_0.VIN.n83 0.062375
R14697 6to4_0.buff_PI_d32_0.inv_PI_d16$1_0.VIN.n80 6to4_0.buff_PI_d32_0.inv_PI_d16$1_0.VIN 0.062375
R14698 6to4_0.buff_PI_d32_0.inv_PI_d16$1_0.VIN 6to4_0.buff_PI_d32_0.inv_PI_d16$1_0.VIN.n77 0.062375
R14699 6to4_0.buff_PI_d32_0.inv_PI_d16$1_0.VIN.n74 6to4_0.buff_PI_d32_0.inv_PI_d16$1_0.VIN 0.062375
R14700 6to4_0.buff_PI_d32_0.inv_PI_d16$1_0.VIN 6to4_0.buff_PI_d32_0.inv_PI_d16$1_0.VIN.n71 0.062375
R14701 6to4_0.buff_PI_d32_0.inv_PI_d16$1_0.VIN.n68 6to4_0.buff_PI_d32_0.inv_PI_d16$1_0.VIN 0.062375
R14702 6to4_0.buff_PI_d32_0.inv_PI_d16$1_0.VIN 6to4_0.buff_PI_d32_0.inv_PI_d16$1_0.VIN.n65 0.062375
R14703 6to4_0.buff_PI_d32_0.inv_PI_d16$1_0.VIN.n62 6to4_0.buff_PI_d32_0.inv_PI_d16$1_0.VIN 0.062375
R14704 6to4_0.buff_PI_d32_0.inv_PI_d16$1_0.VIN.n31 6to4_0.buff_PI_d32_0.inv_PI_d16$1_0.VIN 0.059489
R14705 6to4_0.buff_PI_d32_0.inv_PI_d16$1_0.VIN.n28 6to4_0.buff_PI_d32_0.inv_PI_d16$1_0.VIN 0.0555
R14706 6to4_0.buff_PI_d32_0.inv_PI_d16$1_0.VIN.n20 6to4_0.buff_PI_d32_0.inv_PI_d16$1_0.VIN 0.0555
R14707 6to4_0.buff_PI_d32_0.inv_PI_d16$1_0.VIN.n12 6to4_0.buff_PI_d32_0.inv_PI_d16$1_0.VIN 0.0555
R14708 6to4_0.buff_PI_d32_0.inv_PI_d16$1_0.VIN.n9 6to4_0.buff_PI_d32_0.inv_PI_d16$1_0.VIN 0.0555
R14709 6to4_0.buff_PI_d32_0.inv_PI_d16$1_0.VIN.n6 6to4_0.buff_PI_d32_0.inv_PI_d16$1_0.VIN 0.0555
R14710 6to4_0.buff_PI_d32_0.inv_PI_d16$1_0.VIN.n16 6to4_0.buff_PI_d32_0.inv_PI_d16$1_0.VIN 0.0555
R14711 6to4_0.buff_PI_d32_0.inv_PI_d16$1_0.VIN.n24 6to4_0.buff_PI_d32_0.inv_PI_d16$1_0.VIN 0.0555
R14712 6to4_0.buff_PI_d32_0.inv_PI_d16$1_0.VIN.n32 6to4_0.buff_PI_d32_0.inv_PI_d16$1_0.VIN 0.0555
R14713 6to4_0.buff_PI_d32_0.inv_PI_d16$1_0.VIN 6to4_0.buff_PI_d32_0.inv_PI_d16$1_0.VIN.n56 0.034875
R14714 6to4_0.buff_PI_d32_0.inv_PI_d16$1_0.VIN 6to4_0.buff_PI_d32_0.inv_PI_d16$1_0.VIN.n50 0.034875
R14715 6to4_0.buff_PI_d32_0.inv_PI_d16$1_0.VIN 6to4_0.buff_PI_d32_0.inv_PI_d16$1_0.VIN.n44 0.034875
R14716 6to4_0.buff_PI_d32_0.inv_PI_d16$1_0.VIN 6to4_0.buff_PI_d32_0.inv_PI_d16$1_0.VIN.n38 0.034875
R14717 6to4_0.buff_PI_d32_0.inv_PI_d16$1_0.VIN 6to4_0.buff_PI_d32_0.inv_PI_d16$1_0.VIN.n82 0.034875
R14718 6to4_0.buff_PI_d32_0.inv_PI_d16$1_0.VIN 6to4_0.buff_PI_d32_0.inv_PI_d16$1_0.VIN.n76 0.034875
R14719 6to4_0.buff_PI_d32_0.inv_PI_d16$1_0.VIN 6to4_0.buff_PI_d32_0.inv_PI_d16$1_0.VIN.n70 0.034875
R14720 6to4_0.buff_PI_d32_0.inv_PI_d16$1_0.VIN 6to4_0.buff_PI_d32_0.inv_PI_d16$1_0.VIN.n64 0.034875
R14721 6to4_0.buff_PI_d32_0.inv_PI_d16$1_0.VIN.n0 6to4_0.buff_PI_d32_0.inv_PI_d16$1_0.VIN 0.0115
R14722 6to4_0.buff_PI_d32_0.inv_PI_d16$1_0.VIN.n2 6to4_0.buff_PI_d32_0.inv_PI_d16$1_0.VIN 0.0115
R14723 6to4_0.buff_PI_d32_0.inv_PI_d16$1_0.VIN.n4 6to4_0.buff_PI_d32_0.inv_PI_d16$1_0.VIN 0.0115
R14724 6to4_0.buff_PI_d32_0.inv_PI_d16$1_0.VIN.n10 6to4_0.buff_PI_d32_0.inv_PI_d16$1_0.VIN 0.0115
R14725 6to4_0.buff_PI_d32_0.inv_PI_d16$1_0.VIN.n7 6to4_0.buff_PI_d32_0.inv_PI_d16$1_0.VIN 0.0115
R14726 6to4_0.buff_PI_d32_0.inv_PI_d16$1_0.VIN.n18 6to4_0.buff_PI_d32_0.inv_PI_d16$1_0.VIN 0.0115
R14727 6to4_0.buff_PI_d32_0.inv_PI_d16$1_0.VIN.n26 6to4_0.buff_PI_d32_0.inv_PI_d16$1_0.VIN 0.0115
R14728 6to4_0.buff_PI_d32_0.inv_PI_d16$1_0.VIN.n34 6to4_0.buff_PI_d32_0.inv_PI_d16$1_0.VIN 0.0115
R14729 6to4_0.buff_PI_d32_0.inv_PI_d16$1_0.VIN 6to4_0.buff_PI_d32_0.inv_PI_d16$1_0.VIN.n60 0.00469048
R14730 6ph_rosc_0.PH1.n20 6ph_rosc_0.PH1 33.1992
R14731 6ph_rosc_0.PH1.n23 6ph_rosc_0.PH1.n22 25.5471
R14732 6ph_rosc_0.PH1.n11 6ph_rosc_0.PH1.t8 17.0005
R14733 6ph_rosc_0.PH1.n13 6ph_rosc_0.PH1.t9 17.0005
R14734 6ph_rosc_0.PH1.n6 6ph_rosc_0.PH1.t3 17.0005
R14735 6ph_rosc_0.PH1.n8 6ph_rosc_0.PH1.t5 17.0005
R14736 6ph_rosc_0.PH1.n3 6ph_rosc_0.PH1.t0 17.0005
R14737 6ph_rosc_0.PH1.n5 6ph_rosc_0.PH1.t7 17.0005
R14738 6ph_rosc_0.PH1.n0 6ph_rosc_0.PH1.t2 17.0005
R14739 6ph_rosc_0.PH1.n2 6ph_rosc_0.PH1.t4 17.0005
R14740 6ph_rosc_0.PH1.n24 6ph_rosc_0.PH1.t6 17.0005
R14741 6ph_rosc_0.PH1.n26 6ph_rosc_0.PH1.t1 17.0005
R14742 6ph_rosc_0.PH1.n21 6ph_rosc_0.PH1.t10 15.0005
R14743 6ph_rosc_0.PH1.n18 6ph_rosc_0.PH1.t12 15.0005
R14744 6ph_rosc_0.PH1.n17 6ph_rosc_0.PH1.t11 15.0005
R14745 6ph_rosc_0.PH1.n14 6ph_rosc_0.PH1.t14 15.0005
R14746 6ph_rosc_0.PH1 6ph_rosc_0.PH1.t13 15.0005
R14747 6ph_rosc_0.PH1.n19 6ph_rosc_0.PH1.n17 10.3469
R14748 6ph_rosc_0.PH1.n15 6ph_rosc_0.PH1.n13 9.9157
R14749 6ph_rosc_0.PH1.n9 6ph_rosc_0.PH1.n8 9.91525
R14750 6ph_rosc_0.PH1.n24 6ph_rosc_0.PH1.n23 9.15359
R14751 6ph_rosc_0.PH1.n9 6ph_rosc_0.PH1.n5 9.12325
R14752 6ph_rosc_0.PH1.n10 6ph_rosc_0.PH1.n2 9.12325
R14753 6ph_rosc_0.PH1.n19 6ph_rosc_0.PH1.n18 9.0005
R14754 6ph_rosc_0.PH1.n16 6ph_rosc_0.PH1 9.0005
R14755 6ph_rosc_0.PH1.n15 6ph_rosc_0.PH1.n14 9.0005
R14756 6ph_rosc_0.PH1.n22 6ph_rosc_0.PH1.n21 9.0005
R14757 6ph_rosc_0.PH1.n13 6ph_rosc_0.PH1 1.19877
R14758 6ph_rosc_0.PH1.n8 6ph_rosc_0.PH1 1.19877
R14759 6ph_rosc_0.PH1.n5 6ph_rosc_0.PH1 1.19877
R14760 6ph_rosc_0.PH1.n2 6ph_rosc_0.PH1 1.19877
R14761 6ph_rosc_0.PH1.n24 6ph_rosc_0.PH1 1.19877
R14762 6ph_rosc_0.PH1.n20 6ph_rosc_0.PH1.n16 1.19719
R14763 6ph_rosc_0.PH1.n22 6ph_rosc_0.PH1.n20 0.806901
R14764 6ph_rosc_0.PH1.n23 6ph_rosc_0.PH1.n10 0.7287
R14765 6ph_rosc_0.PH1.n12 6ph_rosc_0.PH1 0.559983
R14766 6ph_rosc_0.PH1.n7 6ph_rosc_0.PH1 0.559983
R14767 6ph_rosc_0.PH1.n4 6ph_rosc_0.PH1 0.559983
R14768 6ph_rosc_0.PH1.n1 6ph_rosc_0.PH1 0.559983
R14769 6ph_rosc_0.PH1.n25 6ph_rosc_0.PH1 0.559983
R14770 6ph_rosc_0.PH1.n16 6ph_rosc_0.PH1.n15 0.4405
R14771 6ph_rosc_0.PH1.n10 6ph_rosc_0.PH1 0.4273
R14772 6ph_rosc_0.PH1 6ph_rosc_0.PH1.n9 0.3657
R14773 6ph_rosc_0.PH1.n12 6ph_rosc_0.PH1 0.292688
R14774 6ph_rosc_0.PH1.n7 6ph_rosc_0.PH1 0.292688
R14775 6ph_rosc_0.PH1.n4 6ph_rosc_0.PH1 0.292688
R14776 6ph_rosc_0.PH1.n1 6ph_rosc_0.PH1 0.292688
R14777 6ph_rosc_0.PH1 6ph_rosc_0.PH1.n25 0.292688
R14778 6ph_rosc_0.PH1 6ph_rosc_0.PH1.n11 0.282375
R14779 6ph_rosc_0.PH1 6ph_rosc_0.PH1.n6 0.282375
R14780 6ph_rosc_0.PH1 6ph_rosc_0.PH1.n3 0.282375
R14781 6ph_rosc_0.PH1 6ph_rosc_0.PH1.n0 0.282375
R14782 6ph_rosc_0.PH1.n26 6ph_rosc_0.PH1 0.282375
R14783 6ph_rosc_0.PH1.n11 6ph_rosc_0.PH1 0.089875
R14784 6ph_rosc_0.PH1.n6 6ph_rosc_0.PH1 0.089875
R14785 6ph_rosc_0.PH1.n3 6ph_rosc_0.PH1 0.089875
R14786 6ph_rosc_0.PH1.n0 6ph_rosc_0.PH1 0.089875
R14787 6ph_rosc_0.PH1 6ph_rosc_0.PH1.n26 0.089875
R14788 6ph_rosc_0.PH1 6ph_rosc_0.PH1.n19 0.0643
R14789 6ph_rosc_0.PH1.n17 6ph_rosc_0.PH1 0.0555
R14790 6ph_rosc_0.PH1.n13 6ph_rosc_0.PH1.n12 0.0403276
R14791 6ph_rosc_0.PH1.n8 6ph_rosc_0.PH1.n7 0.0403276
R14792 6ph_rosc_0.PH1.n5 6ph_rosc_0.PH1.n4 0.0403276
R14793 6ph_rosc_0.PH1.n2 6ph_rosc_0.PH1.n1 0.0403276
R14794 6ph_rosc_0.PH1.n25 6ph_rosc_0.PH1.n24 0.0403276
R14795 6ph_rosc_0.PH1.n21 6ph_rosc_0.PH1 0.0316667
R14796 6ph_rosc_0.PH1.n14 6ph_rosc_0.PH1 0.0151667
R14797 6ph_rosc_0.PH1.n21 6ph_rosc_0.PH1 0.0115
R14798 6ph_rosc_0.PH1.n18 6ph_rosc_0.PH1 0.0115
R14799 6ph_rosc_0.PH0.n16 6ph_rosc_0.PH0 24.2883
R14800 6ph_rosc_0.PH0 6ph_rosc_0.PH0.t9 17.3649
R14801 6ph_rosc_0.PH0.n18 6ph_rosc_0.PH0.t1 17.0005
R14802 6ph_rosc_0.PH0.n20 6ph_rosc_0.PH0.t4 17.0005
R14803 6ph_rosc_0.PH0.n9 6ph_rosc_0.PH0.t8 17.0005
R14804 6ph_rosc_0.PH0.n0 6ph_rosc_0.PH0.t0 17.0005
R14805 6ph_rosc_0.PH0.n2 6ph_rosc_0.PH0.t6 17.0005
R14806 6ph_rosc_0.PH0.n3 6ph_rosc_0.PH0.t2 17.0005
R14807 6ph_rosc_0.PH0.n5 6ph_rosc_0.PH0.t7 17.0005
R14808 6ph_rosc_0.PH0.n23 6ph_rosc_0.PH0.t5 17.0005
R14809 6ph_rosc_0.PH0.n25 6ph_rosc_0.PH0.t3 17.0005
R14810 6ph_rosc_0.PH0 6ph_rosc_0.PH0.t10 15.0005
R14811 6ph_rosc_0.PH0.n14 6ph_rosc_0.PH0.t14 15.0005
R14812 6ph_rosc_0.PH0.n13 6ph_rosc_0.PH0.t12 15.0005
R14813 6ph_rosc_0.PH0 6ph_rosc_0.PH0.t13 15.0005
R14814 6ph_rosc_0.PH0.n10 6ph_rosc_0.PH0.t11 15.0005
R14815 6ph_rosc_0.PH0.n15 6ph_rosc_0.PH0.n13 10.3469
R14816 6ph_rosc_0.PH0.n11 6ph_rosc_0.PH0.n9 9.9201
R14817 6ph_rosc_0.PH0.n6 6ph_rosc_0.PH0.n5 9.91525
R14818 6ph_rosc_0.PH0.n21 6ph_rosc_0.PH0.n20 9.12325
R14819 6ph_rosc_0.PH0.n6 6ph_rosc_0.PH0.n2 9.12325
R14820 6ph_rosc_0.PH0.n23 6ph_rosc_0.PH0.n22 9.12325
R14821 6ph_rosc_0.PH0.n15 6ph_rosc_0.PH0.n14 9.0005
R14822 6ph_rosc_0.PH0.n11 6ph_rosc_0.PH0.n10 9.0005
R14823 6ph_rosc_0.PH0.n12 6ph_rosc_0.PH0 9.0005
R14824 6ph_rosc_0.PH0.n17 6ph_rosc_0.PH0 9.0005
R14825 6ph_rosc_0.PH0.n21 6ph_rosc_0.PH0.n17 3.2455
R14826 6ph_rosc_0.PH0.n20 6ph_rosc_0.PH0 1.19877
R14827 6ph_rosc_0.PH0.n2 6ph_rosc_0.PH0 1.19877
R14828 6ph_rosc_0.PH0.n5 6ph_rosc_0.PH0 1.19877
R14829 6ph_rosc_0.PH0.n23 6ph_rosc_0.PH0 1.19877
R14830 6ph_rosc_0.PH0.n16 6ph_rosc_0.PH0.n12 1.19719
R14831 6ph_rosc_0.PH0.n17 6ph_rosc_0.PH0.n16 0.806901
R14832 6ph_rosc_0.PH0.n22 6ph_rosc_0.PH0.n21 0.7925
R14833 6ph_rosc_0.PH0.n19 6ph_rosc_0.PH0 0.559983
R14834 6ph_rosc_0.PH0.n1 6ph_rosc_0.PH0 0.559983
R14835 6ph_rosc_0.PH0.n4 6ph_rosc_0.PH0 0.559983
R14836 6ph_rosc_0.PH0.n24 6ph_rosc_0.PH0 0.559983
R14837 6ph_rosc_0.PH0.n12 6ph_rosc_0.PH0.n11 0.4405
R14838 6ph_rosc_0.PH0.n22 6ph_rosc_0.PH0 0.4273
R14839 6ph_rosc_0.PH0 6ph_rosc_0.PH0.n6 0.3657
R14840 6ph_rosc_0.PH0.n8 6ph_rosc_0.PH0 0.3525
R14841 6ph_rosc_0.PH0.n19 6ph_rosc_0.PH0 0.292688
R14842 6ph_rosc_0.PH0.n1 6ph_rosc_0.PH0 0.292688
R14843 6ph_rosc_0.PH0.n4 6ph_rosc_0.PH0 0.292688
R14844 6ph_rosc_0.PH0 6ph_rosc_0.PH0.n24 0.292688
R14845 6ph_rosc_0.PH0 6ph_rosc_0.PH0.n18 0.282375
R14846 6ph_rosc_0.PH0 6ph_rosc_0.PH0.n0 0.282375
R14847 6ph_rosc_0.PH0 6ph_rosc_0.PH0.n3 0.282375
R14848 6ph_rosc_0.PH0.n25 6ph_rosc_0.PH0 0.282375
R14849 6ph_rosc_0.PH0.n7 6ph_rosc_0.PH0 0.210188
R14850 6ph_rosc_0.PH0.n7 6ph_rosc_0.PH0 0.162063
R14851 6ph_rosc_0.PH0.n18 6ph_rosc_0.PH0 0.089875
R14852 6ph_rosc_0.PH0.n0 6ph_rosc_0.PH0 0.089875
R14853 6ph_rosc_0.PH0.n3 6ph_rosc_0.PH0 0.089875
R14854 6ph_rosc_0.PH0 6ph_rosc_0.PH0.n25 0.089875
R14855 6ph_rosc_0.PH0 6ph_rosc_0.PH0.n15 0.0643
R14856 6ph_rosc_0.PH0.n13 6ph_rosc_0.PH0 0.0555
R14857 6ph_rosc_0.PH0.n10 6ph_rosc_0.PH0 0.0555
R14858 6ph_rosc_0.PH0.n20 6ph_rosc_0.PH0.n19 0.0403276
R14859 6ph_rosc_0.PH0.n9 6ph_rosc_0.PH0.n7 0.0403276
R14860 6ph_rosc_0.PH0.n9 6ph_rosc_0.PH0.n8 0.0403276
R14861 6ph_rosc_0.PH0.n2 6ph_rosc_0.PH0.n1 0.0403276
R14862 6ph_rosc_0.PH0.n5 6ph_rosc_0.PH0.n4 0.0403276
R14863 6ph_rosc_0.PH0.n24 6ph_rosc_0.PH0.n23 0.0403276
R14864 6ph_rosc_0.PH0.n14 6ph_rosc_0.PH0 0.0115
R14865 6ph_rosc_0.PH0.n10 6ph_rosc_0.PH0 0.0115
R14866 6ph_rosc_0.PH0.n8 6ph_rosc_0.PH0 0.00998276
R14867 6ph_rosc_0.psdiff_0.buff_d8$1_0.VIN.n21 6ph_rosc_0.psdiff_0.buff_d8$1_0.VIN.n20 36.6537
R14868 6ph_rosc_0.psdiff_0.buff_d8$1_0.VIN.n29 6ph_rosc_0.psdiff_0.buff_d8$1_0.VIN.n28 19.5243
R14869 6ph_rosc_0.psdiff_0.buff_d8$1_0.VIN.n6 6ph_rosc_0.psdiff_0.buff_d8$1_0.VIN.t29 17.3511
R14870 6ph_rosc_0.psdiff_0.buff_d8$1_0.VIN.n4 6ph_rosc_0.psdiff_0.buff_d8$1_0.VIN.t22 17.3511
R14871 6ph_rosc_0.psdiff_0.buff_d8$1_0.VIN.n2 6ph_rosc_0.psdiff_0.buff_d8$1_0.VIN.t17 17.3511
R14872 6ph_rosc_0.psdiff_0.buff_d8$1_0.VIN.n0 6ph_rosc_0.psdiff_0.buff_d8$1_0.VIN.t23 17.3511
R14873 6ph_rosc_0.psdiff_0.buff_d8$1_0.VIN.n8 6ph_rosc_0.psdiff_0.buff_d8$1_0.VIN.t7 17.3511
R14874 6ph_rosc_0.psdiff_0.buff_d8$1_0.VIN.n9 6ph_rosc_0.psdiff_0.buff_d8$1_0.VIN.t1 17.3511
R14875 6ph_rosc_0.psdiff_0.buff_d8$1_0.VIN.n11 6ph_rosc_0.psdiff_0.buff_d8$1_0.VIN.t4 17.3511
R14876 6ph_rosc_0.psdiff_0.buff_d8$1_0.VIN.n13 6ph_rosc_0.psdiff_0.buff_d8$1_0.VIN.t2 17.3511
R14877 6ph_rosc_0.psdiff_0.buff_d8$1_0.VIN.n17 6ph_rosc_0.psdiff_0.buff_d8$1_0.VIN.t9 17.3511
R14878 6ph_rosc_0.psdiff_0.buff_d8$1_0.VIN.n23 6ph_rosc_0.psdiff_0.buff_d8$1_0.VIN.t11 17.2171
R14879 6ph_rosc_0.psdiff_0.buff_d8$1_0.VIN.n6 6ph_rosc_0.psdiff_0.buff_d8$1_0.VIN.t25 17.0005
R14880 6ph_rosc_0.psdiff_0.buff_d8$1_0.VIN.n7 6ph_rosc_0.psdiff_0.buff_d8$1_0.VIN.t26 17.0005
R14881 6ph_rosc_0.psdiff_0.buff_d8$1_0.VIN.n4 6ph_rosc_0.psdiff_0.buff_d8$1_0.VIN.t19 17.0005
R14882 6ph_rosc_0.psdiff_0.buff_d8$1_0.VIN.n5 6ph_rosc_0.psdiff_0.buff_d8$1_0.VIN.t20 17.0005
R14883 6ph_rosc_0.psdiff_0.buff_d8$1_0.VIN.n2 6ph_rosc_0.psdiff_0.buff_d8$1_0.VIN.t30 17.0005
R14884 6ph_rosc_0.psdiff_0.buff_d8$1_0.VIN.n3 6ph_rosc_0.psdiff_0.buff_d8$1_0.VIN.t31 17.0005
R14885 6ph_rosc_0.psdiff_0.buff_d8$1_0.VIN.n0 6ph_rosc_0.psdiff_0.buff_d8$1_0.VIN.t18 17.0005
R14886 6ph_rosc_0.psdiff_0.buff_d8$1_0.VIN.n1 6ph_rosc_0.psdiff_0.buff_d8$1_0.VIN.t21 17.0005
R14887 6ph_rosc_0.psdiff_0.buff_d8$1_0.VIN.n28 6ph_rosc_0.psdiff_0.buff_d8$1_0.VIN.t27 17.0005
R14888 6ph_rosc_0.psdiff_0.buff_d8$1_0.VIN.n27 6ph_rosc_0.psdiff_0.buff_d8$1_0.VIN.t28 17.0005
R14889 6ph_rosc_0.psdiff_0.buff_d8$1_0.VIN.n26 6ph_rosc_0.psdiff_0.buff_d8$1_0.VIN.t24 17.0005
R14890 6ph_rosc_0.psdiff_0.buff_d8$1_0.VIN.n21 6ph_rosc_0.psdiff_0.buff_d8$1_0.VIN.t10 17.0005
R14891 6ph_rosc_0.psdiff_0.buff_d8$1_0.VIN.n8 6ph_rosc_0.psdiff_0.buff_d8$1_0.VIN.t3 17.0005
R14892 6ph_rosc_0.psdiff_0.buff_d8$1_0.VIN.n20 6ph_rosc_0.psdiff_0.buff_d8$1_0.VIN.t14 17.0005
R14893 6ph_rosc_0.psdiff_0.buff_d8$1_0.VIN.n10 6ph_rosc_0.psdiff_0.buff_d8$1_0.VIN.t13 17.0005
R14894 6ph_rosc_0.psdiff_0.buff_d8$1_0.VIN.n9 6ph_rosc_0.psdiff_0.buff_d8$1_0.VIN.t6 17.0005
R14895 6ph_rosc_0.psdiff_0.buff_d8$1_0.VIN.n12 6ph_rosc_0.psdiff_0.buff_d8$1_0.VIN.t12 17.0005
R14896 6ph_rosc_0.psdiff_0.buff_d8$1_0.VIN.n11 6ph_rosc_0.psdiff_0.buff_d8$1_0.VIN.t8 17.0005
R14897 6ph_rosc_0.psdiff_0.buff_d8$1_0.VIN.n14 6ph_rosc_0.psdiff_0.buff_d8$1_0.VIN.t16 17.0005
R14898 6ph_rosc_0.psdiff_0.buff_d8$1_0.VIN.n13 6ph_rosc_0.psdiff_0.buff_d8$1_0.VIN.t5 17.0005
R14899 6ph_rosc_0.psdiff_0.buff_d8$1_0.VIN.n18 6ph_rosc_0.psdiff_0.buff_d8$1_0.VIN.t15 17.0005
R14900 6ph_rosc_0.psdiff_0.buff_d8$1_0.VIN.n17 6ph_rosc_0.psdiff_0.buff_d8$1_0.VIN.t0 17.0005
R14901 6ph_rosc_0.psdiff_0.buff_d8$1_0.VIN.n29 6ph_rosc_0.psdiff_0.buff_d8$1_0.VIN.t32 15.0005
R14902 6ph_rosc_0.psdiff_0.buff_d8$1_0.VIN.n26 6ph_rosc_0.psdiff_0.buff_d8$1_0.VIN.n25 0.997375
R14903 6ph_rosc_0.psdiff_0.buff_d8$1_0.VIN.n15 6ph_rosc_0.psdiff_0.buff_d8$1_0.VIN.n14 0.997375
R14904 6ph_rosc_0.psdiff_0.buff_d8$1_0.VIN.n20 6ph_rosc_0.psdiff_0.buff_d8$1_0.VIN.n19 0.965015
R14905 6ph_rosc_0.psdiff_0.buff_d8$1_0.VIN.n25 6ph_rosc_0.psdiff_0.buff_d8$1_0.VIN.n24 0.78425
R14906 6ph_rosc_0.psdiff_0.buff_d8$1_0.VIN.n24 6ph_rosc_0.psdiff_0.buff_d8$1_0.VIN.n23 0.78425
R14907 6ph_rosc_0.psdiff_0.buff_d8$1_0.VIN.n23 6ph_rosc_0.psdiff_0.buff_d8$1_0.VIN.n22 0.78425
R14908 6ph_rosc_0.psdiff_0.buff_d8$1_0.VIN.n19 6ph_rosc_0.psdiff_0.buff_d8$1_0.VIN.n16 0.78425
R14909 6ph_rosc_0.psdiff_0.buff_d8$1_0.VIN.n16 6ph_rosc_0.psdiff_0.buff_d8$1_0.VIN.n15 0.78425
R14910 6ph_rosc_0.psdiff_0.buff_d8$1_0.VIN.n10 6ph_rosc_0.psdiff_0.buff_d8$1_0.VIN.n9 0.622687
R14911 6ph_rosc_0.psdiff_0.buff_d8$1_0.VIN.n12 6ph_rosc_0.psdiff_0.buff_d8$1_0.VIN.n11 0.622687
R14912 6ph_rosc_0.psdiff_0.buff_d8$1_0.VIN.n14 6ph_rosc_0.psdiff_0.buff_d8$1_0.VIN.n13 0.622687
R14913 6ph_rosc_0.psdiff_0.buff_d8$1_0.VIN.n18 6ph_rosc_0.psdiff_0.buff_d8$1_0.VIN.n17 0.622687
R14914 6ph_rosc_0.psdiff_0.buff_d8$1_0.VIN.n20 6ph_rosc_0.psdiff_0.buff_d8$1_0.VIN.n8 0.590328
R14915 6ph_rosc_0.psdiff_0.buff_d8$1_0.VIN.n7 6ph_rosc_0.psdiff_0.buff_d8$1_0.VIN.n6 0.351125
R14916 6ph_rosc_0.psdiff_0.buff_d8$1_0.VIN.n5 6ph_rosc_0.psdiff_0.buff_d8$1_0.VIN.n4 0.351125
R14917 6ph_rosc_0.psdiff_0.buff_d8$1_0.VIN.n3 6ph_rosc_0.psdiff_0.buff_d8$1_0.VIN.n2 0.351125
R14918 6ph_rosc_0.psdiff_0.buff_d8$1_0.VIN.n1 6ph_rosc_0.psdiff_0.buff_d8$1_0.VIN.n0 0.351125
R14919 6ph_rosc_0.psdiff_0.buff_d8$1_0.VIN.n27 6ph_rosc_0.psdiff_0.buff_d8$1_0.VIN.n26 0.351125
R14920 6ph_rosc_0.psdiff_0.buff_d8$1_0.VIN.n28 6ph_rosc_0.psdiff_0.buff_d8$1_0.VIN.n27 0.318765
R14921 6ph_rosc_0.psdiff_0.buff_d8$1_0.VIN.n22 6ph_rosc_0.psdiff_0.buff_d8$1_0.VIN.n7 0.213625
R14922 6ph_rosc_0.psdiff_0.buff_d8$1_0.VIN.n23 6ph_rosc_0.psdiff_0.buff_d8$1_0.VIN.n5 0.213625
R14923 6ph_rosc_0.psdiff_0.buff_d8$1_0.VIN.n24 6ph_rosc_0.psdiff_0.buff_d8$1_0.VIN.n3 0.213625
R14924 6ph_rosc_0.psdiff_0.buff_d8$1_0.VIN.n25 6ph_rosc_0.psdiff_0.buff_d8$1_0.VIN.n1 0.213625
R14925 6ph_rosc_0.psdiff_0.buff_d8$1_0.VIN.n16 6ph_rosc_0.psdiff_0.buff_d8$1_0.VIN.n10 0.213625
R14926 6ph_rosc_0.psdiff_0.buff_d8$1_0.VIN.n15 6ph_rosc_0.psdiff_0.buff_d8$1_0.VIN.n12 0.213625
R14927 6ph_rosc_0.psdiff_0.buff_d8$1_0.VIN.n19 6ph_rosc_0.psdiff_0.buff_d8$1_0.VIN.n18 0.213625
R14928 6ph_rosc_0.psdiff_0.buff_d8$1_0.VIN.n22 6ph_rosc_0.psdiff_0.buff_d8$1_0.VIN.n21 0.184703
R14929 6ph_rosc_0.psdiff_0.buff_d8$1_0.inv$3_0.VIN 6ph_rosc_0.psdiff_0.buff_d8$1_0.VIN.n29 0.0555
R14930 6ph_rosc_0.psdiff_0.buff_d8$1_0.VIN.n29 6ph_rosc_0.psdiff_0.buff_d8$1_0.inv$3_0.VIN 0.0151667
R14931 6to4_0.buff_PI_d32_3.inv_PI_d16$1_0.VIN.n36 6to4_0.buff_PI_d32_3.inv_PI_d16$1_0.VIN.t30 17.6089
R14932 6to4_0.buff_PI_d32_3.inv_PI_d16$1_0.VIN.n39 6to4_0.buff_PI_d32_3.inv_PI_d16$1_0.VIN.t9 17.6089
R14933 6to4_0.buff_PI_d32_3.inv_PI_d16$1_0.VIN.n42 6to4_0.buff_PI_d32_3.inv_PI_d16$1_0.VIN.t33 17.6089
R14934 6to4_0.buff_PI_d32_3.inv_PI_d16$1_0.VIN.n45 6to4_0.buff_PI_d32_3.inv_PI_d16$1_0.VIN.t12 17.6089
R14935 6to4_0.buff_PI_d32_3.inv_PI_d16$1_0.VIN.n48 6to4_0.buff_PI_d32_3.inv_PI_d16$1_0.VIN.t15 17.6089
R14936 6to4_0.buff_PI_d32_3.inv_PI_d16$1_0.VIN.n51 6to4_0.buff_PI_d32_3.inv_PI_d16$1_0.VIN.t45 17.6089
R14937 6to4_0.buff_PI_d32_3.inv_PI_d16$1_0.VIN.n54 6to4_0.buff_PI_d32_3.inv_PI_d16$1_0.VIN.t42 17.6089
R14938 6to4_0.buff_PI_d32_3.inv_PI_d16$1_0.VIN.n57 6to4_0.buff_PI_d32_3.inv_PI_d16$1_0.VIN.t39 17.6089
R14939 6to4_0.buff_PI_d32_3.inv_PI_d16$1_0.VIN.n62 6to4_0.buff_PI_d32_3.inv_PI_d16$1_0.VIN.t6 17.6089
R14940 6to4_0.buff_PI_d32_3.inv_PI_d16$1_0.VIN.n65 6to4_0.buff_PI_d32_3.inv_PI_d16$1_0.VIN.t21 17.6089
R14941 6to4_0.buff_PI_d32_3.inv_PI_d16$1_0.VIN.n68 6to4_0.buff_PI_d32_3.inv_PI_d16$1_0.VIN.t18 17.6089
R14942 6to4_0.buff_PI_d32_3.inv_PI_d16$1_0.VIN.n74 6to4_0.buff_PI_d32_3.inv_PI_d16$1_0.VIN.t27 17.6089
R14943 6to4_0.buff_PI_d32_3.inv_PI_d16$1_0.VIN.n77 6to4_0.buff_PI_d32_3.inv_PI_d16$1_0.VIN.t36 17.6089
R14944 6to4_0.buff_PI_d32_3.inv_PI_d16$1_0.VIN.n80 6to4_0.buff_PI_d32_3.inv_PI_d16$1_0.VIN.t3 17.6089
R14945 6to4_0.buff_PI_d32_3.inv_PI_d16$1_0.VIN.n83 6to4_0.buff_PI_d32_3.inv_PI_d16$1_0.VIN.t24 17.6089
R14946 6to4_0.buff_PI_d32_3.inv_PI_d16$1_0.VIN.n71 6to4_0.buff_PI_d32_3.inv_PI_d16$1_0.VIN.t0 17.6089
R14947 6to4_0.buff_PI_d32_3.inv_PI_d16$1_0.VIN 6to4_0.buff_PI_d32_3.inv_PI_d16$1_0.VIN.t31 17.5436
R14948 6to4_0.buff_PI_d32_3.inv_PI_d16$1_0.VIN 6to4_0.buff_PI_d32_3.inv_PI_d16$1_0.VIN.t7 17.5436
R14949 6to4_0.buff_PI_d32_3.inv_PI_d16$1_0.VIN.n58 6to4_0.buff_PI_d32_3.inv_PI_d16$1_0.VIN.t40 17.2136
R14950 6to4_0.buff_PI_d32_3.inv_PI_d16$1_0.VIN.n56 6to4_0.buff_PI_d32_3.inv_PI_d16$1_0.VIN.t41 17.2136
R14951 6to4_0.buff_PI_d32_3.inv_PI_d16$1_0.VIN.n55 6to4_0.buff_PI_d32_3.inv_PI_d16$1_0.VIN.t43 17.2136
R14952 6to4_0.buff_PI_d32_3.inv_PI_d16$1_0.VIN.n53 6to4_0.buff_PI_d32_3.inv_PI_d16$1_0.VIN.t44 17.2136
R14953 6to4_0.buff_PI_d32_3.inv_PI_d16$1_0.VIN.n52 6to4_0.buff_PI_d32_3.inv_PI_d16$1_0.VIN.t46 17.2136
R14954 6to4_0.buff_PI_d32_3.inv_PI_d16$1_0.VIN.n50 6to4_0.buff_PI_d32_3.inv_PI_d16$1_0.VIN.t47 17.2136
R14955 6to4_0.buff_PI_d32_3.inv_PI_d16$1_0.VIN.n49 6to4_0.buff_PI_d32_3.inv_PI_d16$1_0.VIN.t16 17.2136
R14956 6to4_0.buff_PI_d32_3.inv_PI_d16$1_0.VIN.n47 6to4_0.buff_PI_d32_3.inv_PI_d16$1_0.VIN.t17 17.2136
R14957 6to4_0.buff_PI_d32_3.inv_PI_d16$1_0.VIN.n46 6to4_0.buff_PI_d32_3.inv_PI_d16$1_0.VIN.t14 17.2136
R14958 6to4_0.buff_PI_d32_3.inv_PI_d16$1_0.VIN.n44 6to4_0.buff_PI_d32_3.inv_PI_d16$1_0.VIN.t13 17.2136
R14959 6to4_0.buff_PI_d32_3.inv_PI_d16$1_0.VIN.n43 6to4_0.buff_PI_d32_3.inv_PI_d16$1_0.VIN.t35 17.2136
R14960 6to4_0.buff_PI_d32_3.inv_PI_d16$1_0.VIN.n41 6to4_0.buff_PI_d32_3.inv_PI_d16$1_0.VIN.t34 17.2136
R14961 6to4_0.buff_PI_d32_3.inv_PI_d16$1_0.VIN.n40 6to4_0.buff_PI_d32_3.inv_PI_d16$1_0.VIN.t11 17.2136
R14962 6to4_0.buff_PI_d32_3.inv_PI_d16$1_0.VIN.n38 6to4_0.buff_PI_d32_3.inv_PI_d16$1_0.VIN.t10 17.2136
R14963 6to4_0.buff_PI_d32_3.inv_PI_d16$1_0.VIN.n37 6to4_0.buff_PI_d32_3.inv_PI_d16$1_0.VIN.t32 17.2136
R14964 6to4_0.buff_PI_d32_3.inv_PI_d16$1_0.VIN.n61 6to4_0.buff_PI_d32_3.inv_PI_d16$1_0.VIN.t26 17.2136
R14965 6to4_0.buff_PI_d32_3.inv_PI_d16$1_0.VIN.n82 6to4_0.buff_PI_d32_3.inv_PI_d16$1_0.VIN.t25 17.2136
R14966 6to4_0.buff_PI_d32_3.inv_PI_d16$1_0.VIN.n81 6to4_0.buff_PI_d32_3.inv_PI_d16$1_0.VIN.t5 17.2136
R14967 6to4_0.buff_PI_d32_3.inv_PI_d16$1_0.VIN.n79 6to4_0.buff_PI_d32_3.inv_PI_d16$1_0.VIN.t4 17.2136
R14968 6to4_0.buff_PI_d32_3.inv_PI_d16$1_0.VIN.n78 6to4_0.buff_PI_d32_3.inv_PI_d16$1_0.VIN.t37 17.2136
R14969 6to4_0.buff_PI_d32_3.inv_PI_d16$1_0.VIN.n76 6to4_0.buff_PI_d32_3.inv_PI_d16$1_0.VIN.t38 17.2136
R14970 6to4_0.buff_PI_d32_3.inv_PI_d16$1_0.VIN.n75 6to4_0.buff_PI_d32_3.inv_PI_d16$1_0.VIN.t29 17.2136
R14971 6to4_0.buff_PI_d32_3.inv_PI_d16$1_0.VIN.n73 6to4_0.buff_PI_d32_3.inv_PI_d16$1_0.VIN.t28 17.2136
R14972 6to4_0.buff_PI_d32_3.inv_PI_d16$1_0.VIN.n72 6to4_0.buff_PI_d32_3.inv_PI_d16$1_0.VIN.t1 17.2136
R14973 6to4_0.buff_PI_d32_3.inv_PI_d16$1_0.VIN.n70 6to4_0.buff_PI_d32_3.inv_PI_d16$1_0.VIN.t2 17.2136
R14974 6to4_0.buff_PI_d32_3.inv_PI_d16$1_0.VIN.n69 6to4_0.buff_PI_d32_3.inv_PI_d16$1_0.VIN.t19 17.2136
R14975 6to4_0.buff_PI_d32_3.inv_PI_d16$1_0.VIN.n67 6to4_0.buff_PI_d32_3.inv_PI_d16$1_0.VIN.t20 17.2136
R14976 6to4_0.buff_PI_d32_3.inv_PI_d16$1_0.VIN.n66 6to4_0.buff_PI_d32_3.inv_PI_d16$1_0.VIN.t22 17.2136
R14977 6to4_0.buff_PI_d32_3.inv_PI_d16$1_0.VIN.n64 6to4_0.buff_PI_d32_3.inv_PI_d16$1_0.VIN.t23 17.2136
R14978 6to4_0.buff_PI_d32_3.inv_PI_d16$1_0.VIN.n63 6to4_0.buff_PI_d32_3.inv_PI_d16$1_0.VIN.t8 17.2136
R14979 6to4_0.buff_PI_d32_3.inv_PI_d16$1_0.VIN.n0 6to4_0.buff_PI_d32_3.inv_PI_d16$1_0.VIN.t58 15.0005
R14980 6to4_0.buff_PI_d32_3.inv_PI_d16$1_0.VIN.n28 6to4_0.buff_PI_d32_3.inv_PI_d16$1_0.VIN.t54 15.0005
R14981 6to4_0.buff_PI_d32_3.inv_PI_d16$1_0.VIN.n2 6to4_0.buff_PI_d32_3.inv_PI_d16$1_0.VIN.t62 15.0005
R14982 6to4_0.buff_PI_d32_3.inv_PI_d16$1_0.VIN.n20 6to4_0.buff_PI_d32_3.inv_PI_d16$1_0.VIN.t61 15.0005
R14983 6to4_0.buff_PI_d32_3.inv_PI_d16$1_0.VIN.n4 6to4_0.buff_PI_d32_3.inv_PI_d16$1_0.VIN.t50 15.0005
R14984 6to4_0.buff_PI_d32_3.inv_PI_d16$1_0.VIN.n12 6to4_0.buff_PI_d32_3.inv_PI_d16$1_0.VIN.t57 15.0005
R14985 6to4_0.buff_PI_d32_3.inv_PI_d16$1_0.VIN.n10 6to4_0.buff_PI_d32_3.inv_PI_d16$1_0.VIN.t59 15.0005
R14986 6to4_0.buff_PI_d32_3.inv_PI_d16$1_0.VIN.n9 6to4_0.buff_PI_d32_3.inv_PI_d16$1_0.VIN.t52 15.0005
R14987 6to4_0.buff_PI_d32_3.inv_PI_d16$1_0.VIN.n7 6to4_0.buff_PI_d32_3.inv_PI_d16$1_0.VIN.t53 15.0005
R14988 6to4_0.buff_PI_d32_3.inv_PI_d16$1_0.VIN.n6 6to4_0.buff_PI_d32_3.inv_PI_d16$1_0.VIN.t56 15.0005
R14989 6to4_0.buff_PI_d32_3.inv_PI_d16$1_0.VIN.n18 6to4_0.buff_PI_d32_3.inv_PI_d16$1_0.VIN.t51 15.0005
R14990 6to4_0.buff_PI_d32_3.inv_PI_d16$1_0.VIN.n16 6to4_0.buff_PI_d32_3.inv_PI_d16$1_0.VIN.t49 15.0005
R14991 6to4_0.buff_PI_d32_3.inv_PI_d16$1_0.VIN.n26 6to4_0.buff_PI_d32_3.inv_PI_d16$1_0.VIN.t55 15.0005
R14992 6to4_0.buff_PI_d32_3.inv_PI_d16$1_0.VIN.n24 6to4_0.buff_PI_d32_3.inv_PI_d16$1_0.VIN.t60 15.0005
R14993 6to4_0.buff_PI_d32_3.inv_PI_d16$1_0.VIN.n34 6to4_0.buff_PI_d32_3.inv_PI_d16$1_0.VIN.t48 15.0005
R14994 6to4_0.buff_PI_d32_3.inv_PI_d16$1_0.VIN.n32 6to4_0.buff_PI_d32_3.inv_PI_d16$1_0.VIN.t63 15.0005
R14995 6to4_0.buff_PI_d32_3.inv_PI_d16$1_0.VIN.n11 6to4_0.buff_PI_d32_3.inv_PI_d16$1_0.VIN.n9 10.3469
R14996 6to4_0.buff_PI_d32_3.inv_PI_d16$1_0.VIN.n8 6to4_0.buff_PI_d32_3.inv_PI_d16$1_0.VIN.n6 10.3469
R14997 6to4_0.buff_PI_d32_3.inv_PI_d16$1_0.VIN.n11 6to4_0.buff_PI_d32_3.inv_PI_d16$1_0.VIN.n10 9.0005
R14998 6to4_0.buff_PI_d32_3.inv_PI_d16$1_0.VIN.n17 6to4_0.buff_PI_d32_3.inv_PI_d16$1_0.VIN.n16 9.0005
R14999 6to4_0.buff_PI_d32_3.inv_PI_d16$1_0.VIN.n19 6to4_0.buff_PI_d32_3.inv_PI_d16$1_0.VIN.n18 9.0005
R15000 6to4_0.buff_PI_d32_3.inv_PI_d16$1_0.VIN.n8 6to4_0.buff_PI_d32_3.inv_PI_d16$1_0.VIN.n7 9.0005
R15001 6to4_0.buff_PI_d32_3.inv_PI_d16$1_0.VIN.n25 6to4_0.buff_PI_d32_3.inv_PI_d16$1_0.VIN.n24 9.0005
R15002 6to4_0.buff_PI_d32_3.inv_PI_d16$1_0.VIN.n27 6to4_0.buff_PI_d32_3.inv_PI_d16$1_0.VIN.n26 9.0005
R15003 6to4_0.buff_PI_d32_3.inv_PI_d16$1_0.VIN.n13 6to4_0.buff_PI_d32_3.inv_PI_d16$1_0.VIN.n12 9.0005
R15004 6to4_0.buff_PI_d32_3.inv_PI_d16$1_0.VIN.n5 6to4_0.buff_PI_d32_3.inv_PI_d16$1_0.VIN.n4 9.0005
R15005 6to4_0.buff_PI_d32_3.inv_PI_d16$1_0.VIN.n33 6to4_0.buff_PI_d32_3.inv_PI_d16$1_0.VIN.n32 9.0005
R15006 6to4_0.buff_PI_d32_3.inv_PI_d16$1_0.VIN.n35 6to4_0.buff_PI_d32_3.inv_PI_d16$1_0.VIN.n34 9.0005
R15007 6to4_0.buff_PI_d32_3.inv_PI_d16$1_0.VIN.n21 6to4_0.buff_PI_d32_3.inv_PI_d16$1_0.VIN.n20 9.0005
R15008 6to4_0.buff_PI_d32_3.inv_PI_d16$1_0.VIN.n3 6to4_0.buff_PI_d32_3.inv_PI_d16$1_0.VIN.n2 9.0005
R15009 6to4_0.buff_PI_d32_3.inv_PI_d16$1_0.VIN.n29 6to4_0.buff_PI_d32_3.inv_PI_d16$1_0.VIN.n28 9.0005
R15010 6to4_0.buff_PI_d32_3.inv_PI_d16$1_0.VIN.n1 6to4_0.buff_PI_d32_3.inv_PI_d16$1_0.VIN.n0 9.0005
R15011 6to4_0.buff_PI_d32_3.inv_PI_d16$1_0.VIN.n59 6to4_0.buff_PI_d32_3.inv_PI_d16$1_0.VIN.n58 5.12956
R15012 6to4_0.buff_PI_d32_3.inv_PI_d16$1_0.VIN.n61 6to4_0.buff_PI_d32_3.inv_PI_d16$1_0.VIN 5.12956
R15013 6to4_0.buff_PI_d32_3.inv_PI_d16$1_0.VIN.n53 6to4_0.buff_PI_d32_3.inv_PI_d16$1_0.VIN.n52 1.41675
R15014 6to4_0.buff_PI_d32_3.inv_PI_d16$1_0.VIN.n47 6to4_0.buff_PI_d32_3.inv_PI_d16$1_0.VIN.n46 1.41675
R15015 6to4_0.buff_PI_d32_3.inv_PI_d16$1_0.VIN.n41 6to4_0.buff_PI_d32_3.inv_PI_d16$1_0.VIN.n40 1.41675
R15016 6to4_0.buff_PI_d32_3.inv_PI_d16$1_0.VIN.n79 6to4_0.buff_PI_d32_3.inv_PI_d16$1_0.VIN.n78 1.41675
R15017 6to4_0.buff_PI_d32_3.inv_PI_d16$1_0.VIN.n73 6to4_0.buff_PI_d32_3.inv_PI_d16$1_0.VIN.n72 1.41675
R15018 6to4_0.buff_PI_d32_3.inv_PI_d16$1_0.VIN.n67 6to4_0.buff_PI_d32_3.inv_PI_d16$1_0.VIN.n66 1.41675
R15019 6to4_0.buff_PI_d32_3.inv_PI_d16$1_0.VIN.n19 6to4_0.buff_PI_d32_3.inv_PI_d16$1_0.VIN.n17 1.3469
R15020 6to4_0.buff_PI_d32_3.inv_PI_d16$1_0.VIN.n27 6to4_0.buff_PI_d32_3.inv_PI_d16$1_0.VIN.n25 1.3469
R15021 6to4_0.buff_PI_d32_3.inv_PI_d16$1_0.VIN.n13 6to4_0.buff_PI_d32_3.inv_PI_d16$1_0.VIN.n5 1.3469
R15022 6to4_0.buff_PI_d32_3.inv_PI_d16$1_0.VIN.n35 6to4_0.buff_PI_d32_3.inv_PI_d16$1_0.VIN.n33 1.3469
R15023 6to4_0.buff_PI_d32_3.inv_PI_d16$1_0.VIN.n21 6to4_0.buff_PI_d32_3.inv_PI_d16$1_0.VIN.n3 1.3469
R15024 6to4_0.buff_PI_d32_3.inv_PI_d16$1_0.VIN.n29 6to4_0.buff_PI_d32_3.inv_PI_d16$1_0.VIN.n1 1.3469
R15025 6to4_0.buff_PI_d32_3.inv_PI_d16$1_0.VIN.n60 6to4_0.buff_PI_d32_3.inv_PI_d16$1_0.VIN 1.0984
R15026 6to4_0.buff_PI_d32_3.inv_PI_d16$1_0.VIN.n15 6to4_0.buff_PI_d32_3.inv_PI_d16$1_0.VIN.n14 0.67839
R15027 6to4_0.buff_PI_d32_3.inv_PI_d16$1_0.VIN.n23 6to4_0.buff_PI_d32_3.inv_PI_d16$1_0.VIN.n22 0.67839
R15028 6to4_0.buff_PI_d32_3.inv_PI_d16$1_0.VIN.n56 6to4_0.buff_PI_d32_3.inv_PI_d16$1_0.VIN.n55 0.633
R15029 6to4_0.buff_PI_d32_3.inv_PI_d16$1_0.VIN.n50 6to4_0.buff_PI_d32_3.inv_PI_d16$1_0.VIN.n49 0.633
R15030 6to4_0.buff_PI_d32_3.inv_PI_d16$1_0.VIN.n44 6to4_0.buff_PI_d32_3.inv_PI_d16$1_0.VIN.n43 0.633
R15031 6to4_0.buff_PI_d32_3.inv_PI_d16$1_0.VIN.n38 6to4_0.buff_PI_d32_3.inv_PI_d16$1_0.VIN.n37 0.633
R15032 6to4_0.buff_PI_d32_3.inv_PI_d16$1_0.VIN.n82 6to4_0.buff_PI_d32_3.inv_PI_d16$1_0.VIN.n81 0.633
R15033 6to4_0.buff_PI_d32_3.inv_PI_d16$1_0.VIN.n76 6to4_0.buff_PI_d32_3.inv_PI_d16$1_0.VIN.n75 0.633
R15034 6to4_0.buff_PI_d32_3.inv_PI_d16$1_0.VIN.n70 6to4_0.buff_PI_d32_3.inv_PI_d16$1_0.VIN.n69 0.633
R15035 6to4_0.buff_PI_d32_3.inv_PI_d16$1_0.VIN.n64 6to4_0.buff_PI_d32_3.inv_PI_d16$1_0.VIN.n63 0.633
R15036 6to4_0.buff_PI_d32_3.inv_PI_d16$1_0.VIN.n59 6to4_0.buff_PI_d32_3.inv_PI_d16$1_0.VIN.n35 0.587691
R15037 6to4_0.buff_PI_d32_3.inv_PI_d16$1_0.VIN.n60 6to4_0.buff_PI_d32_3.inv_PI_d16$1_0.VIN.n1 0.5835
R15038 6to4_0.buff_PI_d32_3.inv_PI_d16$1_0.VIN.n55 6to4_0.buff_PI_d32_3.inv_PI_d16$1_0.VIN.n54 0.392375
R15039 6to4_0.buff_PI_d32_3.inv_PI_d16$1_0.VIN.n49 6to4_0.buff_PI_d32_3.inv_PI_d16$1_0.VIN.n48 0.392375
R15040 6to4_0.buff_PI_d32_3.inv_PI_d16$1_0.VIN.n43 6to4_0.buff_PI_d32_3.inv_PI_d16$1_0.VIN.n42 0.392375
R15041 6to4_0.buff_PI_d32_3.inv_PI_d16$1_0.VIN.n37 6to4_0.buff_PI_d32_3.inv_PI_d16$1_0.VIN.n36 0.392375
R15042 6to4_0.buff_PI_d32_3.inv_PI_d16$1_0.VIN.n81 6to4_0.buff_PI_d32_3.inv_PI_d16$1_0.VIN.n80 0.392375
R15043 6to4_0.buff_PI_d32_3.inv_PI_d16$1_0.VIN.n75 6to4_0.buff_PI_d32_3.inv_PI_d16$1_0.VIN.n74 0.392375
R15044 6to4_0.buff_PI_d32_3.inv_PI_d16$1_0.VIN.n69 6to4_0.buff_PI_d32_3.inv_PI_d16$1_0.VIN.n68 0.392375
R15045 6to4_0.buff_PI_d32_3.inv_PI_d16$1_0.VIN.n63 6to4_0.buff_PI_d32_3.inv_PI_d16$1_0.VIN.n62 0.392375
R15046 6to4_0.buff_PI_d32_3.inv_PI_d16$1_0.VIN.n14 6to4_0.buff_PI_d32_3.inv_PI_d16$1_0.VIN.n11 0.3855
R15047 6to4_0.buff_PI_d32_3.inv_PI_d16$1_0.VIN.n22 6to4_0.buff_PI_d32_3.inv_PI_d16$1_0.VIN.n19 0.3855
R15048 6to4_0.buff_PI_d32_3.inv_PI_d16$1_0.VIN.n15 6to4_0.buff_PI_d32_3.inv_PI_d16$1_0.VIN.n8 0.3855
R15049 6to4_0.buff_PI_d32_3.inv_PI_d16$1_0.VIN.n30 6to4_0.buff_PI_d32_3.inv_PI_d16$1_0.VIN.n27 0.3855
R15050 6to4_0.buff_PI_d32_3.inv_PI_d16$1_0.VIN.n23 6to4_0.buff_PI_d32_3.inv_PI_d16$1_0.VIN.n5 0.3855
R15051 6to4_0.buff_PI_d32_3.inv_PI_d16$1_0.VIN.n31 6to4_0.buff_PI_d32_3.inv_PI_d16$1_0.VIN.n3 0.3855
R15052 6to4_0.buff_PI_d32_3.inv_PI_d16$1_0.VIN.n17 6to4_0.buff_PI_d32_3.inv_PI_d16$1_0.VIN.n15 0.3833
R15053 6to4_0.buff_PI_d32_3.inv_PI_d16$1_0.VIN.n25 6to4_0.buff_PI_d32_3.inv_PI_d16$1_0.VIN.n23 0.3833
R15054 6to4_0.buff_PI_d32_3.inv_PI_d16$1_0.VIN.n14 6to4_0.buff_PI_d32_3.inv_PI_d16$1_0.VIN.n13 0.3833
R15055 6to4_0.buff_PI_d32_3.inv_PI_d16$1_0.VIN.n33 6to4_0.buff_PI_d32_3.inv_PI_d16$1_0.VIN.n31 0.3833
R15056 6to4_0.buff_PI_d32_3.inv_PI_d16$1_0.VIN.n22 6to4_0.buff_PI_d32_3.inv_PI_d16$1_0.VIN.n21 0.3833
R15057 6to4_0.buff_PI_d32_3.inv_PI_d16$1_0.VIN.n30 6to4_0.buff_PI_d32_3.inv_PI_d16$1_0.VIN.n29 0.3833
R15058 6to4_0.buff_PI_d32_3.inv_PI_d16$1_0.VIN.n57 6to4_0.buff_PI_d32_3.inv_PI_d16$1_0.VIN 0.358
R15059 6to4_0.buff_PI_d32_3.inv_PI_d16$1_0.VIN.n51 6to4_0.buff_PI_d32_3.inv_PI_d16$1_0.VIN 0.358
R15060 6to4_0.buff_PI_d32_3.inv_PI_d16$1_0.VIN.n45 6to4_0.buff_PI_d32_3.inv_PI_d16$1_0.VIN 0.358
R15061 6to4_0.buff_PI_d32_3.inv_PI_d16$1_0.VIN.n39 6to4_0.buff_PI_d32_3.inv_PI_d16$1_0.VIN 0.358
R15062 6to4_0.buff_PI_d32_3.inv_PI_d16$1_0.VIN.n83 6to4_0.buff_PI_d32_3.inv_PI_d16$1_0.VIN 0.358
R15063 6to4_0.buff_PI_d32_3.inv_PI_d16$1_0.VIN.n77 6to4_0.buff_PI_d32_3.inv_PI_d16$1_0.VIN 0.358
R15064 6to4_0.buff_PI_d32_3.inv_PI_d16$1_0.VIN.n71 6to4_0.buff_PI_d32_3.inv_PI_d16$1_0.VIN 0.358
R15065 6to4_0.buff_PI_d32_3.inv_PI_d16$1_0.VIN.n65 6to4_0.buff_PI_d32_3.inv_PI_d16$1_0.VIN 0.358
R15066 6to4_0.buff_PI_d32_3.inv_PI_d16$1_0.VIN 6to4_0.buff_PI_d32_3.inv_PI_d16$1_0.VIN.n53 0.3305
R15067 6to4_0.buff_PI_d32_3.inv_PI_d16$1_0.VIN.n52 6to4_0.buff_PI_d32_3.inv_PI_d16$1_0.VIN 0.3305
R15068 6to4_0.buff_PI_d32_3.inv_PI_d16$1_0.VIN 6to4_0.buff_PI_d32_3.inv_PI_d16$1_0.VIN.n47 0.3305
R15069 6to4_0.buff_PI_d32_3.inv_PI_d16$1_0.VIN 6to4_0.buff_PI_d32_3.inv_PI_d16$1_0.VIN.n41 0.3305
R15070 6to4_0.buff_PI_d32_3.inv_PI_d16$1_0.VIN.n40 6to4_0.buff_PI_d32_3.inv_PI_d16$1_0.VIN 0.3305
R15071 6to4_0.buff_PI_d32_3.inv_PI_d16$1_0.VIN 6to4_0.buff_PI_d32_3.inv_PI_d16$1_0.VIN.n79 0.3305
R15072 6to4_0.buff_PI_d32_3.inv_PI_d16$1_0.VIN.n78 6to4_0.buff_PI_d32_3.inv_PI_d16$1_0.VIN 0.3305
R15073 6to4_0.buff_PI_d32_3.inv_PI_d16$1_0.VIN 6to4_0.buff_PI_d32_3.inv_PI_d16$1_0.VIN.n73 0.3305
R15074 6to4_0.buff_PI_d32_3.inv_PI_d16$1_0.VIN 6to4_0.buff_PI_d32_3.inv_PI_d16$1_0.VIN.n67 0.3305
R15075 6to4_0.buff_PI_d32_3.inv_PI_d16$1_0.VIN.n66 6to4_0.buff_PI_d32_3.inv_PI_d16$1_0.VIN 0.3305
R15076 6to4_0.buff_PI_d32_3.inv_PI_d16$1_0.VIN 6to4_0.buff_PI_d32_3.inv_PI_d16$1_0.VIN.n59 0.239357
R15077 6to4_0.buff_PI_d32_3.inv_PI_d16$1_0.VIN.n58 6to4_0.buff_PI_d32_3.inv_PI_d16$1_0.VIN 0.113938
R15078 6to4_0.buff_PI_d32_3.inv_PI_d16$1_0.VIN.n46 6to4_0.buff_PI_d32_3.inv_PI_d16$1_0.VIN 0.113938
R15079 6to4_0.buff_PI_d32_3.inv_PI_d16$1_0.VIN 6to4_0.buff_PI_d32_3.inv_PI_d16$1_0.VIN.n61 0.113938
R15080 6to4_0.buff_PI_d32_3.inv_PI_d16$1_0.VIN.n72 6to4_0.buff_PI_d32_3.inv_PI_d16$1_0.VIN 0.113938
R15081 6to4_0.buff_PI_d32_3.inv_PI_d16$1_0.VIN 6to4_0.buff_PI_d32_3.inv_PI_d16$1_0.VIN.n30 0.0662582
R15082 6to4_0.buff_PI_d32_3.inv_PI_d16$1_0.VIN 6to4_0.buff_PI_d32_3.inv_PI_d16$1_0.VIN.n57 0.062375
R15083 6to4_0.buff_PI_d32_3.inv_PI_d16$1_0.VIN.n54 6to4_0.buff_PI_d32_3.inv_PI_d16$1_0.VIN 0.062375
R15084 6to4_0.buff_PI_d32_3.inv_PI_d16$1_0.VIN 6to4_0.buff_PI_d32_3.inv_PI_d16$1_0.VIN.n51 0.062375
R15085 6to4_0.buff_PI_d32_3.inv_PI_d16$1_0.VIN.n48 6to4_0.buff_PI_d32_3.inv_PI_d16$1_0.VIN 0.062375
R15086 6to4_0.buff_PI_d32_3.inv_PI_d16$1_0.VIN 6to4_0.buff_PI_d32_3.inv_PI_d16$1_0.VIN.n45 0.062375
R15087 6to4_0.buff_PI_d32_3.inv_PI_d16$1_0.VIN.n42 6to4_0.buff_PI_d32_3.inv_PI_d16$1_0.VIN 0.062375
R15088 6to4_0.buff_PI_d32_3.inv_PI_d16$1_0.VIN 6to4_0.buff_PI_d32_3.inv_PI_d16$1_0.VIN.n39 0.062375
R15089 6to4_0.buff_PI_d32_3.inv_PI_d16$1_0.VIN.n36 6to4_0.buff_PI_d32_3.inv_PI_d16$1_0.VIN 0.062375
R15090 6to4_0.buff_PI_d32_3.inv_PI_d16$1_0.VIN 6to4_0.buff_PI_d32_3.inv_PI_d16$1_0.VIN.n83 0.062375
R15091 6to4_0.buff_PI_d32_3.inv_PI_d16$1_0.VIN.n80 6to4_0.buff_PI_d32_3.inv_PI_d16$1_0.VIN 0.062375
R15092 6to4_0.buff_PI_d32_3.inv_PI_d16$1_0.VIN 6to4_0.buff_PI_d32_3.inv_PI_d16$1_0.VIN.n77 0.062375
R15093 6to4_0.buff_PI_d32_3.inv_PI_d16$1_0.VIN.n74 6to4_0.buff_PI_d32_3.inv_PI_d16$1_0.VIN 0.062375
R15094 6to4_0.buff_PI_d32_3.inv_PI_d16$1_0.VIN 6to4_0.buff_PI_d32_3.inv_PI_d16$1_0.VIN.n71 0.062375
R15095 6to4_0.buff_PI_d32_3.inv_PI_d16$1_0.VIN.n68 6to4_0.buff_PI_d32_3.inv_PI_d16$1_0.VIN 0.062375
R15096 6to4_0.buff_PI_d32_3.inv_PI_d16$1_0.VIN 6to4_0.buff_PI_d32_3.inv_PI_d16$1_0.VIN.n65 0.062375
R15097 6to4_0.buff_PI_d32_3.inv_PI_d16$1_0.VIN.n62 6to4_0.buff_PI_d32_3.inv_PI_d16$1_0.VIN 0.062375
R15098 6to4_0.buff_PI_d32_3.inv_PI_d16$1_0.VIN.n31 6to4_0.buff_PI_d32_3.inv_PI_d16$1_0.VIN 0.059489
R15099 6to4_0.buff_PI_d32_3.inv_PI_d16$1_0.VIN.n28 6to4_0.buff_PI_d32_3.inv_PI_d16$1_0.VIN 0.0555
R15100 6to4_0.buff_PI_d32_3.inv_PI_d16$1_0.VIN.n20 6to4_0.buff_PI_d32_3.inv_PI_d16$1_0.VIN 0.0555
R15101 6to4_0.buff_PI_d32_3.inv_PI_d16$1_0.VIN.n12 6to4_0.buff_PI_d32_3.inv_PI_d16$1_0.VIN 0.0555
R15102 6to4_0.buff_PI_d32_3.inv_PI_d16$1_0.VIN.n9 6to4_0.buff_PI_d32_3.inv_PI_d16$1_0.VIN 0.0555
R15103 6to4_0.buff_PI_d32_3.inv_PI_d16$1_0.VIN.n6 6to4_0.buff_PI_d32_3.inv_PI_d16$1_0.VIN 0.0555
R15104 6to4_0.buff_PI_d32_3.inv_PI_d16$1_0.VIN.n16 6to4_0.buff_PI_d32_3.inv_PI_d16$1_0.VIN 0.0555
R15105 6to4_0.buff_PI_d32_3.inv_PI_d16$1_0.VIN.n24 6to4_0.buff_PI_d32_3.inv_PI_d16$1_0.VIN 0.0555
R15106 6to4_0.buff_PI_d32_3.inv_PI_d16$1_0.VIN.n32 6to4_0.buff_PI_d32_3.inv_PI_d16$1_0.VIN 0.0555
R15107 6to4_0.buff_PI_d32_3.inv_PI_d16$1_0.VIN 6to4_0.buff_PI_d32_3.inv_PI_d16$1_0.VIN.n56 0.034875
R15108 6to4_0.buff_PI_d32_3.inv_PI_d16$1_0.VIN 6to4_0.buff_PI_d32_3.inv_PI_d16$1_0.VIN.n50 0.034875
R15109 6to4_0.buff_PI_d32_3.inv_PI_d16$1_0.VIN 6to4_0.buff_PI_d32_3.inv_PI_d16$1_0.VIN.n44 0.034875
R15110 6to4_0.buff_PI_d32_3.inv_PI_d16$1_0.VIN 6to4_0.buff_PI_d32_3.inv_PI_d16$1_0.VIN.n38 0.034875
R15111 6to4_0.buff_PI_d32_3.inv_PI_d16$1_0.VIN 6to4_0.buff_PI_d32_3.inv_PI_d16$1_0.VIN.n82 0.034875
R15112 6to4_0.buff_PI_d32_3.inv_PI_d16$1_0.VIN 6to4_0.buff_PI_d32_3.inv_PI_d16$1_0.VIN.n76 0.034875
R15113 6to4_0.buff_PI_d32_3.inv_PI_d16$1_0.VIN 6to4_0.buff_PI_d32_3.inv_PI_d16$1_0.VIN.n70 0.034875
R15114 6to4_0.buff_PI_d32_3.inv_PI_d16$1_0.VIN 6to4_0.buff_PI_d32_3.inv_PI_d16$1_0.VIN.n64 0.034875
R15115 6to4_0.buff_PI_d32_3.inv_PI_d16$1_0.VIN.n0 6to4_0.buff_PI_d32_3.inv_PI_d16$1_0.VIN 0.0115
R15116 6to4_0.buff_PI_d32_3.inv_PI_d16$1_0.VIN.n2 6to4_0.buff_PI_d32_3.inv_PI_d16$1_0.VIN 0.0115
R15117 6to4_0.buff_PI_d32_3.inv_PI_d16$1_0.VIN.n4 6to4_0.buff_PI_d32_3.inv_PI_d16$1_0.VIN 0.0115
R15118 6to4_0.buff_PI_d32_3.inv_PI_d16$1_0.VIN.n10 6to4_0.buff_PI_d32_3.inv_PI_d16$1_0.VIN 0.0115
R15119 6to4_0.buff_PI_d32_3.inv_PI_d16$1_0.VIN.n7 6to4_0.buff_PI_d32_3.inv_PI_d16$1_0.VIN 0.0115
R15120 6to4_0.buff_PI_d32_3.inv_PI_d16$1_0.VIN.n18 6to4_0.buff_PI_d32_3.inv_PI_d16$1_0.VIN 0.0115
R15121 6to4_0.buff_PI_d32_3.inv_PI_d16$1_0.VIN.n26 6to4_0.buff_PI_d32_3.inv_PI_d16$1_0.VIN 0.0115
R15122 6to4_0.buff_PI_d32_3.inv_PI_d16$1_0.VIN.n34 6to4_0.buff_PI_d32_3.inv_PI_d16$1_0.VIN 0.0115
R15123 6to4_0.buff_PI_d32_3.inv_PI_d16$1_0.VIN 6to4_0.buff_PI_d32_3.inv_PI_d16$1_0.VIN.n60 0.00469048
R15124 6ph_rosc_0.psdiff_1.buff_d8$1_1.VIN.n28 6ph_rosc_0.psdiff_1.buff_d8$1_1.VIN.n27 20.4895
R15125 6ph_rosc_0.psdiff_1.buff_d8$1_1.VIN.n21 6ph_rosc_0.psdiff_1.buff_d8$1_1.VIN.n20 18.6537
R15126 6ph_rosc_0.psdiff_1.buff_d8$1_1.VIN.n13 6ph_rosc_0.psdiff_1.buff_d8$1_1.VIN.t8 17.3511
R15127 6ph_rosc_0.psdiff_1.buff_d8$1_1.VIN.n11 6ph_rosc_0.psdiff_1.buff_d8$1_1.VIN.t6 17.3511
R15128 6ph_rosc_0.psdiff_1.buff_d8$1_1.VIN.n9 6ph_rosc_0.psdiff_1.buff_d8$1_1.VIN.t3 17.3511
R15129 6ph_rosc_0.psdiff_1.buff_d8$1_1.VIN.n6 6ph_rosc_0.psdiff_1.buff_d8$1_1.VIN.t22 17.3511
R15130 6ph_rosc_0.psdiff_1.buff_d8$1_1.VIN.n4 6ph_rosc_0.psdiff_1.buff_d8$1_1.VIN.t18 17.3511
R15131 6ph_rosc_0.psdiff_1.buff_d8$1_1.VIN.n26 6ph_rosc_0.psdiff_1.buff_d8$1_1.VIN.t26 17.3511
R15132 6ph_rosc_0.psdiff_1.buff_d8$1_1.VIN.n0 6ph_rosc_0.psdiff_1.buff_d8$1_1.VIN.t27 17.3511
R15133 6ph_rosc_0.psdiff_1.buff_d8$1_1.VIN.n2 6ph_rosc_0.psdiff_1.buff_d8$1_1.VIN.t24 17.3511
R15134 6ph_rosc_0.psdiff_1.buff_d8$1_1.VIN.n8 6ph_rosc_0.psdiff_1.buff_d8$1_1.VIN.t7 17.3511
R15135 6ph_rosc_0.psdiff_1.buff_d8$1_1.VIN.n15 6ph_rosc_0.psdiff_1.buff_d8$1_1.VIN.t2 17.3511
R15136 6ph_rosc_0.psdiff_1.buff_d8$1_1.VIN.n23 6ph_rosc_0.psdiff_1.buff_d8$1_1.VIN.t10 17.2171
R15137 6ph_rosc_0.psdiff_1.buff_d8$1_1.VIN.n14 6ph_rosc_0.psdiff_1.buff_d8$1_1.VIN.t14 17.0005
R15138 6ph_rosc_0.psdiff_1.buff_d8$1_1.VIN.n13 6ph_rosc_0.psdiff_1.buff_d8$1_1.VIN.t4 17.0005
R15139 6ph_rosc_0.psdiff_1.buff_d8$1_1.VIN.n12 6ph_rosc_0.psdiff_1.buff_d8$1_1.VIN.t12 17.0005
R15140 6ph_rosc_0.psdiff_1.buff_d8$1_1.VIN.n11 6ph_rosc_0.psdiff_1.buff_d8$1_1.VIN.t1 17.0005
R15141 6ph_rosc_0.psdiff_1.buff_d8$1_1.VIN.n10 6ph_rosc_0.psdiff_1.buff_d8$1_1.VIN.t16 17.0005
R15142 6ph_rosc_0.psdiff_1.buff_d8$1_1.VIN.n9 6ph_rosc_0.psdiff_1.buff_d8$1_1.VIN.t5 17.0005
R15143 6ph_rosc_0.psdiff_1.buff_d8$1_1.VIN.n6 6ph_rosc_0.psdiff_1.buff_d8$1_1.VIN.t29 17.0005
R15144 6ph_rosc_0.psdiff_1.buff_d8$1_1.VIN.n7 6ph_rosc_0.psdiff_1.buff_d8$1_1.VIN.t20 17.0005
R15145 6ph_rosc_0.psdiff_1.buff_d8$1_1.VIN.n4 6ph_rosc_0.psdiff_1.buff_d8$1_1.VIN.t28 17.0005
R15146 6ph_rosc_0.psdiff_1.buff_d8$1_1.VIN.n5 6ph_rosc_0.psdiff_1.buff_d8$1_1.VIN.t17 17.0005
R15147 6ph_rosc_0.psdiff_1.buff_d8$1_1.VIN.n26 6ph_rosc_0.psdiff_1.buff_d8$1_1.VIN.t19 17.0005
R15148 6ph_rosc_0.psdiff_1.buff_d8$1_1.VIN.n27 6ph_rosc_0.psdiff_1.buff_d8$1_1.VIN.t23 17.0005
R15149 6ph_rosc_0.psdiff_1.buff_d8$1_1.VIN.n0 6ph_rosc_0.psdiff_1.buff_d8$1_1.VIN.t31 17.0005
R15150 6ph_rosc_0.psdiff_1.buff_d8$1_1.VIN.n1 6ph_rosc_0.psdiff_1.buff_d8$1_1.VIN.t25 17.0005
R15151 6ph_rosc_0.psdiff_1.buff_d8$1_1.VIN.n2 6ph_rosc_0.psdiff_1.buff_d8$1_1.VIN.t30 17.0005
R15152 6ph_rosc_0.psdiff_1.buff_d8$1_1.VIN.n3 6ph_rosc_0.psdiff_1.buff_d8$1_1.VIN.t21 17.0005
R15153 6ph_rosc_0.psdiff_1.buff_d8$1_1.VIN.n21 6ph_rosc_0.psdiff_1.buff_d8$1_1.VIN.t11 17.0005
R15154 6ph_rosc_0.psdiff_1.buff_d8$1_1.VIN.n8 6ph_rosc_0.psdiff_1.buff_d8$1_1.VIN.t0 17.0005
R15155 6ph_rosc_0.psdiff_1.buff_d8$1_1.VIN.n20 6ph_rosc_0.psdiff_1.buff_d8$1_1.VIN.t13 17.0005
R15156 6ph_rosc_0.psdiff_1.buff_d8$1_1.VIN.n16 6ph_rosc_0.psdiff_1.buff_d8$1_1.VIN.t15 17.0005
R15157 6ph_rosc_0.psdiff_1.buff_d8$1_1.VIN.n15 6ph_rosc_0.psdiff_1.buff_d8$1_1.VIN.t9 17.0005
R15158 6ph_rosc_0.psdiff_1.buff_d8$1_1.VIN.n28 6ph_rosc_0.psdiff_1.buff_d8$1_1.VIN.t32 15.0005
R15159 6ph_rosc_0.psdiff_1.buff_d8$1_1.VIN.n17 6ph_rosc_0.psdiff_1.buff_d8$1_1.VIN.n16 0.997375
R15160 6ph_rosc_0.psdiff_1.buff_d8$1_1.VIN.n27 6ph_rosc_0.psdiff_1.buff_d8$1_1.VIN.n25 0.965015
R15161 6ph_rosc_0.psdiff_1.buff_d8$1_1.VIN.n20 6ph_rosc_0.psdiff_1.buff_d8$1_1.VIN.n19 0.965015
R15162 6ph_rosc_0.psdiff_1.buff_d8$1_1.VIN.n23 6ph_rosc_0.psdiff_1.buff_d8$1_1.VIN.n22 0.78425
R15163 6ph_rosc_0.psdiff_1.buff_d8$1_1.VIN.n24 6ph_rosc_0.psdiff_1.buff_d8$1_1.VIN.n23 0.78425
R15164 6ph_rosc_0.psdiff_1.buff_d8$1_1.VIN.n25 6ph_rosc_0.psdiff_1.buff_d8$1_1.VIN.n24 0.78425
R15165 6ph_rosc_0.psdiff_1.buff_d8$1_1.VIN.n18 6ph_rosc_0.psdiff_1.buff_d8$1_1.VIN.n17 0.78425
R15166 6ph_rosc_0.psdiff_1.buff_d8$1_1.VIN.n19 6ph_rosc_0.psdiff_1.buff_d8$1_1.VIN.n18 0.78425
R15167 6ph_rosc_0.psdiff_1.buff_d8$1_1.VIN.n14 6ph_rosc_0.psdiff_1.buff_d8$1_1.VIN.n13 0.622687
R15168 6ph_rosc_0.psdiff_1.buff_d8$1_1.VIN.n12 6ph_rosc_0.psdiff_1.buff_d8$1_1.VIN.n11 0.622687
R15169 6ph_rosc_0.psdiff_1.buff_d8$1_1.VIN.n10 6ph_rosc_0.psdiff_1.buff_d8$1_1.VIN.n9 0.622687
R15170 6ph_rosc_0.psdiff_1.buff_d8$1_1.VIN.n16 6ph_rosc_0.psdiff_1.buff_d8$1_1.VIN.n15 0.622687
R15171 6ph_rosc_0.psdiff_1.buff_d8$1_1.VIN.n20 6ph_rosc_0.psdiff_1.buff_d8$1_1.VIN.n8 0.590328
R15172 6ph_rosc_0.psdiff_1.buff_d8$1_1.VIN.n7 6ph_rosc_0.psdiff_1.buff_d8$1_1.VIN.n6 0.351125
R15173 6ph_rosc_0.psdiff_1.buff_d8$1_1.VIN.n5 6ph_rosc_0.psdiff_1.buff_d8$1_1.VIN.n4 0.351125
R15174 6ph_rosc_0.psdiff_1.buff_d8$1_1.VIN.n1 6ph_rosc_0.psdiff_1.buff_d8$1_1.VIN.n0 0.351125
R15175 6ph_rosc_0.psdiff_1.buff_d8$1_1.VIN.n3 6ph_rosc_0.psdiff_1.buff_d8$1_1.VIN.n2 0.351125
R15176 6ph_rosc_0.psdiff_1.buff_d8$1_1.VIN.n27 6ph_rosc_0.psdiff_1.buff_d8$1_1.VIN.n26 0.318765
R15177 6ph_rosc_0.psdiff_1.buff_d8$1_1.VIN.n17 6ph_rosc_0.psdiff_1.buff_d8$1_1.VIN.n14 0.213625
R15178 6ph_rosc_0.psdiff_1.buff_d8$1_1.VIN.n18 6ph_rosc_0.psdiff_1.buff_d8$1_1.VIN.n12 0.213625
R15179 6ph_rosc_0.psdiff_1.buff_d8$1_1.VIN.n19 6ph_rosc_0.psdiff_1.buff_d8$1_1.VIN.n10 0.213625
R15180 6ph_rosc_0.psdiff_1.buff_d8$1_1.VIN.n22 6ph_rosc_0.psdiff_1.buff_d8$1_1.VIN.n7 0.213625
R15181 6ph_rosc_0.psdiff_1.buff_d8$1_1.VIN.n23 6ph_rosc_0.psdiff_1.buff_d8$1_1.VIN.n5 0.213625
R15182 6ph_rosc_0.psdiff_1.buff_d8$1_1.VIN.n25 6ph_rosc_0.psdiff_1.buff_d8$1_1.VIN.n1 0.213625
R15183 6ph_rosc_0.psdiff_1.buff_d8$1_1.VIN.n24 6ph_rosc_0.psdiff_1.buff_d8$1_1.VIN.n3 0.213625
R15184 6ph_rosc_0.psdiff_1.buff_d8$1_1.VIN.n22 6ph_rosc_0.psdiff_1.buff_d8$1_1.VIN.n21 0.184703
R15185 6ph_rosc_0.psdiff_1.buff_d8$1_1.inv$3_0.VIN 6ph_rosc_0.psdiff_1.buff_d8$1_1.VIN.n28 0.0151667
R15186 6ph_rosc_0.psdiff_2.CLKP.n7 6ph_rosc_0.psdiff_2.CLKP 85.2142
R15187 6ph_rosc_0.psdiff_2.CLKP.n10 6ph_rosc_0.psdiff_2.CLKP.t1 17.0005
R15188 6ph_rosc_0.psdiff_2.CLKP.n12 6ph_rosc_0.psdiff_2.CLKP.t6 17.0005
R15189 6ph_rosc_0.psdiff_2.CLKP.n0 6ph_rosc_0.psdiff_2.CLKP.t0 17.0005
R15190 6ph_rosc_0.psdiff_2.CLKP.n2 6ph_rosc_0.psdiff_2.CLKP.t7 17.0005
R15191 6ph_rosc_0.psdiff_2.CLKP.n3 6ph_rosc_0.psdiff_2.CLKP.t2 17.0005
R15192 6ph_rosc_0.psdiff_2.CLKP.n5 6ph_rosc_0.psdiff_2.CLKP.t4 17.0005
R15193 6ph_rosc_0.psdiff_2.CLKP.n14 6ph_rosc_0.psdiff_2.CLKP.t5 17.0005
R15194 6ph_rosc_0.psdiff_2.CLKP.n16 6ph_rosc_0.psdiff_2.CLKP.t3 17.0005
R15195 6ph_rosc_0.psdiff_2.CLKP 6ph_rosc_0.psdiff_2.CLKP.t8 15.0494
R15196 6ph_rosc_0.psdiff_2.CLKP.n6 6ph_rosc_0.psdiff_2.CLKP.t9 15.0005
R15197 6ph_rosc_0.psdiff_2.CLKP.n13 6ph_rosc_0.psdiff_2.CLKP.n12 9.91525
R15198 6ph_rosc_0.psdiff_2.CLKP.n7 6ph_rosc_0.psdiff_2.CLKP.n6 9.72119
R15199 6ph_rosc_0.psdiff_2.CLKP.n9 6ph_rosc_0.psdiff_2.CLKP.n2 9.12325
R15200 6ph_rosc_0.psdiff_2.CLKP.n8 6ph_rosc_0.psdiff_2.CLKP.n5 9.12325
R15201 6ph_rosc_0.psdiff_2.CLKP.n14 6ph_rosc_0.psdiff_2.CLKP.n13 9.12325
R15202 6ph_rosc_0.psdiff_2.CLKP.n12 6ph_rosc_0.psdiff_2.CLKP 1.19877
R15203 6ph_rosc_0.psdiff_2.CLKP.n2 6ph_rosc_0.psdiff_2.CLKP 1.19877
R15204 6ph_rosc_0.psdiff_2.CLKP.n5 6ph_rosc_0.psdiff_2.CLKP 1.19877
R15205 6ph_rosc_0.psdiff_2.CLKP.n14 6ph_rosc_0.psdiff_2.CLKP 1.19877
R15206 6ph_rosc_0.psdiff_2.CLKP.n9 6ph_rosc_0.psdiff_2.CLKP.n8 0.7925
R15207 6ph_rosc_0.psdiff_2.CLKP.n11 6ph_rosc_0.psdiff_2.CLKP 0.559983
R15208 6ph_rosc_0.psdiff_2.CLKP.n1 6ph_rosc_0.psdiff_2.CLKP 0.559983
R15209 6ph_rosc_0.psdiff_2.CLKP.n4 6ph_rosc_0.psdiff_2.CLKP 0.559983
R15210 6ph_rosc_0.psdiff_2.CLKP.n15 6ph_rosc_0.psdiff_2.CLKP 0.559983
R15211 6ph_rosc_0.psdiff_2.CLKP 6ph_rosc_0.psdiff_2.CLKP.n9 0.4273
R15212 6ph_rosc_0.psdiff_2.CLKP.n13 6ph_rosc_0.psdiff_2.CLKP 0.3657
R15213 6ph_rosc_0.psdiff_2.CLKP.n11 6ph_rosc_0.psdiff_2.CLKP 0.292688
R15214 6ph_rosc_0.psdiff_2.CLKP.n1 6ph_rosc_0.psdiff_2.CLKP 0.292688
R15215 6ph_rosc_0.psdiff_2.CLKP.n4 6ph_rosc_0.psdiff_2.CLKP 0.292688
R15216 6ph_rosc_0.psdiff_2.CLKP 6ph_rosc_0.psdiff_2.CLKP.n15 0.292688
R15217 6ph_rosc_0.psdiff_2.CLKP 6ph_rosc_0.psdiff_2.CLKP.n10 0.282375
R15218 6ph_rosc_0.psdiff_2.CLKP 6ph_rosc_0.psdiff_2.CLKP.n0 0.282375
R15219 6ph_rosc_0.psdiff_2.CLKP 6ph_rosc_0.psdiff_2.CLKP.n3 0.282375
R15220 6ph_rosc_0.psdiff_2.CLKP.n16 6ph_rosc_0.psdiff_2.CLKP 0.282375
R15221 6ph_rosc_0.psdiff_2.CLKP.n8 6ph_rosc_0.psdiff_2.CLKP.n7 0.1567
R15222 6ph_rosc_0.psdiff_2.CLKP.n10 6ph_rosc_0.psdiff_2.CLKP 0.089875
R15223 6ph_rosc_0.psdiff_2.CLKP.n0 6ph_rosc_0.psdiff_2.CLKP 0.089875
R15224 6ph_rosc_0.psdiff_2.CLKP.n3 6ph_rosc_0.psdiff_2.CLKP 0.089875
R15225 6ph_rosc_0.psdiff_2.CLKP 6ph_rosc_0.psdiff_2.CLKP.n16 0.089875
R15226 6ph_rosc_0.psdiff_2.CLKP.n6 6ph_rosc_0.psdiff_2.CLKP 0.0555
R15227 6ph_rosc_0.psdiff_2.CLKP.n12 6ph_rosc_0.psdiff_2.CLKP.n11 0.0403276
R15228 6ph_rosc_0.psdiff_2.CLKP.n2 6ph_rosc_0.psdiff_2.CLKP.n1 0.0403276
R15229 6ph_rosc_0.psdiff_2.CLKP.n5 6ph_rosc_0.psdiff_2.CLKP.n4 0.0403276
R15230 6ph_rosc_0.psdiff_2.CLKP.n15 6ph_rosc_0.psdiff_2.CLKP.n14 0.0403276
R15231 6ph_rosc_0.psdiff_2.CLKP.n6 6ph_rosc_0.psdiff_2.CLKP 0.0151667
R15232 6ph_rosc_0.psdiff_2.buff_d8$1_1.VIN.n28 6ph_rosc_0.psdiff_2.buff_d8$1_1.VIN.n27 20.4895
R15233 6ph_rosc_0.psdiff_2.buff_d8$1_1.VIN.n19 6ph_rosc_0.psdiff_2.buff_d8$1_1.VIN.n18 18.6537
R15234 6ph_rosc_0.psdiff_2.buff_d8$1_1.VIN.n6 6ph_rosc_0.psdiff_2.buff_d8$1_1.VIN.t23 17.3511
R15235 6ph_rosc_0.psdiff_2.buff_d8$1_1.VIN.n13 6ph_rosc_0.psdiff_2.buff_d8$1_1.VIN.t18 17.3511
R15236 6ph_rosc_0.psdiff_2.buff_d8$1_1.VIN.n11 6ph_rosc_0.psdiff_2.buff_d8$1_1.VIN.t15 17.3511
R15237 6ph_rosc_0.psdiff_2.buff_d8$1_1.VIN.n9 6ph_rosc_0.psdiff_2.buff_d8$1_1.VIN.t17 17.3511
R15238 6ph_rosc_0.psdiff_2.buff_d8$1_1.VIN.n7 6ph_rosc_0.psdiff_2.buff_d8$1_1.VIN.t16 17.3511
R15239 6ph_rosc_0.psdiff_2.buff_d8$1_1.VIN.n20 6ph_rosc_0.psdiff_2.buff_d8$1_1.VIN.t0 17.3511
R15240 6ph_rosc_0.psdiff_2.buff_d8$1_1.VIN.n4 6ph_rosc_0.psdiff_2.buff_d8$1_1.VIN.t12 17.3511
R15241 6ph_rosc_0.psdiff_2.buff_d8$1_1.VIN.n0 6ph_rosc_0.psdiff_2.buff_d8$1_1.VIN.t13 17.3511
R15242 6ph_rosc_0.psdiff_2.buff_d8$1_1.VIN.n2 6ph_rosc_0.psdiff_2.buff_d8$1_1.VIN.t8 17.3511
R15243 6ph_rosc_0.psdiff_2.buff_d8$1_1.VIN.n26 6ph_rosc_0.psdiff_2.buff_d8$1_1.VIN.t1 17.3511
R15244 6ph_rosc_0.psdiff_2.buff_d8$1_1.VIN.n23 6ph_rosc_0.psdiff_2.buff_d8$1_1.VIN.t25 17.2171
R15245 6ph_rosc_0.psdiff_2.buff_d8$1_1.VIN.n6 6ph_rosc_0.psdiff_2.buff_d8$1_1.VIN.t19 17.0005
R15246 6ph_rosc_0.psdiff_2.buff_d8$1_1.VIN.n14 6ph_rosc_0.psdiff_2.buff_d8$1_1.VIN.t29 17.0005
R15247 6ph_rosc_0.psdiff_2.buff_d8$1_1.VIN.n13 6ph_rosc_0.psdiff_2.buff_d8$1_1.VIN.t24 17.0005
R15248 6ph_rosc_0.psdiff_2.buff_d8$1_1.VIN.n12 6ph_rosc_0.psdiff_2.buff_d8$1_1.VIN.t27 17.0005
R15249 6ph_rosc_0.psdiff_2.buff_d8$1_1.VIN.n11 6ph_rosc_0.psdiff_2.buff_d8$1_1.VIN.t20 17.0005
R15250 6ph_rosc_0.psdiff_2.buff_d8$1_1.VIN.n10 6ph_rosc_0.psdiff_2.buff_d8$1_1.VIN.t30 17.0005
R15251 6ph_rosc_0.psdiff_2.buff_d8$1_1.VIN.n9 6ph_rosc_0.psdiff_2.buff_d8$1_1.VIN.t22 17.0005
R15252 6ph_rosc_0.psdiff_2.buff_d8$1_1.VIN.n8 6ph_rosc_0.psdiff_2.buff_d8$1_1.VIN.t28 17.0005
R15253 6ph_rosc_0.psdiff_2.buff_d8$1_1.VIN.n7 6ph_rosc_0.psdiff_2.buff_d8$1_1.VIN.t21 17.0005
R15254 6ph_rosc_0.psdiff_2.buff_d8$1_1.VIN.n18 6ph_rosc_0.psdiff_2.buff_d8$1_1.VIN.t31 17.0005
R15255 6ph_rosc_0.psdiff_2.buff_d8$1_1.VIN.n19 6ph_rosc_0.psdiff_2.buff_d8$1_1.VIN.t26 17.0005
R15256 6ph_rosc_0.psdiff_2.buff_d8$1_1.VIN.n20 6ph_rosc_0.psdiff_2.buff_d8$1_1.VIN.t7 17.0005
R15257 6ph_rosc_0.psdiff_2.buff_d8$1_1.VIN.n21 6ph_rosc_0.psdiff_2.buff_d8$1_1.VIN.t14 17.0005
R15258 6ph_rosc_0.psdiff_2.buff_d8$1_1.VIN.n4 6ph_rosc_0.psdiff_2.buff_d8$1_1.VIN.t3 17.0005
R15259 6ph_rosc_0.psdiff_2.buff_d8$1_1.VIN.n5 6ph_rosc_0.psdiff_2.buff_d8$1_1.VIN.t10 17.0005
R15260 6ph_rosc_0.psdiff_2.buff_d8$1_1.VIN.n0 6ph_rosc_0.psdiff_2.buff_d8$1_1.VIN.t4 17.0005
R15261 6ph_rosc_0.psdiff_2.buff_d8$1_1.VIN.n1 6ph_rosc_0.psdiff_2.buff_d8$1_1.VIN.t11 17.0005
R15262 6ph_rosc_0.psdiff_2.buff_d8$1_1.VIN.n2 6ph_rosc_0.psdiff_2.buff_d8$1_1.VIN.t2 17.0005
R15263 6ph_rosc_0.psdiff_2.buff_d8$1_1.VIN.n3 6ph_rosc_0.psdiff_2.buff_d8$1_1.VIN.t6 17.0005
R15264 6ph_rosc_0.psdiff_2.buff_d8$1_1.VIN.n26 6ph_rosc_0.psdiff_2.buff_d8$1_1.VIN.t9 17.0005
R15265 6ph_rosc_0.psdiff_2.buff_d8$1_1.VIN.n27 6ph_rosc_0.psdiff_2.buff_d8$1_1.VIN.t5 17.0005
R15266 6ph_rosc_0.psdiff_2.buff_d8$1_1.VIN.n28 6ph_rosc_0.psdiff_2.buff_d8$1_1.VIN.t32 15.0005
R15267 6ph_rosc_0.psdiff_2.buff_d8$1_1.VIN.n15 6ph_rosc_0.psdiff_2.buff_d8$1_1.VIN.n14 0.997375
R15268 6ph_rosc_0.psdiff_2.buff_d8$1_1.VIN.n18 6ph_rosc_0.psdiff_2.buff_d8$1_1.VIN.n17 0.965015
R15269 6ph_rosc_0.psdiff_2.buff_d8$1_1.VIN.n27 6ph_rosc_0.psdiff_2.buff_d8$1_1.VIN.n25 0.965015
R15270 6ph_rosc_0.psdiff_2.buff_d8$1_1.VIN.n16 6ph_rosc_0.psdiff_2.buff_d8$1_1.VIN.n15 0.78425
R15271 6ph_rosc_0.psdiff_2.buff_d8$1_1.VIN.n17 6ph_rosc_0.psdiff_2.buff_d8$1_1.VIN.n16 0.78425
R15272 6ph_rosc_0.psdiff_2.buff_d8$1_1.VIN.n23 6ph_rosc_0.psdiff_2.buff_d8$1_1.VIN.n22 0.78425
R15273 6ph_rosc_0.psdiff_2.buff_d8$1_1.VIN.n24 6ph_rosc_0.psdiff_2.buff_d8$1_1.VIN.n23 0.78425
R15274 6ph_rosc_0.psdiff_2.buff_d8$1_1.VIN.n25 6ph_rosc_0.psdiff_2.buff_d8$1_1.VIN.n24 0.78425
R15275 6ph_rosc_0.psdiff_2.buff_d8$1_1.VIN.n14 6ph_rosc_0.psdiff_2.buff_d8$1_1.VIN.n13 0.622687
R15276 6ph_rosc_0.psdiff_2.buff_d8$1_1.VIN.n12 6ph_rosc_0.psdiff_2.buff_d8$1_1.VIN.n11 0.622687
R15277 6ph_rosc_0.psdiff_2.buff_d8$1_1.VIN.n10 6ph_rosc_0.psdiff_2.buff_d8$1_1.VIN.n9 0.622687
R15278 6ph_rosc_0.psdiff_2.buff_d8$1_1.VIN.n8 6ph_rosc_0.psdiff_2.buff_d8$1_1.VIN.n7 0.622687
R15279 6ph_rosc_0.psdiff_2.buff_d8$1_1.VIN.n18 6ph_rosc_0.psdiff_2.buff_d8$1_1.VIN.n6 0.590328
R15280 6ph_rosc_0.psdiff_2.buff_d8$1_1.VIN.n21 6ph_rosc_0.psdiff_2.buff_d8$1_1.VIN.n20 0.351125
R15281 6ph_rosc_0.psdiff_2.buff_d8$1_1.VIN.n5 6ph_rosc_0.psdiff_2.buff_d8$1_1.VIN.n4 0.351125
R15282 6ph_rosc_0.psdiff_2.buff_d8$1_1.VIN.n1 6ph_rosc_0.psdiff_2.buff_d8$1_1.VIN.n0 0.351125
R15283 6ph_rosc_0.psdiff_2.buff_d8$1_1.VIN.n3 6ph_rosc_0.psdiff_2.buff_d8$1_1.VIN.n2 0.351125
R15284 6ph_rosc_0.psdiff_2.buff_d8$1_1.VIN.n27 6ph_rosc_0.psdiff_2.buff_d8$1_1.VIN.n26 0.318765
R15285 6ph_rosc_0.psdiff_2.buff_d8$1_1.VIN.n15 6ph_rosc_0.psdiff_2.buff_d8$1_1.VIN.n12 0.213625
R15286 6ph_rosc_0.psdiff_2.buff_d8$1_1.VIN.n16 6ph_rosc_0.psdiff_2.buff_d8$1_1.VIN.n10 0.213625
R15287 6ph_rosc_0.psdiff_2.buff_d8$1_1.VIN.n17 6ph_rosc_0.psdiff_2.buff_d8$1_1.VIN.n8 0.213625
R15288 6ph_rosc_0.psdiff_2.buff_d8$1_1.VIN.n22 6ph_rosc_0.psdiff_2.buff_d8$1_1.VIN.n21 0.213625
R15289 6ph_rosc_0.psdiff_2.buff_d8$1_1.VIN.n23 6ph_rosc_0.psdiff_2.buff_d8$1_1.VIN.n5 0.213625
R15290 6ph_rosc_0.psdiff_2.buff_d8$1_1.VIN.n25 6ph_rosc_0.psdiff_2.buff_d8$1_1.VIN.n1 0.213625
R15291 6ph_rosc_0.psdiff_2.buff_d8$1_1.VIN.n24 6ph_rosc_0.psdiff_2.buff_d8$1_1.VIN.n3 0.213625
R15292 6ph_rosc_0.psdiff_2.buff_d8$1_1.VIN.n22 6ph_rosc_0.psdiff_2.buff_d8$1_1.VIN.n19 0.184703
R15293 6ph_rosc_0.psdiff_2.buff_d8$1_1.inv$3_0.VIN 6ph_rosc_0.psdiff_2.buff_d8$1_1.VIN.n28 0.0151667
R15294 PH180.n46 PH180.t24 17.6089
R15295 PH180.n49 PH180.t19 17.6089
R15296 PH180.n52 PH180.t27 17.6089
R15297 PH180.n55 PH180.t13 17.6089
R15298 PH180.n58 PH180.t20 17.6089
R15299 PH180.n61 PH180.t1 17.6089
R15300 PH180.n64 PH180.t22 17.6089
R15301 PH180.n67 PH180.t23 17.6089
R15302 PH180.n23 PH180.t5 17.6089
R15303 PH180.n26 PH180.t6 17.6089
R15304 PH180.n29 PH180.t11 17.6089
R15305 PH180.n32 PH180.t25 17.6089
R15306 PH180.n35 PH180.t28 17.6089
R15307 PH180.n38 PH180.t17 17.6089
R15308 PH180.n41 PH180.t30 17.6089
R15309 PH180.n44 PH180.t4 17.6089
R15310 PH180.n0 PH180.t15 17.6089
R15311 PH180.n3 PH180.t16 17.6089
R15312 PH180.n6 PH180.t21 17.6089
R15313 PH180.n9 PH180.t29 17.6089
R15314 PH180.n12 PH180.t31 17.6089
R15315 PH180.n15 PH180.t7 17.6089
R15316 PH180.n18 PH180.t0 17.6089
R15317 PH180.n21 PH180.t14 17.6089
R15318 PH180.n70 PH180.t12 17.6089
R15319 PH180.n73 PH180.t2 17.6089
R15320 PH180.n76 PH180.t18 17.6089
R15321 PH180.n82 PH180.t3 17.6089
R15322 PH180.n85 PH180.t26 17.6089
R15323 PH180.n88 PH180.t9 17.6089
R15324 PH180.n91 PH180.t10 17.6089
R15325 PH180.n79 PH180.t8 17.6089
R15326 PH180 PH180.t58 17.5436
R15327 PH180 PH180.t44 17.5436
R15328 PH180 PH180.t68 17.5436
R15329 PH180 PH180.t73 17.5436
R15330 PH180.n68 PH180.t69 17.2136
R15331 PH180.n66 PH180.t57 17.2136
R15332 PH180.n65 PH180.t34 17.2136
R15333 PH180.n63 PH180.t56 17.2136
R15334 PH180.n62 PH180.t33 17.2136
R15335 PH180.n60 PH180.t46 17.2136
R15336 PH180.n59 PH180.t94 17.2136
R15337 PH180.n57 PH180.t45 17.2136
R15338 PH180.n56 PH180.t84 17.2136
R15339 PH180.n54 PH180.t90 17.2136
R15340 PH180.n53 PH180.t93 17.2136
R15341 PH180.n51 PH180.t37 17.2136
R15342 PH180.n50 PH180.t59 17.2136
R15343 PH180.n48 PH180.t88 17.2136
R15344 PH180.n47 PH180.t91 17.2136
R15345 PH180.n45 PH180.t82 17.2136
R15346 PH180.n43 PH180.t74 17.2136
R15347 PH180.n42 PH180.t50 17.2136
R15348 PH180.n40 PH180.t72 17.2136
R15349 PH180.n39 PH180.t49 17.2136
R15350 PH180.n37 PH180.t65 17.2136
R15351 PH180.n36 PH180.t42 17.2136
R15352 PH180.n34 PH180.t64 17.2136
R15353 PH180.n33 PH180.t40 17.2136
R15354 PH180.n31 PH180.t95 17.2136
R15355 PH180.n30 PH180.t39 17.2136
R15356 PH180.n28 PH180.t54 17.2136
R15357 PH180.n27 PH180.t77 17.2136
R15358 PH180.n25 PH180.t92 17.2136
R15359 PH180.n24 PH180.t32 17.2136
R15360 PH180.n22 PH180.t53 17.2136
R15361 PH180.n20 PH180.t86 17.2136
R15362 PH180.n19 PH180.t76 17.2136
R15363 PH180.n17 PH180.t52 17.2136
R15364 PH180.n16 PH180.t75 17.2136
R15365 PH180.n14 PH180.t83 17.2136
R15366 PH180.n13 PH180.t67 17.2136
R15367 PH180.n11 PH180.t43 17.2136
R15368 PH180.n10 PH180.t35 17.2136
R15369 PH180.n8 PH180.t51 17.2136
R15370 PH180.n7 PH180.t66 17.2136
R15371 PH180.n5 PH180.t78 17.2136
R15372 PH180.n4 PH180.t87 17.2136
R15373 PH180.n2 PH180.t41 17.2136
R15374 PH180.n1 PH180.t55 17.2136
R15375 PH180.n69 PH180.t62 17.2136
R15376 PH180.n90 PH180.t89 17.2136
R15377 PH180.n89 PH180.t80 17.2136
R15378 PH180.n87 PH180.t61 17.2136
R15379 PH180.n86 PH180.t79 17.2136
R15380 PH180.n84 PH180.t85 17.2136
R15381 PH180.n83 PH180.t71 17.2136
R15382 PH180.n81 PH180.t48 17.2136
R15383 PH180.n80 PH180.t38 17.2136
R15384 PH180.n78 PH180.t60 17.2136
R15385 PH180.n77 PH180.t70 17.2136
R15386 PH180.n75 PH180.t81 17.2136
R15387 PH180.n74 PH180.t36 17.2136
R15388 PH180.n72 PH180.t47 17.2136
R15389 PH180.n71 PH180.t63 17.2136
R15390 PH180.n69 PH180 5.49623
R15391 PH180 PH180.n68 5.12956
R15392 PH180 PH180.n45 5.12956
R15393 PH180 PH180.n22 5.12956
R15394 PH180.n63 PH180.n62 1.41675
R15395 PH180.n57 PH180.n56 1.41675
R15396 PH180.n51 PH180.n50 1.41675
R15397 PH180.n40 PH180.n39 1.41675
R15398 PH180.n34 PH180.n33 1.41675
R15399 PH180.n28 PH180.n27 1.41675
R15400 PH180.n17 PH180.n16 1.41675
R15401 PH180.n11 PH180.n10 1.41675
R15402 PH180.n5 PH180.n4 1.41675
R15403 PH180.n87 PH180.n86 1.41675
R15404 PH180.n81 PH180.n80 1.41675
R15405 PH180.n75 PH180.n74 1.41675
R15406 PH180.n66 PH180.n65 0.633
R15407 PH180.n60 PH180.n59 0.633
R15408 PH180.n54 PH180.n53 0.633
R15409 PH180.n48 PH180.n47 0.633
R15410 PH180.n43 PH180.n42 0.633
R15411 PH180.n37 PH180.n36 0.633
R15412 PH180.n31 PH180.n30 0.633
R15413 PH180.n25 PH180.n24 0.633
R15414 PH180.n20 PH180.n19 0.633
R15415 PH180.n14 PH180.n13 0.633
R15416 PH180.n8 PH180.n7 0.633
R15417 PH180.n2 PH180.n1 0.633
R15418 PH180.n90 PH180.n89 0.633
R15419 PH180.n84 PH180.n83 0.633
R15420 PH180.n78 PH180.n77 0.633
R15421 PH180.n72 PH180.n71 0.633
R15422 PH180.n65 PH180.n64 0.392375
R15423 PH180.n59 PH180.n58 0.392375
R15424 PH180.n53 PH180.n52 0.392375
R15425 PH180.n47 PH180.n46 0.392375
R15426 PH180.n42 PH180.n41 0.392375
R15427 PH180.n36 PH180.n35 0.392375
R15428 PH180.n30 PH180.n29 0.392375
R15429 PH180.n24 PH180.n23 0.392375
R15430 PH180.n19 PH180.n18 0.392375
R15431 PH180.n13 PH180.n12 0.392375
R15432 PH180.n7 PH180.n6 0.392375
R15433 PH180.n1 PH180.n0 0.392375
R15434 PH180.n89 PH180.n88 0.392375
R15435 PH180.n83 PH180.n82 0.392375
R15436 PH180.n77 PH180.n76 0.392375
R15437 PH180.n71 PH180.n70 0.392375
R15438 PH180.n67 PH180 0.358
R15439 PH180.n61 PH180 0.358
R15440 PH180.n55 PH180 0.358
R15441 PH180.n49 PH180 0.358
R15442 PH180.n44 PH180 0.358
R15443 PH180.n38 PH180 0.358
R15444 PH180.n32 PH180 0.358
R15445 PH180.n26 PH180 0.358
R15446 PH180.n21 PH180 0.358
R15447 PH180.n15 PH180 0.358
R15448 PH180.n9 PH180 0.358
R15449 PH180.n3 PH180 0.358
R15450 PH180.n91 PH180 0.358
R15451 PH180.n85 PH180 0.358
R15452 PH180.n79 PH180 0.358
R15453 PH180.n73 PH180 0.358
R15454 PH180 PH180.n63 0.3305
R15455 PH180.n62 PH180 0.3305
R15456 PH180 PH180.n57 0.3305
R15457 PH180 PH180.n51 0.3305
R15458 PH180.n50 PH180 0.3305
R15459 PH180 PH180.n40 0.3305
R15460 PH180.n39 PH180 0.3305
R15461 PH180 PH180.n34 0.3305
R15462 PH180 PH180.n28 0.3305
R15463 PH180.n27 PH180 0.3305
R15464 PH180 PH180.n17 0.3305
R15465 PH180.n16 PH180 0.3305
R15466 PH180 PH180.n11 0.3305
R15467 PH180 PH180.n5 0.3305
R15468 PH180.n4 PH180 0.3305
R15469 PH180 PH180.n87 0.3305
R15470 PH180.n86 PH180 0.3305
R15471 PH180 PH180.n81 0.3305
R15472 PH180 PH180.n75 0.3305
R15473 PH180.n74 PH180 0.3305
R15474 PH180.n68 PH180 0.113938
R15475 PH180.n56 PH180 0.113938
R15476 PH180.n45 PH180 0.113938
R15477 PH180.n33 PH180 0.113938
R15478 PH180.n22 PH180 0.113938
R15479 PH180.n10 PH180 0.113938
R15480 PH180 PH180.n69 0.113938
R15481 PH180.n80 PH180 0.113938
R15482 PH180 PH180.n67 0.062375
R15483 PH180.n64 PH180 0.062375
R15484 PH180 PH180.n61 0.062375
R15485 PH180.n58 PH180 0.062375
R15486 PH180 PH180.n55 0.062375
R15487 PH180.n52 PH180 0.062375
R15488 PH180 PH180.n49 0.062375
R15489 PH180.n46 PH180 0.062375
R15490 PH180 PH180.n44 0.062375
R15491 PH180.n41 PH180 0.062375
R15492 PH180 PH180.n38 0.062375
R15493 PH180.n35 PH180 0.062375
R15494 PH180 PH180.n32 0.062375
R15495 PH180.n29 PH180 0.062375
R15496 PH180 PH180.n26 0.062375
R15497 PH180.n23 PH180 0.062375
R15498 PH180 PH180.n21 0.062375
R15499 PH180.n18 PH180 0.062375
R15500 PH180 PH180.n15 0.062375
R15501 PH180.n12 PH180 0.062375
R15502 PH180 PH180.n9 0.062375
R15503 PH180.n6 PH180 0.062375
R15504 PH180 PH180.n3 0.062375
R15505 PH180.n0 PH180 0.062375
R15506 PH180 PH180.n91 0.062375
R15507 PH180.n88 PH180 0.062375
R15508 PH180 PH180.n85 0.062375
R15509 PH180.n82 PH180 0.062375
R15510 PH180 PH180.n79 0.062375
R15511 PH180.n76 PH180 0.062375
R15512 PH180 PH180.n73 0.062375
R15513 PH180.n70 PH180 0.062375
R15514 PH180 PH180.n66 0.034875
R15515 PH180 PH180.n60 0.034875
R15516 PH180 PH180.n54 0.034875
R15517 PH180 PH180.n48 0.034875
R15518 PH180 PH180.n43 0.034875
R15519 PH180 PH180.n37 0.034875
R15520 PH180 PH180.n31 0.034875
R15521 PH180 PH180.n25 0.034875
R15522 PH180 PH180.n20 0.034875
R15523 PH180 PH180.n14 0.034875
R15524 PH180 PH180.n8 0.034875
R15525 PH180 PH180.n2 0.034875
R15526 PH180 PH180.n90 0.034875
R15527 PH180 PH180.n84 0.034875
R15528 PH180 PH180.n78 0.034875
R15529 PH180 PH180.n72 0.034875
R15530 6ph_rosc_0.PH4.n21 6ph_rosc_0.PH4 29.7965
R15531 6ph_rosc_0.PH4 6ph_rosc_0.PH4.t1 17.3649
R15532 6ph_rosc_0.PH4.n2 6ph_rosc_0.PH4.t4 17.0005
R15533 6ph_rosc_0.PH4.n4 6ph_rosc_0.PH4.t9 17.0005
R15534 6ph_rosc_0.PH4.n5 6ph_rosc_0.PH4.t5 17.0005
R15535 6ph_rosc_0.PH4.n7 6ph_rosc_0.PH4.t7 17.0005
R15536 6ph_rosc_0.PH4.n8 6ph_rosc_0.PH4.t3 17.0005
R15537 6ph_rosc_0.PH4.n10 6ph_rosc_0.PH4.t8 17.0005
R15538 6ph_rosc_0.PH4.n11 6ph_rosc_0.PH4.t2 17.0005
R15539 6ph_rosc_0.PH4.n13 6ph_rosc_0.PH4.t6 17.0005
R15540 6ph_rosc_0.PH4.n24 6ph_rosc_0.PH4.t0 17.0005
R15541 6ph_rosc_0.PH4 6ph_rosc_0.PH4.t13 15.0005
R15542 6ph_rosc_0.PH4.n1 6ph_rosc_0.PH4.t12 15.0005
R15543 6ph_rosc_0.PH4.n19 6ph_rosc_0.PH4.t14 15.0005
R15544 6ph_rosc_0.PH4.n18 6ph_rosc_0.PH4.t11 15.0005
R15545 6ph_rosc_0.PH4 6ph_rosc_0.PH4.t10 15.0005
R15546 6ph_rosc_0.PH4.n20 6ph_rosc_0.PH4.n18 10.3469
R15547 6ph_rosc_0.PH4.n24 6ph_rosc_0.PH4.n23 9.9201
R15548 6ph_rosc_0.PH4.n14 6ph_rosc_0.PH4.n13 9.91525
R15549 6ph_rosc_0.PH4.n16 6ph_rosc_0.PH4.n4 9.12325
R15550 6ph_rosc_0.PH4.n15 6ph_rosc_0.PH4.n7 9.12325
R15551 6ph_rosc_0.PH4.n14 6ph_rosc_0.PH4.n10 9.12325
R15552 6ph_rosc_0.PH4.n20 6ph_rosc_0.PH4.n19 9.0005
R15553 6ph_rosc_0.PH4.n17 6ph_rosc_0.PH4 9.0005
R15554 6ph_rosc_0.PH4.n23 6ph_rosc_0.PH4.n1 9.0005
R15555 6ph_rosc_0.PH4.n22 6ph_rosc_0.PH4 9.0005
R15556 6ph_rosc_0.PH4.n17 6ph_rosc_0.PH4.n16 3.2455
R15557 6ph_rosc_0.PH4.n4 6ph_rosc_0.PH4 1.19877
R15558 6ph_rosc_0.PH4.n7 6ph_rosc_0.PH4 1.19877
R15559 6ph_rosc_0.PH4.n10 6ph_rosc_0.PH4 1.19877
R15560 6ph_rosc_0.PH4.n13 6ph_rosc_0.PH4 1.19877
R15561 6ph_rosc_0.PH4.n22 6ph_rosc_0.PH4.n21 1.19719
R15562 6ph_rosc_0.PH4.n21 6ph_rosc_0.PH4.n17 0.806901
R15563 6ph_rosc_0.PH4.n16 6ph_rosc_0.PH4.n15 0.7925
R15564 6ph_rosc_0.PH4.n3 6ph_rosc_0.PH4 0.559983
R15565 6ph_rosc_0.PH4.n6 6ph_rosc_0.PH4 0.559983
R15566 6ph_rosc_0.PH4.n9 6ph_rosc_0.PH4 0.559983
R15567 6ph_rosc_0.PH4.n12 6ph_rosc_0.PH4 0.559983
R15568 6ph_rosc_0.PH4.n23 6ph_rosc_0.PH4.n22 0.4405
R15569 6ph_rosc_0.PH4.n15 6ph_rosc_0.PH4 0.4273
R15570 6ph_rosc_0.PH4 6ph_rosc_0.PH4.n14 0.3657
R15571 6ph_rosc_0.PH4.n25 6ph_rosc_0.PH4 0.3525
R15572 6ph_rosc_0.PH4.n3 6ph_rosc_0.PH4 0.292688
R15573 6ph_rosc_0.PH4.n6 6ph_rosc_0.PH4 0.292688
R15574 6ph_rosc_0.PH4.n9 6ph_rosc_0.PH4 0.292688
R15575 6ph_rosc_0.PH4.n12 6ph_rosc_0.PH4 0.292688
R15576 6ph_rosc_0.PH4 6ph_rosc_0.PH4.n2 0.282375
R15577 6ph_rosc_0.PH4 6ph_rosc_0.PH4.n5 0.282375
R15578 6ph_rosc_0.PH4 6ph_rosc_0.PH4.n8 0.282375
R15579 6ph_rosc_0.PH4 6ph_rosc_0.PH4.n11 0.282375
R15580 6ph_rosc_0.PH4.n0 6ph_rosc_0.PH4 0.210188
R15581 6ph_rosc_0.PH4.n0 6ph_rosc_0.PH4 0.162063
R15582 6ph_rosc_0.PH4.n2 6ph_rosc_0.PH4 0.089875
R15583 6ph_rosc_0.PH4.n5 6ph_rosc_0.PH4 0.089875
R15584 6ph_rosc_0.PH4.n8 6ph_rosc_0.PH4 0.089875
R15585 6ph_rosc_0.PH4.n11 6ph_rosc_0.PH4 0.089875
R15586 6ph_rosc_0.PH4 6ph_rosc_0.PH4.n20 0.0643
R15587 6ph_rosc_0.PH4.n1 6ph_rosc_0.PH4 0.0555
R15588 6ph_rosc_0.PH4.n18 6ph_rosc_0.PH4 0.0555
R15589 6ph_rosc_0.PH4.n4 6ph_rosc_0.PH4.n3 0.0403276
R15590 6ph_rosc_0.PH4.n7 6ph_rosc_0.PH4.n6 0.0403276
R15591 6ph_rosc_0.PH4.n10 6ph_rosc_0.PH4.n9 0.0403276
R15592 6ph_rosc_0.PH4.n13 6ph_rosc_0.PH4.n12 0.0403276
R15593 6ph_rosc_0.PH4.n24 6ph_rosc_0.PH4.n0 0.0403276
R15594 6ph_rosc_0.PH4.n25 6ph_rosc_0.PH4.n24 0.0403276
R15595 6ph_rosc_0.PH4.n1 6ph_rosc_0.PH4 0.0115
R15596 6ph_rosc_0.PH4.n19 6ph_rosc_0.PH4 0.0115
R15597 6ph_rosc_0.PH4 6ph_rosc_0.PH4.n25 0.00998276
R15598 6ph_rosc_0.PH3.n16 6ph_rosc_0.PH3.n14 25.5471
R15599 6ph_rosc_0.PH3.n20 6ph_rosc_0.PH3 18.9231
R15600 6ph_rosc_0.PH3.n0 6ph_rosc_0.PH3.t4 17.0005
R15601 6ph_rosc_0.PH3.n2 6ph_rosc_0.PH3.t6 17.0005
R15602 6ph_rosc_0.PH3.n9 6ph_rosc_0.PH3.t3 17.0005
R15603 6ph_rosc_0.PH3.n11 6ph_rosc_0.PH3.t7 17.0005
R15604 6ph_rosc_0.PH3.n6 6ph_rosc_0.PH3.t5 17.0005
R15605 6ph_rosc_0.PH3.n8 6ph_rosc_0.PH3.t8 17.0005
R15606 6ph_rosc_0.PH3.n3 6ph_rosc_0.PH3.t2 17.0005
R15607 6ph_rosc_0.PH3.n5 6ph_rosc_0.PH3.t9 17.0005
R15608 6ph_rosc_0.PH3.n24 6ph_rosc_0.PH3.t1 17.0005
R15609 6ph_rosc_0.PH3.n26 6ph_rosc_0.PH3.t0 17.0005
R15610 6ph_rosc_0.PH3.n22 6ph_rosc_0.PH3.t14 15.0005
R15611 6ph_rosc_0.PH3 6ph_rosc_0.PH3.t13 15.0005
R15612 6ph_rosc_0.PH3.n18 6ph_rosc_0.PH3.t10 15.0005
R15613 6ph_rosc_0.PH3.n17 6ph_rosc_0.PH3.t12 15.0005
R15614 6ph_rosc_0.PH3.n15 6ph_rosc_0.PH3.t11 15.0005
R15615 6ph_rosc_0.PH3.n19 6ph_rosc_0.PH3.n17 10.3469
R15616 6ph_rosc_0.PH3.n24 6ph_rosc_0.PH3.n23 9.9157
R15617 6ph_rosc_0.PH3.n12 6ph_rosc_0.PH3.n11 9.91525
R15618 6ph_rosc_0.PH3.n14 6ph_rosc_0.PH3.n2 9.12325
R15619 6ph_rosc_0.PH3.n12 6ph_rosc_0.PH3.n8 9.12325
R15620 6ph_rosc_0.PH3.n13 6ph_rosc_0.PH3.n5 9.12325
R15621 6ph_rosc_0.PH3.n19 6ph_rosc_0.PH3.n18 9.0005
R15622 6ph_rosc_0.PH3.n16 6ph_rosc_0.PH3.n15 9.0005
R15623 6ph_rosc_0.PH3.n21 6ph_rosc_0.PH3 9.0005
R15624 6ph_rosc_0.PH3.n23 6ph_rosc_0.PH3.n22 9.0005
R15625 6ph_rosc_0.PH3.n2 6ph_rosc_0.PH3 1.19877
R15626 6ph_rosc_0.PH3.n11 6ph_rosc_0.PH3 1.19877
R15627 6ph_rosc_0.PH3.n8 6ph_rosc_0.PH3 1.19877
R15628 6ph_rosc_0.PH3.n5 6ph_rosc_0.PH3 1.19877
R15629 6ph_rosc_0.PH3.n24 6ph_rosc_0.PH3 1.19877
R15630 6ph_rosc_0.PH3.n21 6ph_rosc_0.PH3.n20 1.19719
R15631 6ph_rosc_0.PH3.n20 6ph_rosc_0.PH3.n16 0.806901
R15632 6ph_rosc_0.PH3.n14 6ph_rosc_0.PH3.n13 0.7925
R15633 6ph_rosc_0.PH3.n1 6ph_rosc_0.PH3 0.559983
R15634 6ph_rosc_0.PH3.n10 6ph_rosc_0.PH3 0.559983
R15635 6ph_rosc_0.PH3.n7 6ph_rosc_0.PH3 0.559983
R15636 6ph_rosc_0.PH3.n4 6ph_rosc_0.PH3 0.559983
R15637 6ph_rosc_0.PH3.n25 6ph_rosc_0.PH3 0.559983
R15638 6ph_rosc_0.PH3.n23 6ph_rosc_0.PH3.n21 0.4405
R15639 6ph_rosc_0.PH3.n13 6ph_rosc_0.PH3 0.4273
R15640 6ph_rosc_0.PH3 6ph_rosc_0.PH3.n12 0.3657
R15641 6ph_rosc_0.PH3.n1 6ph_rosc_0.PH3 0.292688
R15642 6ph_rosc_0.PH3.n10 6ph_rosc_0.PH3 0.292688
R15643 6ph_rosc_0.PH3.n7 6ph_rosc_0.PH3 0.292688
R15644 6ph_rosc_0.PH3.n4 6ph_rosc_0.PH3 0.292688
R15645 6ph_rosc_0.PH3 6ph_rosc_0.PH3.n25 0.292688
R15646 6ph_rosc_0.PH3 6ph_rosc_0.PH3.n0 0.282375
R15647 6ph_rosc_0.PH3 6ph_rosc_0.PH3.n9 0.282375
R15648 6ph_rosc_0.PH3 6ph_rosc_0.PH3.n6 0.282375
R15649 6ph_rosc_0.PH3 6ph_rosc_0.PH3.n3 0.282375
R15650 6ph_rosc_0.PH3.n26 6ph_rosc_0.PH3 0.282375
R15651 6ph_rosc_0.PH3.n0 6ph_rosc_0.PH3 0.089875
R15652 6ph_rosc_0.PH3.n9 6ph_rosc_0.PH3 0.089875
R15653 6ph_rosc_0.PH3.n6 6ph_rosc_0.PH3 0.089875
R15654 6ph_rosc_0.PH3.n3 6ph_rosc_0.PH3 0.089875
R15655 6ph_rosc_0.PH3 6ph_rosc_0.PH3.n26 0.089875
R15656 6ph_rosc_0.PH3 6ph_rosc_0.PH3.n19 0.0643
R15657 6ph_rosc_0.PH3.n17 6ph_rosc_0.PH3 0.0555
R15658 6ph_rosc_0.PH3.n2 6ph_rosc_0.PH3.n1 0.0403276
R15659 6ph_rosc_0.PH3.n11 6ph_rosc_0.PH3.n10 0.0403276
R15660 6ph_rosc_0.PH3.n8 6ph_rosc_0.PH3.n7 0.0403276
R15661 6ph_rosc_0.PH3.n5 6ph_rosc_0.PH3.n4 0.0403276
R15662 6ph_rosc_0.PH3.n25 6ph_rosc_0.PH3.n24 0.0403276
R15663 6ph_rosc_0.PH3.n22 6ph_rosc_0.PH3 0.0151667
R15664 6ph_rosc_0.PH3.n18 6ph_rosc_0.PH3 0.0115
R15665 6ph_rosc_0.PH3.n15 6ph_rosc_0.PH3 0.0115
R15666 6to4_0.buff_PI_d32_3.buff_PI_d16$1_0.inv_PI_d8$1_0.VOUT.n35 6to4_0.buff_PI_d32_3.buff_PI_d16$1_0.inv_PI_d8$1_0.VOUT.t6 17.6089
R15667 6to4_0.buff_PI_d32_3.buff_PI_d16$1_0.inv_PI_d8$1_0.VOUT.n38 6to4_0.buff_PI_d32_3.buff_PI_d16$1_0.inv_PI_d8$1_0.VOUT.t4 17.6089
R15668 6to4_0.buff_PI_d32_3.buff_PI_d16$1_0.inv_PI_d8$1_0.VOUT.n44 6to4_0.buff_PI_d32_3.buff_PI_d16$1_0.inv_PI_d8$1_0.VOUT.t1 17.6089
R15669 6to4_0.buff_PI_d32_3.buff_PI_d16$1_0.inv_PI_d8$1_0.VOUT.n47 6to4_0.buff_PI_d32_3.buff_PI_d16$1_0.inv_PI_d8$1_0.VOUT.t3 17.6089
R15670 6to4_0.buff_PI_d32_3.buff_PI_d16$1_0.inv_PI_d8$1_0.VOUT.n50 6to4_0.buff_PI_d32_3.buff_PI_d16$1_0.inv_PI_d8$1_0.VOUT.t0 17.6089
R15671 6to4_0.buff_PI_d32_3.buff_PI_d16$1_0.inv_PI_d8$1_0.VOUT.n53 6to4_0.buff_PI_d32_3.buff_PI_d16$1_0.inv_PI_d8$1_0.VOUT.t5 17.6089
R15672 6to4_0.buff_PI_d32_3.buff_PI_d16$1_0.inv_PI_d8$1_0.VOUT.n56 6to4_0.buff_PI_d32_3.buff_PI_d16$1_0.inv_PI_d8$1_0.VOUT.t2 17.6089
R15673 6to4_0.buff_PI_d32_3.buff_PI_d16$1_0.inv_PI_d8$1_0.VOUT.n41 6to4_0.buff_PI_d32_3.buff_PI_d16$1_0.inv_PI_d8$1_0.VOUT.t7 17.6089
R15674 6to4_0.buff_PI_d32_3.buff_PI_d16$1_0.inv_PI_d8$1_0.inv_PI_d4$1_1.inv_PI_d2$1_1.inv_PI$1_1.VOUT 6to4_0.buff_PI_d32_3.buff_PI_d16$1_0.inv_PI_d8$1_0.VOUT.t21 17.5436
R15675 6to4_0.buff_PI_d32_3.buff_PI_d16$1_0.inv_PI_d8$1_0.VOUT.n34 6to4_0.buff_PI_d32_3.buff_PI_d16$1_0.inv_PI_d8$1_0.VOUT.t13 17.2136
R15676 6to4_0.buff_PI_d32_3.buff_PI_d16$1_0.inv_PI_d8$1_0.VOUT.n55 6to4_0.buff_PI_d32_3.buff_PI_d16$1_0.inv_PI_d8$1_0.VOUT.t22 17.2136
R15677 6to4_0.buff_PI_d32_3.buff_PI_d16$1_0.inv_PI_d8$1_0.VOUT.n54 6to4_0.buff_PI_d32_3.buff_PI_d16$1_0.inv_PI_d8$1_0.VOUT.t18 17.2136
R15678 6to4_0.buff_PI_d32_3.buff_PI_d16$1_0.inv_PI_d8$1_0.VOUT.n52 6to4_0.buff_PI_d32_3.buff_PI_d16$1_0.inv_PI_d8$1_0.VOUT.t20 17.2136
R15679 6to4_0.buff_PI_d32_3.buff_PI_d16$1_0.inv_PI_d8$1_0.VOUT.n51 6to4_0.buff_PI_d32_3.buff_PI_d16$1_0.inv_PI_d8$1_0.VOUT.t10 17.2136
R15680 6to4_0.buff_PI_d32_3.buff_PI_d16$1_0.inv_PI_d8$1_0.VOUT.n49 6to4_0.buff_PI_d32_3.buff_PI_d16$1_0.inv_PI_d8$1_0.VOUT.t19 17.2136
R15681 6to4_0.buff_PI_d32_3.buff_PI_d16$1_0.inv_PI_d8$1_0.VOUT.n48 6to4_0.buff_PI_d32_3.buff_PI_d16$1_0.inv_PI_d8$1_0.VOUT.t16 17.2136
R15682 6to4_0.buff_PI_d32_3.buff_PI_d16$1_0.inv_PI_d8$1_0.VOUT.n46 6to4_0.buff_PI_d32_3.buff_PI_d16$1_0.inv_PI_d8$1_0.VOUT.t12 17.2136
R15683 6to4_0.buff_PI_d32_3.buff_PI_d16$1_0.inv_PI_d8$1_0.VOUT.n45 6to4_0.buff_PI_d32_3.buff_PI_d16$1_0.inv_PI_d8$1_0.VOUT.t15 17.2136
R15684 6to4_0.buff_PI_d32_3.buff_PI_d16$1_0.inv_PI_d8$1_0.VOUT.n43 6to4_0.buff_PI_d32_3.buff_PI_d16$1_0.inv_PI_d8$1_0.VOUT.t11 17.2136
R15685 6to4_0.buff_PI_d32_3.buff_PI_d16$1_0.inv_PI_d8$1_0.VOUT.n42 6to4_0.buff_PI_d32_3.buff_PI_d16$1_0.inv_PI_d8$1_0.VOUT.t8 17.2136
R15686 6to4_0.buff_PI_d32_3.buff_PI_d16$1_0.inv_PI_d8$1_0.VOUT.n40 6to4_0.buff_PI_d32_3.buff_PI_d16$1_0.inv_PI_d8$1_0.VOUT.t9 17.2136
R15687 6to4_0.buff_PI_d32_3.buff_PI_d16$1_0.inv_PI_d8$1_0.VOUT.n39 6to4_0.buff_PI_d32_3.buff_PI_d16$1_0.inv_PI_d8$1_0.VOUT.t14 17.2136
R15688 6to4_0.buff_PI_d32_3.buff_PI_d16$1_0.inv_PI_d8$1_0.VOUT.n37 6to4_0.buff_PI_d32_3.buff_PI_d16$1_0.inv_PI_d8$1_0.VOUT.t17 17.2136
R15689 6to4_0.buff_PI_d32_3.buff_PI_d16$1_0.inv_PI_d8$1_0.VOUT.n36 6to4_0.buff_PI_d32_3.buff_PI_d16$1_0.inv_PI_d8$1_0.VOUT.t23 17.2136
R15690 6to4_0.buff_PI_d32_3.buff_PI_d16$1_0.inv_PI_d8$1_0.VOUT.n31 6to4_0.buff_PI_d32_3.buff_PI_d16$1_0.inv_PI_d8$1_0.VOUT.t27 15.0005
R15691 6to4_0.buff_PI_d32_3.buff_PI_d16$1_0.inv_PI_d8$1_0.VOUT.n27 6to4_0.buff_PI_d32_3.buff_PI_d16$1_0.inv_PI_d8$1_0.VOUT.t30 15.0005
R15692 6to4_0.buff_PI_d32_3.buff_PI_d16$1_0.inv_PI_d8$1_0.VOUT.n25 6to4_0.buff_PI_d32_3.buff_PI_d16$1_0.inv_PI_d8$1_0.VOUT.t24 15.0005
R15693 6to4_0.buff_PI_d32_3.buff_PI_d16$1_0.inv_PI_d8$1_0.VOUT.n21 6to4_0.buff_PI_d32_3.buff_PI_d16$1_0.inv_PI_d8$1_0.VOUT.t29 15.0005
R15694 6to4_0.buff_PI_d32_3.buff_PI_d16$1_0.inv_PI_d8$1_0.VOUT.n19 6to4_0.buff_PI_d32_3.buff_PI_d16$1_0.inv_PI_d8$1_0.VOUT.t39 15.0005
R15695 6to4_0.buff_PI_d32_3.buff_PI_d16$1_0.inv_PI_d8$1_0.VOUT.n10 6to4_0.buff_PI_d32_3.buff_PI_d16$1_0.inv_PI_d8$1_0.VOUT.t38 15.0005
R15696 6to4_0.buff_PI_d32_3.buff_PI_d16$1_0.inv_PI_d8$1_0.VOUT.n9 6to4_0.buff_PI_d32_3.buff_PI_d16$1_0.inv_PI_d8$1_0.VOUT.t37 15.0005
R15697 6to4_0.buff_PI_d32_3.buff_PI_d16$1_0.inv_PI_d8$1_0.VOUT.n15 6to4_0.buff_PI_d32_3.buff_PI_d16$1_0.inv_PI_d8$1_0.VOUT.t25 15.0005
R15698 6to4_0.buff_PI_d32_3.buff_PI_d16$1_0.inv_PI_d8$1_0.VOUT.n14 6to4_0.buff_PI_d32_3.buff_PI_d16$1_0.inv_PI_d8$1_0.VOUT.t32 15.0005
R15699 6to4_0.buff_PI_d32_3.buff_PI_d16$1_0.inv_PI_d8$1_0.VOUT.n5 6to4_0.buff_PI_d32_3.buff_PI_d16$1_0.inv_PI_d8$1_0.VOUT.t33 15.0005
R15700 6to4_0.buff_PI_d32_3.buff_PI_d16$1_0.inv_PI_d8$1_0.VOUT.n12 6to4_0.buff_PI_d32_3.buff_PI_d16$1_0.inv_PI_d8$1_0.VOUT.t36 15.0005
R15701 6to4_0.buff_PI_d32_3.buff_PI_d16$1_0.inv_PI_d8$1_0.VOUT.n0 6to4_0.buff_PI_d32_3.buff_PI_d16$1_0.inv_PI_d8$1_0.VOUT.t35 15.0005
R15702 6to4_0.buff_PI_d32_3.buff_PI_d16$1_0.inv_PI_d8$1_0.VOUT.n7 6to4_0.buff_PI_d32_3.buff_PI_d16$1_0.inv_PI_d8$1_0.VOUT.t28 15.0005
R15703 6to4_0.buff_PI_d32_3.buff_PI_d16$1_0.inv_PI_d8$1_0.VOUT.n2 6to4_0.buff_PI_d32_3.buff_PI_d16$1_0.inv_PI_d8$1_0.VOUT.t26 15.0005
R15704 6to4_0.buff_PI_d32_3.buff_PI_d16$1_0.inv_PI_d8$1_0.VOUT.n3 6to4_0.buff_PI_d32_3.buff_PI_d16$1_0.inv_PI_d8$1_0.VOUT.t31 15.0005
R15705 6to4_0.buff_PI_d32_3.buff_PI_d16$1_0.inv_PI_d8$1_0.VOUT.n33 6to4_0.buff_PI_d32_3.buff_PI_d16$1_0.inv_PI_d8$1_0.VOUT.t34 15.0005
R15706 6to4_0.buff_PI_d32_3.buff_PI_d16$1_0.inv_PI_d8$1_0.VOUT.n11 6to4_0.buff_PI_d32_3.buff_PI_d16$1_0.inv_PI_d8$1_0.VOUT.n9 10.3469
R15707 6to4_0.buff_PI_d32_3.buff_PI_d16$1_0.inv_PI_d8$1_0.VOUT.n16 6to4_0.buff_PI_d32_3.buff_PI_d16$1_0.inv_PI_d8$1_0.VOUT.n14 10.3469
R15708 6to4_0.buff_PI_d32_3.buff_PI_d16$1_0.inv_PI_d8$1_0.VOUT.n4 6to4_0.buff_PI_d32_3.buff_PI_d16$1_0.inv_PI_d8$1_0.VOUT.n2 10.3469
R15709 6to4_0.buff_PI_d32_3.buff_PI_d16$1_0.inv_PI_d8$1_0.VOUT.n33 6to4_0.buff_PI_d32_3.buff_PI_d16$1_0.inv_PI_d8$1_0.VOUT.n32 10.3469
R15710 6to4_0.buff_PI_d32_3.buff_PI_d16$1_0.inv_PI_d8$1_0.VOUT.n11 6to4_0.buff_PI_d32_3.buff_PI_d16$1_0.inv_PI_d8$1_0.VOUT.n10 9.0005
R15711 6to4_0.buff_PI_d32_3.buff_PI_d16$1_0.inv_PI_d8$1_0.VOUT.n13 6to4_0.buff_PI_d32_3.buff_PI_d16$1_0.inv_PI_d8$1_0.VOUT.n12 9.0005
R15712 6to4_0.buff_PI_d32_3.buff_PI_d16$1_0.inv_PI_d8$1_0.VOUT.n6 6to4_0.buff_PI_d32_3.buff_PI_d16$1_0.inv_PI_d8$1_0.VOUT.n5 9.0005
R15713 6to4_0.buff_PI_d32_3.buff_PI_d16$1_0.inv_PI_d8$1_0.VOUT.n16 6to4_0.buff_PI_d32_3.buff_PI_d16$1_0.inv_PI_d8$1_0.VOUT.n15 9.0005
R15714 6to4_0.buff_PI_d32_3.buff_PI_d16$1_0.inv_PI_d8$1_0.VOUT.n8 6to4_0.buff_PI_d32_3.buff_PI_d16$1_0.inv_PI_d8$1_0.VOUT.n7 9.0005
R15715 6to4_0.buff_PI_d32_3.buff_PI_d16$1_0.inv_PI_d8$1_0.VOUT.n1 6to4_0.buff_PI_d32_3.buff_PI_d16$1_0.inv_PI_d8$1_0.VOUT.n0 9.0005
R15716 6to4_0.buff_PI_d32_3.buff_PI_d16$1_0.inv_PI_d8$1_0.VOUT.n20 6to4_0.buff_PI_d32_3.buff_PI_d16$1_0.inv_PI_d8$1_0.VOUT.n19 9.0005
R15717 6to4_0.buff_PI_d32_3.buff_PI_d16$1_0.inv_PI_d8$1_0.VOUT.n22 6to4_0.buff_PI_d32_3.buff_PI_d16$1_0.inv_PI_d8$1_0.VOUT.n21 9.0005
R15718 6to4_0.buff_PI_d32_3.buff_PI_d16$1_0.inv_PI_d8$1_0.VOUT.n4 6to4_0.buff_PI_d32_3.buff_PI_d16$1_0.inv_PI_d8$1_0.VOUT.n3 9.0005
R15719 6to4_0.buff_PI_d32_3.buff_PI_d16$1_0.inv_PI_d8$1_0.VOUT.n26 6to4_0.buff_PI_d32_3.buff_PI_d16$1_0.inv_PI_d8$1_0.VOUT.n25 9.0005
R15720 6to4_0.buff_PI_d32_3.buff_PI_d16$1_0.inv_PI_d8$1_0.VOUT.n28 6to4_0.buff_PI_d32_3.buff_PI_d16$1_0.inv_PI_d8$1_0.VOUT.n27 9.0005
R15721 6to4_0.buff_PI_d32_3.buff_PI_d16$1_0.inv_PI_d8$1_0.VOUT.n32 6to4_0.buff_PI_d32_3.buff_PI_d16$1_0.inv_PI_d8$1_0.VOUT.n31 9.0005
R15722 6to4_0.buff_PI_d32_3.buff_PI_d16$1_0.inv_PI_d8$1_0.VOUT.n34 6to4_0.buff_PI_d32_3.buff_PI_d16$1_0.inv_PI_d16$1_0.inv_PI_d8$1_1.inv_PI_d4$1_1.inv_PI_d2$1_1.inv_PI$1_1.VIN 1.53363
R15723 6to4_0.buff_PI_d32_3.buff_PI_d16$1_0.inv_PI_d8$1_0.VOUT.n52 6to4_0.buff_PI_d32_3.buff_PI_d16$1_0.inv_PI_d8$1_0.VOUT.n51 1.41675
R15724 6to4_0.buff_PI_d32_3.buff_PI_d16$1_0.inv_PI_d8$1_0.VOUT.n46 6to4_0.buff_PI_d32_3.buff_PI_d16$1_0.inv_PI_d8$1_0.VOUT.n45 1.41675
R15725 6to4_0.buff_PI_d32_3.buff_PI_d16$1_0.inv_PI_d8$1_0.VOUT.n40 6to4_0.buff_PI_d32_3.buff_PI_d16$1_0.inv_PI_d8$1_0.VOUT.n39 1.41675
R15726 6to4_0.buff_PI_d32_3.buff_PI_d16$1_0.inv_PI_d8$1_0.VOUT.n13 6to4_0.buff_PI_d32_3.buff_PI_d16$1_0.inv_PI_d8$1_0.VOUT.n6 1.3469
R15727 6to4_0.buff_PI_d32_3.buff_PI_d16$1_0.inv_PI_d8$1_0.VOUT.n8 6to4_0.buff_PI_d32_3.buff_PI_d16$1_0.inv_PI_d8$1_0.VOUT.n1 1.3469
R15728 6to4_0.buff_PI_d32_3.buff_PI_d16$1_0.inv_PI_d8$1_0.VOUT.n22 6to4_0.buff_PI_d32_3.buff_PI_d16$1_0.inv_PI_d8$1_0.VOUT.n20 1.3469
R15729 6to4_0.buff_PI_d32_3.buff_PI_d16$1_0.inv_PI_d8$1_0.VOUT.n28 6to4_0.buff_PI_d32_3.buff_PI_d16$1_0.inv_PI_d8$1_0.VOUT.n26 1.3469
R15730 6to4_0.buff_PI_d32_3.buff_PI_d16$1_0.inv_PI_d8$1_0.VOUT.n18 6to4_0.buff_PI_d32_3.buff_PI_d16$1_0.inv_PI_d8$1_0.VOUT.n17 0.67839
R15731 6to4_0.buff_PI_d32_3.buff_PI_d16$1_0.inv_PI_d8$1_0.VOUT.n24 6to4_0.buff_PI_d32_3.buff_PI_d16$1_0.inv_PI_d8$1_0.VOUT.n23 0.67839
R15732 6to4_0.buff_PI_d32_3.buff_PI_d16$1_0.inv_PI_d8$1_0.VOUT.n55 6to4_0.buff_PI_d32_3.buff_PI_d16$1_0.inv_PI_d8$1_0.VOUT.n54 0.633
R15733 6to4_0.buff_PI_d32_3.buff_PI_d16$1_0.inv_PI_d8$1_0.VOUT.n49 6to4_0.buff_PI_d32_3.buff_PI_d16$1_0.inv_PI_d8$1_0.VOUT.n48 0.633
R15734 6to4_0.buff_PI_d32_3.buff_PI_d16$1_0.inv_PI_d8$1_0.VOUT.n43 6to4_0.buff_PI_d32_3.buff_PI_d16$1_0.inv_PI_d8$1_0.VOUT.n42 0.633
R15735 6to4_0.buff_PI_d32_3.buff_PI_d16$1_0.inv_PI_d8$1_0.VOUT.n37 6to4_0.buff_PI_d32_3.buff_PI_d16$1_0.inv_PI_d8$1_0.VOUT.n36 0.633
R15736 6to4_0.buff_PI_d32_3.buff_PI_d16$1_0.inv_PI_d8$1_0.VOUT.n54 6to4_0.buff_PI_d32_3.buff_PI_d16$1_0.inv_PI_d8$1_0.VOUT.n53 0.392375
R15737 6to4_0.buff_PI_d32_3.buff_PI_d16$1_0.inv_PI_d8$1_0.VOUT.n48 6to4_0.buff_PI_d32_3.buff_PI_d16$1_0.inv_PI_d8$1_0.VOUT.n47 0.392375
R15738 6to4_0.buff_PI_d32_3.buff_PI_d16$1_0.inv_PI_d8$1_0.VOUT.n42 6to4_0.buff_PI_d32_3.buff_PI_d16$1_0.inv_PI_d8$1_0.VOUT.n41 0.392375
R15739 6to4_0.buff_PI_d32_3.buff_PI_d16$1_0.inv_PI_d8$1_0.VOUT.n36 6to4_0.buff_PI_d32_3.buff_PI_d16$1_0.inv_PI_d8$1_0.VOUT.n35 0.392375
R15740 6to4_0.buff_PI_d32_3.buff_PI_d16$1_0.inv_PI_d8$1_0.VOUT.n18 6to4_0.buff_PI_d32_3.buff_PI_d16$1_0.inv_PI_d8$1_0.VOUT.n11 0.3855
R15741 6to4_0.buff_PI_d32_3.buff_PI_d16$1_0.inv_PI_d8$1_0.VOUT.n24 6to4_0.buff_PI_d32_3.buff_PI_d16$1_0.inv_PI_d8$1_0.VOUT.n6 0.3855
R15742 6to4_0.buff_PI_d32_3.buff_PI_d16$1_0.inv_PI_d8$1_0.VOUT.n17 6to4_0.buff_PI_d32_3.buff_PI_d16$1_0.inv_PI_d8$1_0.VOUT.n16 0.3855
R15743 6to4_0.buff_PI_d32_3.buff_PI_d16$1_0.inv_PI_d8$1_0.VOUT.n30 6to4_0.buff_PI_d32_3.buff_PI_d16$1_0.inv_PI_d8$1_0.VOUT.n1 0.3855
R15744 6to4_0.buff_PI_d32_3.buff_PI_d16$1_0.inv_PI_d8$1_0.VOUT.n23 6to4_0.buff_PI_d32_3.buff_PI_d16$1_0.inv_PI_d8$1_0.VOUT.n22 0.3855
R15745 6to4_0.buff_PI_d32_3.buff_PI_d16$1_0.inv_PI_d8$1_0.VOUT.n29 6to4_0.buff_PI_d32_3.buff_PI_d16$1_0.inv_PI_d8$1_0.VOUT.n28 0.3855
R15746 6to4_0.buff_PI_d32_3.buff_PI_d16$1_0.inv_PI_d8$1_0.VOUT.n17 6to4_0.buff_PI_d32_3.buff_PI_d16$1_0.inv_PI_d8$1_0.VOUT.n13 0.3833
R15747 6to4_0.buff_PI_d32_3.buff_PI_d16$1_0.inv_PI_d8$1_0.VOUT.n23 6to4_0.buff_PI_d32_3.buff_PI_d16$1_0.inv_PI_d8$1_0.VOUT.n8 0.3833
R15748 6to4_0.buff_PI_d32_3.buff_PI_d16$1_0.inv_PI_d8$1_0.VOUT.n20 6to4_0.buff_PI_d32_3.buff_PI_d16$1_0.inv_PI_d8$1_0.VOUT.n18 0.3833
R15749 6to4_0.buff_PI_d32_3.buff_PI_d16$1_0.inv_PI_d8$1_0.VOUT.n29 6to4_0.buff_PI_d32_3.buff_PI_d16$1_0.inv_PI_d8$1_0.VOUT.n4 0.3833
R15750 6to4_0.buff_PI_d32_3.buff_PI_d16$1_0.inv_PI_d8$1_0.VOUT.n26 6to4_0.buff_PI_d32_3.buff_PI_d16$1_0.inv_PI_d8$1_0.VOUT.n24 0.3833
R15751 6to4_0.buff_PI_d32_3.buff_PI_d16$1_0.inv_PI_d8$1_0.VOUT.n32 6to4_0.buff_PI_d32_3.buff_PI_d16$1_0.inv_PI_d8$1_0.VOUT.n30 0.3833
R15752 6to4_0.buff_PI_d32_3.buff_PI_d16$1_0.inv_PI_d8$1_0.VOUT.n56 6to4_0.buff_PI_d32_3.buff_PI_d16$1_0.inv_PI_d8$1_0.inv_PI_d4$1_0.inv_PI_d2$1_0.VOUT 0.358
R15753 6to4_0.buff_PI_d32_3.buff_PI_d16$1_0.inv_PI_d8$1_0.VOUT.n50 6to4_0.buff_PI_d32_3.buff_PI_d16$1_0.inv_PI_d8$1_0.inv_PI_d4$1_0.inv_PI_d2$1_1.VOUT 0.358
R15754 6to4_0.buff_PI_d32_3.buff_PI_d16$1_0.inv_PI_d8$1_0.VOUT.n44 6to4_0.buff_PI_d32_3.buff_PI_d16$1_0.inv_PI_d8$1_0.inv_PI_d4$1_1.inv_PI_d2$1_0.VOUT 0.358
R15755 6to4_0.buff_PI_d32_3.buff_PI_d16$1_0.inv_PI_d8$1_0.VOUT.n38 6to4_0.buff_PI_d32_3.buff_PI_d16$1_0.inv_PI_d8$1_0.inv_PI_d4$1_1.inv_PI_d2$1_1.VOUT 0.358
R15756 6to4_0.buff_PI_d32_3.buff_PI_d16$1_0.inv_PI_d8$1_0.inv_PI_d4$1_0.inv_PI_d2$1_0.inv_PI$1_1.VOUT 6to4_0.buff_PI_d32_3.buff_PI_d16$1_0.inv_PI_d8$1_0.VOUT.n52 0.3305
R15757 6to4_0.buff_PI_d32_3.buff_PI_d16$1_0.inv_PI_d8$1_0.VOUT.n51 6to4_0.buff_PI_d32_3.buff_PI_d16$1_0.inv_PI_d8$1_0.inv_PI_d4$1_0.inv_PI_d2$1_1.inv_PI$1_0.VOUT 0.3305
R15758 6to4_0.buff_PI_d32_3.buff_PI_d16$1_0.inv_PI_d8$1_0.inv_PI_d4$1_0.inv_PI_d2$1_1.inv_PI$1_1.VOUT 6to4_0.buff_PI_d32_3.buff_PI_d16$1_0.inv_PI_d8$1_0.VOUT.n46 0.3305
R15759 6to4_0.buff_PI_d32_3.buff_PI_d16$1_0.inv_PI_d8$1_0.inv_PI_d4$1_1.inv_PI_d2$1_0.inv_PI$1_1.VOUT 6to4_0.buff_PI_d32_3.buff_PI_d16$1_0.inv_PI_d8$1_0.VOUT.n40 0.3305
R15760 6to4_0.buff_PI_d32_3.buff_PI_d16$1_0.inv_PI_d8$1_0.VOUT.n39 6to4_0.buff_PI_d32_3.buff_PI_d16$1_0.inv_PI_d8$1_0.inv_PI_d4$1_1.inv_PI_d2$1_1.inv_PI$1_0.VOUT 0.3305
R15761 6to4_0.buff_PI_d32_3.buff_PI_d16$1_0.inv_PI_d8$1_0.inv_PI_d4$1_0.VOUT 6to4_0.buff_PI_d32_3.buff_PI_d16$1_0.inv_PI_d8$1_0.inv_PI_d4$1_0.inv_PI_d2$1_0.inv_PI$1_0.VOUT 0.217062
R15762 6to4_0.buff_PI_d32_3.buff_PI_d16$1_0.inv_PI_d8$1_0.inv_PI_d4$1_1.VOUT 6to4_0.buff_PI_d32_3.buff_PI_d16$1_0.inv_PI_d8$1_0.inv_PI_d4$1_1.inv_PI_d2$1_0.inv_PI$1_0.VOUT 0.217062
R15763 6to4_0.buff_PI_d32_3.buff_PI_d16$1_0.inv_PI_d8$1_0.inv_PI_d4$1_0.VOUT 6to4_0.buff_PI_d32_3.buff_PI_d16$1_0.inv_PI_d8$1_0.VOUT.n34 0.113938
R15764 6to4_0.buff_PI_d32_3.buff_PI_d16$1_0.inv_PI_d8$1_0.VOUT.n45 6to4_0.buff_PI_d32_3.buff_PI_d16$1_0.inv_PI_d8$1_0.inv_PI_d4$1_1.VOUT 0.113938
R15765 6to4_0.buff_PI_d32_3.buff_PI_d16$1_0.inv_PI_d16$1_0.VIN 6to4_0.buff_PI_d32_3.buff_PI_d16$1_0.inv_PI_d8$1_0.VOUT.n29 0.0662582
R15766 6to4_0.buff_PI_d32_3.buff_PI_d16$1_0.inv_PI_d8$1_0.inv_PI_d4$1_0.inv_PI_d2$1_0.inv_PI$1_0.VOUT 6to4_0.buff_PI_d32_3.buff_PI_d16$1_0.inv_PI_d8$1_0.VOUT.n56 0.062375
R15767 6to4_0.buff_PI_d32_3.buff_PI_d16$1_0.inv_PI_d8$1_0.VOUT.n53 6to4_0.buff_PI_d32_3.buff_PI_d16$1_0.inv_PI_d8$1_0.inv_PI_d4$1_0.inv_PI_d2$1_0.inv_PI$1_1.VOUT 0.062375
R15768 6to4_0.buff_PI_d32_3.buff_PI_d16$1_0.inv_PI_d8$1_0.inv_PI_d4$1_0.inv_PI_d2$1_1.inv_PI$1_0.VOUT 6to4_0.buff_PI_d32_3.buff_PI_d16$1_0.inv_PI_d8$1_0.VOUT.n50 0.062375
R15769 6to4_0.buff_PI_d32_3.buff_PI_d16$1_0.inv_PI_d8$1_0.VOUT.n47 6to4_0.buff_PI_d32_3.buff_PI_d16$1_0.inv_PI_d8$1_0.inv_PI_d4$1_0.inv_PI_d2$1_1.inv_PI$1_1.VOUT 0.062375
R15770 6to4_0.buff_PI_d32_3.buff_PI_d16$1_0.inv_PI_d8$1_0.inv_PI_d4$1_1.inv_PI_d2$1_0.inv_PI$1_0.VOUT 6to4_0.buff_PI_d32_3.buff_PI_d16$1_0.inv_PI_d8$1_0.VOUT.n44 0.062375
R15771 6to4_0.buff_PI_d32_3.buff_PI_d16$1_0.inv_PI_d8$1_0.VOUT.n41 6to4_0.buff_PI_d32_3.buff_PI_d16$1_0.inv_PI_d8$1_0.inv_PI_d4$1_1.inv_PI_d2$1_0.inv_PI$1_1.VOUT 0.062375
R15772 6to4_0.buff_PI_d32_3.buff_PI_d16$1_0.inv_PI_d8$1_0.inv_PI_d4$1_1.inv_PI_d2$1_1.inv_PI$1_0.VOUT 6to4_0.buff_PI_d32_3.buff_PI_d16$1_0.inv_PI_d8$1_0.VOUT.n38 0.062375
R15773 6to4_0.buff_PI_d32_3.buff_PI_d16$1_0.inv_PI_d8$1_0.VOUT.n35 6to4_0.buff_PI_d32_3.buff_PI_d16$1_0.inv_PI_d8$1_0.inv_PI_d4$1_1.inv_PI_d2$1_1.inv_PI$1_1.VOUT 0.062375
R15774 6to4_0.buff_PI_d32_3.buff_PI_d16$1_0.inv_PI_d8$1_0.VOUT.n30 6to4_0.buff_PI_d32_3.buff_PI_d16$1_0.inv_PI_d16$1_0.VIN 0.059489
R15775 6to4_0.buff_PI_d32_3.buff_PI_d16$1_0.inv_PI_d8$1_0.VOUT.n31 6to4_0.buff_PI_d32_3.buff_PI_d16$1_0.inv_PI_d16$1_0.inv_PI_d8$1_1.inv_PI_d4$1_1.inv_PI_d2$1_1.inv_PI$1_0.VIN 0.0555
R15776 6to4_0.buff_PI_d32_3.buff_PI_d16$1_0.inv_PI_d8$1_0.VOUT.n25 6to4_0.buff_PI_d32_3.buff_PI_d16$1_0.inv_PI_d16$1_0.inv_PI_d8$1_0.inv_PI_d4$1_1.inv_PI_d2$1_0.inv_PI$1_0.VIN 0.0555
R15777 6to4_0.buff_PI_d32_3.buff_PI_d16$1_0.inv_PI_d8$1_0.VOUT.n19 6to4_0.buff_PI_d32_3.buff_PI_d16$1_0.inv_PI_d16$1_0.inv_PI_d8$1_1.inv_PI_d4$1_0.inv_PI_d2$1_1.inv_PI$1_0.VIN 0.0555
R15778 6to4_0.buff_PI_d32_3.buff_PI_d16$1_0.inv_PI_d8$1_0.VOUT.n9 6to4_0.buff_PI_d32_3.buff_PI_d16$1_0.inv_PI_d16$1_0.inv_PI_d8$1_1.inv_PI_d4$1_0.inv_PI_d2$1_0.inv_PI$1_0.VIN 0.0555
R15779 6to4_0.buff_PI_d32_3.buff_PI_d16$1_0.inv_PI_d8$1_0.VOUT.n14 6to4_0.buff_PI_d32_3.buff_PI_d16$1_0.inv_PI_d16$1_0.inv_PI_d8$1_0.inv_PI_d4$1_0.inv_PI_d2$1_0.inv_PI$1_0.VIN 0.0555
R15780 6to4_0.buff_PI_d32_3.buff_PI_d16$1_0.inv_PI_d8$1_0.VOUT.n12 6to4_0.buff_PI_d32_3.buff_PI_d16$1_0.inv_PI_d16$1_0.inv_PI_d8$1_0.inv_PI_d4$1_0.inv_PI_d2$1_1.inv_PI$1_0.VIN 0.0555
R15781 6to4_0.buff_PI_d32_3.buff_PI_d16$1_0.inv_PI_d8$1_0.VOUT.n7 6to4_0.buff_PI_d32_3.buff_PI_d16$1_0.inv_PI_d16$1_0.inv_PI_d8$1_1.inv_PI_d4$1_1.inv_PI_d2$1_0.inv_PI$1_0.VIN 0.0555
R15782 6to4_0.buff_PI_d32_3.buff_PI_d16$1_0.inv_PI_d8$1_0.VOUT.n3 6to4_0.buff_PI_d32_3.buff_PI_d16$1_0.inv_PI_d16$1_0.inv_PI_d8$1_0.inv_PI_d4$1_1.inv_PI_d2$1_1.inv_PI$1_0.VIN 0.0555
R15783 6to4_0.buff_PI_d32_3.buff_PI_d16$1_0.inv_PI_d16$1_0.inv_PI_d8$1_0.inv_PI_d4$1_1.inv_PI_d2$1_0.VIN 6to4_0.buff_PI_d32_3.buff_PI_d16$1_0.inv_PI_d16$1_0.inv_PI_d8$1_0.inv_PI_d4$1_1.inv_PI_d2$1_0.inv_PI$1_1.VIN 0.0445
R15784 6to4_0.buff_PI_d32_3.buff_PI_d16$1_0.inv_PI_d16$1_0.inv_PI_d8$1_1.inv_PI_d4$1_0.inv_PI_d2$1_0.VIN 6to4_0.buff_PI_d32_3.buff_PI_d16$1_0.inv_PI_d16$1_0.inv_PI_d8$1_1.inv_PI_d4$1_0.inv_PI_d2$1_0.inv_PI$1_1.VIN 0.0445
R15785 6to4_0.buff_PI_d32_3.buff_PI_d16$1_0.inv_PI_d16$1_0.inv_PI_d8$1_0.inv_PI_d4$1_0.inv_PI_d2$1_0.VIN 6to4_0.buff_PI_d32_3.buff_PI_d16$1_0.inv_PI_d16$1_0.inv_PI_d8$1_0.inv_PI_d4$1_0.inv_PI_d2$1_0.inv_PI$1_1.VIN 0.0445
R15786 6to4_0.buff_PI_d32_3.buff_PI_d16$1_0.inv_PI_d16$1_0.inv_PI_d8$1_1.inv_PI_d4$1_1.inv_PI_d2$1_0.VIN 6to4_0.buff_PI_d32_3.buff_PI_d16$1_0.inv_PI_d16$1_0.inv_PI_d8$1_1.inv_PI_d4$1_1.inv_PI_d2$1_0.inv_PI$1_1.VIN 0.0445
R15787 6to4_0.buff_PI_d32_3.buff_PI_d16$1_0.inv_PI_d16$1_0.inv_PI_d8$1_1.inv_PI_d4$1_0.VIN 6to4_0.buff_PI_d32_3.buff_PI_d16$1_0.inv_PI_d16$1_0.inv_PI_d8$1_1.inv_PI_d4$1_0.inv_PI_d2$1_1.inv_PI$1_1.VIN 0.0371667
R15788 6to4_0.buff_PI_d32_3.buff_PI_d16$1_0.inv_PI_d16$1_0.inv_PI_d8$1_0.inv_PI_d4$1_0.VIN 6to4_0.buff_PI_d32_3.buff_PI_d16$1_0.inv_PI_d16$1_0.inv_PI_d8$1_0.inv_PI_d4$1_0.inv_PI_d2$1_1.inv_PI$1_1.VIN 0.0371667
R15789 6to4_0.buff_PI_d32_3.buff_PI_d16$1_0.inv_PI_d16$1_0.inv_PI_d8$1_0.inv_PI_d4$1_1.VIN 6to4_0.buff_PI_d32_3.buff_PI_d16$1_0.inv_PI_d16$1_0.inv_PI_d8$1_0.inv_PI_d4$1_1.inv_PI_d2$1_1.inv_PI$1_1.VIN 0.0371667
R15790 6to4_0.buff_PI_d32_3.buff_PI_d16$1_0.inv_PI_d16$1_0.inv_PI_d8$1_1.inv_PI_d4$1_1.inv_PI_d2$1_1.inv_PI$1_1.VIN 6to4_0.buff_PI_d32_3.buff_PI_d16$1_0.inv_PI_d16$1_0.inv_PI_d8$1_1.inv_PI_d4$1_1.VIN 0.0371667
R15791 6to4_0.buff_PI_d32_3.buff_PI_d16$1_0.inv_PI_d8$1_0.inv_PI_d4$1_0.inv_PI_d2$1_0.VOUT 6to4_0.buff_PI_d32_3.buff_PI_d16$1_0.inv_PI_d8$1_0.VOUT.n55 0.034875
R15792 6to4_0.buff_PI_d32_3.buff_PI_d16$1_0.inv_PI_d8$1_0.inv_PI_d4$1_0.inv_PI_d2$1_1.VOUT 6to4_0.buff_PI_d32_3.buff_PI_d16$1_0.inv_PI_d8$1_0.VOUT.n49 0.034875
R15793 6to4_0.buff_PI_d32_3.buff_PI_d16$1_0.inv_PI_d8$1_0.inv_PI_d4$1_1.inv_PI_d2$1_0.VOUT 6to4_0.buff_PI_d32_3.buff_PI_d16$1_0.inv_PI_d8$1_0.VOUT.n43 0.034875
R15794 6to4_0.buff_PI_d32_3.buff_PI_d16$1_0.inv_PI_d8$1_0.inv_PI_d4$1_1.inv_PI_d2$1_1.VOUT 6to4_0.buff_PI_d32_3.buff_PI_d16$1_0.inv_PI_d8$1_0.VOUT.n37 0.034875
R15795 6to4_0.buff_PI_d32_3.buff_PI_d16$1_0.inv_PI_d8$1_0.VOUT.n27 6to4_0.buff_PI_d32_3.buff_PI_d16$1_0.inv_PI_d16$1_0.inv_PI_d8$1_0.inv_PI_d4$1_1.inv_PI_d2$1_0.VIN 0.0115
R15796 6to4_0.buff_PI_d32_3.buff_PI_d16$1_0.inv_PI_d8$1_0.VOUT.n21 6to4_0.buff_PI_d32_3.buff_PI_d16$1_0.inv_PI_d16$1_0.inv_PI_d8$1_1.inv_PI_d4$1_0.inv_PI_d2$1_1.VIN 0.0115
R15797 6to4_0.buff_PI_d32_3.buff_PI_d16$1_0.inv_PI_d8$1_0.VOUT.n10 6to4_0.buff_PI_d32_3.buff_PI_d16$1_0.inv_PI_d16$1_0.inv_PI_d8$1_1.inv_PI_d4$1_0.inv_PI_d2$1_0.VIN 0.0115
R15798 6to4_0.buff_PI_d32_3.buff_PI_d16$1_0.inv_PI_d8$1_0.VOUT.n15 6to4_0.buff_PI_d32_3.buff_PI_d16$1_0.inv_PI_d16$1_0.inv_PI_d8$1_0.inv_PI_d4$1_0.inv_PI_d2$1_0.VIN 0.0115
R15799 6to4_0.buff_PI_d32_3.buff_PI_d16$1_0.inv_PI_d8$1_0.VOUT.n5 6to4_0.buff_PI_d32_3.buff_PI_d16$1_0.inv_PI_d16$1_0.inv_PI_d8$1_0.inv_PI_d4$1_0.inv_PI_d2$1_1.VIN 0.0115
R15800 6to4_0.buff_PI_d32_3.buff_PI_d16$1_0.inv_PI_d8$1_0.VOUT.n0 6to4_0.buff_PI_d32_3.buff_PI_d16$1_0.inv_PI_d16$1_0.inv_PI_d8$1_1.inv_PI_d4$1_1.inv_PI_d2$1_0.VIN 0.0115
R15801 6to4_0.buff_PI_d32_3.buff_PI_d16$1_0.inv_PI_d8$1_0.VOUT.n2 6to4_0.buff_PI_d32_3.buff_PI_d16$1_0.inv_PI_d16$1_0.inv_PI_d8$1_0.inv_PI_d4$1_1.inv_PI_d2$1_1.VIN 0.0115
R15802 6to4_0.buff_PI_d32_3.buff_PI_d16$1_0.inv_PI_d16$1_0.inv_PI_d8$1_1.inv_PI_d4$1_1.inv_PI_d2$1_1.VIN 6to4_0.buff_PI_d32_3.buff_PI_d16$1_0.inv_PI_d8$1_0.VOUT.n33 0.0115
R15803 6to4_0.buff_PI_d32_3.buff_PI_d16$1_0.inv_PI_d16$1_0.inv_PI_d8$1_1.inv_PI_d4$1_0.inv_PI_d2$1_1.VIN 6to4_0.buff_PI_d32_3.buff_PI_d16$1_0.inv_PI_d16$1_0.inv_PI_d8$1_1.inv_PI_d4$1_0.VIN 0.00783333
R15804 6to4_0.buff_PI_d32_3.buff_PI_d16$1_0.inv_PI_d16$1_0.inv_PI_d8$1_0.inv_PI_d4$1_0.inv_PI_d2$1_1.VIN 6to4_0.buff_PI_d32_3.buff_PI_d16$1_0.inv_PI_d16$1_0.inv_PI_d8$1_0.inv_PI_d4$1_0.VIN 0.00783333
R15805 6to4_0.buff_PI_d32_3.buff_PI_d16$1_0.inv_PI_d16$1_0.inv_PI_d8$1_0.inv_PI_d4$1_1.inv_PI_d2$1_1.VIN 6to4_0.buff_PI_d32_3.buff_PI_d16$1_0.inv_PI_d16$1_0.inv_PI_d8$1_0.inv_PI_d4$1_1.VIN 0.00783333
R15806 6to4_0.buff_PI_d32_3.buff_PI_d16$1_0.inv_PI_d16$1_0.inv_PI_d8$1_1.inv_PI_d4$1_1.VIN 6to4_0.buff_PI_d32_3.buff_PI_d16$1_0.inv_PI_d16$1_0.inv_PI_d8$1_1.inv_PI_d4$1_1.inv_PI_d2$1_1.VIN 0.00783333
R15807 6ph_rosc_0.PH2.n9 6ph_rosc_0.PH2 33.5153
R15808 6ph_rosc_0.PH2 6ph_rosc_0.PH2.t9 17.3649
R15809 6ph_rosc_0.PH2.n2 6ph_rosc_0.PH2.t8 17.0005
R15810 6ph_rosc_0.PH2.n11 6ph_rosc_0.PH2.t0 17.0005
R15811 6ph_rosc_0.PH2.n13 6ph_rosc_0.PH2.t6 17.0005
R15812 6ph_rosc_0.PH2.n14 6ph_rosc_0.PH2.t2 17.0005
R15813 6ph_rosc_0.PH2.n16 6ph_rosc_0.PH2.t4 17.0005
R15814 6ph_rosc_0.PH2.n17 6ph_rosc_0.PH2.t1 17.0005
R15815 6ph_rosc_0.PH2.n19 6ph_rosc_0.PH2.t7 17.0005
R15816 6ph_rosc_0.PH2.n23 6ph_rosc_0.PH2.t5 17.0005
R15817 6ph_rosc_0.PH2.n25 6ph_rosc_0.PH2.t3 17.0005
R15818 6ph_rosc_0.PH2 6ph_rosc_0.PH2.t10 15.0005
R15819 6ph_rosc_0.PH2.n7 6ph_rosc_0.PH2.t11 15.0005
R15820 6ph_rosc_0.PH2.n6 6ph_rosc_0.PH2.t12 15.0005
R15821 6ph_rosc_0.PH2 6ph_rosc_0.PH2.t14 15.0005
R15822 6ph_rosc_0.PH2.n3 6ph_rosc_0.PH2.t13 15.0005
R15823 6ph_rosc_0.PH2.n8 6ph_rosc_0.PH2.n6 10.3469
R15824 6ph_rosc_0.PH2.n4 6ph_rosc_0.PH2.n2 9.9201
R15825 6ph_rosc_0.PH2.n20 6ph_rosc_0.PH2.n19 9.91525
R15826 6ph_rosc_0.PH2.n21 6ph_rosc_0.PH2.n13 9.12325
R15827 6ph_rosc_0.PH2.n20 6ph_rosc_0.PH2.n16 9.12325
R15828 6ph_rosc_0.PH2.n23 6ph_rosc_0.PH2.n22 9.12325
R15829 6ph_rosc_0.PH2.n8 6ph_rosc_0.PH2.n7 9.0005
R15830 6ph_rosc_0.PH2.n4 6ph_rosc_0.PH2.n3 9.0005
R15831 6ph_rosc_0.PH2.n5 6ph_rosc_0.PH2 9.0005
R15832 6ph_rosc_0.PH2.n10 6ph_rosc_0.PH2 9.0005
R15833 6ph_rosc_0.PH2.n22 6ph_rosc_0.PH2.n10 3.2455
R15834 6ph_rosc_0.PH2.n13 6ph_rosc_0.PH2 1.19877
R15835 6ph_rosc_0.PH2.n16 6ph_rosc_0.PH2 1.19877
R15836 6ph_rosc_0.PH2.n19 6ph_rosc_0.PH2 1.19877
R15837 6ph_rosc_0.PH2.n23 6ph_rosc_0.PH2 1.19877
R15838 6ph_rosc_0.PH2.n9 6ph_rosc_0.PH2.n5 1.19719
R15839 6ph_rosc_0.PH2.n10 6ph_rosc_0.PH2.n9 0.806901
R15840 6ph_rosc_0.PH2.n22 6ph_rosc_0.PH2.n21 0.7925
R15841 6ph_rosc_0.PH2.n12 6ph_rosc_0.PH2 0.559983
R15842 6ph_rosc_0.PH2.n15 6ph_rosc_0.PH2 0.559983
R15843 6ph_rosc_0.PH2.n18 6ph_rosc_0.PH2 0.559983
R15844 6ph_rosc_0.PH2.n24 6ph_rosc_0.PH2 0.559983
R15845 6ph_rosc_0.PH2.n5 6ph_rosc_0.PH2.n4 0.4405
R15846 6ph_rosc_0.PH2.n21 6ph_rosc_0.PH2 0.4273
R15847 6ph_rosc_0.PH2 6ph_rosc_0.PH2.n20 0.3657
R15848 6ph_rosc_0.PH2.n1 6ph_rosc_0.PH2 0.3525
R15849 6ph_rosc_0.PH2.n12 6ph_rosc_0.PH2 0.292688
R15850 6ph_rosc_0.PH2.n15 6ph_rosc_0.PH2 0.292688
R15851 6ph_rosc_0.PH2.n18 6ph_rosc_0.PH2 0.292688
R15852 6ph_rosc_0.PH2 6ph_rosc_0.PH2.n24 0.292688
R15853 6ph_rosc_0.PH2 6ph_rosc_0.PH2.n11 0.282375
R15854 6ph_rosc_0.PH2 6ph_rosc_0.PH2.n14 0.282375
R15855 6ph_rosc_0.PH2 6ph_rosc_0.PH2.n17 0.282375
R15856 6ph_rosc_0.PH2.n25 6ph_rosc_0.PH2 0.282375
R15857 6ph_rosc_0.PH2.n0 6ph_rosc_0.PH2 0.210188
R15858 6ph_rosc_0.PH2.n0 6ph_rosc_0.PH2 0.162063
R15859 6ph_rosc_0.PH2.n11 6ph_rosc_0.PH2 0.089875
R15860 6ph_rosc_0.PH2.n14 6ph_rosc_0.PH2 0.089875
R15861 6ph_rosc_0.PH2.n17 6ph_rosc_0.PH2 0.089875
R15862 6ph_rosc_0.PH2 6ph_rosc_0.PH2.n25 0.089875
R15863 6ph_rosc_0.PH2 6ph_rosc_0.PH2.n8 0.0643
R15864 6ph_rosc_0.PH2.n6 6ph_rosc_0.PH2 0.0555
R15865 6ph_rosc_0.PH2.n3 6ph_rosc_0.PH2 0.0555
R15866 6ph_rosc_0.PH2.n2 6ph_rosc_0.PH2.n0 0.0403276
R15867 6ph_rosc_0.PH2.n2 6ph_rosc_0.PH2.n1 0.0403276
R15868 6ph_rosc_0.PH2.n13 6ph_rosc_0.PH2.n12 0.0403276
R15869 6ph_rosc_0.PH2.n16 6ph_rosc_0.PH2.n15 0.0403276
R15870 6ph_rosc_0.PH2.n19 6ph_rosc_0.PH2.n18 0.0403276
R15871 6ph_rosc_0.PH2.n24 6ph_rosc_0.PH2.n23 0.0403276
R15872 6ph_rosc_0.PH2.n7 6ph_rosc_0.PH2 0.0115
R15873 6ph_rosc_0.PH2.n3 6ph_rosc_0.PH2 0.0115
R15874 6ph_rosc_0.PH2.n1 6ph_rosc_0.PH2 0.00998276
R15875 6ph_rosc_0.PH5.n12 6ph_rosc_0.PH5 32.0082
R15876 6ph_rosc_0.PH5.n15 6ph_rosc_0.PH5.n14 25.5168
R15877 6ph_rosc_0.PH5.n0 6ph_rosc_0.PH5.t1 17.0005
R15878 6ph_rosc_0.PH5.n2 6ph_rosc_0.PH5.t7 17.0005
R15879 6ph_rosc_0.PH5.n3 6ph_rosc_0.PH5.t8 17.0005
R15880 6ph_rosc_0.PH5.n5 6ph_rosc_0.PH5.t9 17.0005
R15881 6ph_rosc_0.PH5.n19 6ph_rosc_0.PH5.t0 17.0005
R15882 6ph_rosc_0.PH5.n21 6ph_rosc_0.PH5.t6 17.0005
R15883 6ph_rosc_0.PH5.n16 6ph_rosc_0.PH5.t2 17.0005
R15884 6ph_rosc_0.PH5.n18 6ph_rosc_0.PH5.t4 17.0005
R15885 6ph_rosc_0.PH5.n24 6ph_rosc_0.PH5.t5 17.0005
R15886 6ph_rosc_0.PH5.n26 6ph_rosc_0.PH5.t3 17.0005
R15887 6ph_rosc_0.PH5.n13 6ph_rosc_0.PH5.t12 15.0005
R15888 6ph_rosc_0.PH5.n10 6ph_rosc_0.PH5.t11 15.0005
R15889 6ph_rosc_0.PH5.n9 6ph_rosc_0.PH5.t10 15.0005
R15890 6ph_rosc_0.PH5.n6 6ph_rosc_0.PH5.t14 15.0005
R15891 6ph_rosc_0.PH5 6ph_rosc_0.PH5.t13 15.0005
R15892 6ph_rosc_0.PH5.n11 6ph_rosc_0.PH5.n9 10.3469
R15893 6ph_rosc_0.PH5.n7 6ph_rosc_0.PH5.n5 9.9157
R15894 6ph_rosc_0.PH5.n22 6ph_rosc_0.PH5.n21 9.91525
R15895 6ph_rosc_0.PH5.n15 6ph_rosc_0.PH5.n2 9.12325
R15896 6ph_rosc_0.PH5.n22 6ph_rosc_0.PH5.n18 9.12325
R15897 6ph_rosc_0.PH5.n24 6ph_rosc_0.PH5.n23 9.12325
R15898 6ph_rosc_0.PH5.n11 6ph_rosc_0.PH5.n10 9.0005
R15899 6ph_rosc_0.PH5.n8 6ph_rosc_0.PH5 9.0005
R15900 6ph_rosc_0.PH5.n7 6ph_rosc_0.PH5.n6 9.0005
R15901 6ph_rosc_0.PH5.n14 6ph_rosc_0.PH5.n13 9.0005
R15902 6ph_rosc_0.PH5.n2 6ph_rosc_0.PH5 1.19877
R15903 6ph_rosc_0.PH5.n5 6ph_rosc_0.PH5 1.19877
R15904 6ph_rosc_0.PH5.n21 6ph_rosc_0.PH5 1.19877
R15905 6ph_rosc_0.PH5.n18 6ph_rosc_0.PH5 1.19877
R15906 6ph_rosc_0.PH5.n24 6ph_rosc_0.PH5 1.19877
R15907 6ph_rosc_0.PH5.n12 6ph_rosc_0.PH5.n8 1.19719
R15908 6ph_rosc_0.PH5.n14 6ph_rosc_0.PH5.n12 0.806901
R15909 6ph_rosc_0.PH5.n23 6ph_rosc_0.PH5.n15 0.771233
R15910 6ph_rosc_0.PH5.n1 6ph_rosc_0.PH5 0.559983
R15911 6ph_rosc_0.PH5.n4 6ph_rosc_0.PH5 0.559983
R15912 6ph_rosc_0.PH5.n20 6ph_rosc_0.PH5 0.559983
R15913 6ph_rosc_0.PH5.n17 6ph_rosc_0.PH5 0.559983
R15914 6ph_rosc_0.PH5.n25 6ph_rosc_0.PH5 0.559983
R15915 6ph_rosc_0.PH5.n8 6ph_rosc_0.PH5.n7 0.4405
R15916 6ph_rosc_0.PH5.n23 6ph_rosc_0.PH5 0.4273
R15917 6ph_rosc_0.PH5 6ph_rosc_0.PH5.n22 0.3657
R15918 6ph_rosc_0.PH5.n1 6ph_rosc_0.PH5 0.292688
R15919 6ph_rosc_0.PH5.n4 6ph_rosc_0.PH5 0.292688
R15920 6ph_rosc_0.PH5.n20 6ph_rosc_0.PH5 0.292688
R15921 6ph_rosc_0.PH5.n17 6ph_rosc_0.PH5 0.292688
R15922 6ph_rosc_0.PH5 6ph_rosc_0.PH5.n25 0.292688
R15923 6ph_rosc_0.PH5 6ph_rosc_0.PH5.n0 0.282375
R15924 6ph_rosc_0.PH5 6ph_rosc_0.PH5.n3 0.282375
R15925 6ph_rosc_0.PH5 6ph_rosc_0.PH5.n19 0.282375
R15926 6ph_rosc_0.PH5 6ph_rosc_0.PH5.n16 0.282375
R15927 6ph_rosc_0.PH5.n26 6ph_rosc_0.PH5 0.282375
R15928 6ph_rosc_0.PH5.n0 6ph_rosc_0.PH5 0.089875
R15929 6ph_rosc_0.PH5.n3 6ph_rosc_0.PH5 0.089875
R15930 6ph_rosc_0.PH5.n19 6ph_rosc_0.PH5 0.089875
R15931 6ph_rosc_0.PH5.n16 6ph_rosc_0.PH5 0.089875
R15932 6ph_rosc_0.PH5 6ph_rosc_0.PH5.n26 0.089875
R15933 6ph_rosc_0.PH5 6ph_rosc_0.PH5.n11 0.0643
R15934 6ph_rosc_0.PH5.n9 6ph_rosc_0.PH5 0.0555
R15935 6ph_rosc_0.PH5.n2 6ph_rosc_0.PH5.n1 0.0403276
R15936 6ph_rosc_0.PH5.n5 6ph_rosc_0.PH5.n4 0.0403276
R15937 6ph_rosc_0.PH5.n21 6ph_rosc_0.PH5.n20 0.0403276
R15938 6ph_rosc_0.PH5.n18 6ph_rosc_0.PH5.n17 0.0403276
R15939 6ph_rosc_0.PH5.n25 6ph_rosc_0.PH5.n24 0.0403276
R15940 6ph_rosc_0.PH5.n13 6ph_rosc_0.PH5 0.017
R15941 6ph_rosc_0.PH5.n6 6ph_rosc_0.PH5 0.0151667
R15942 6ph_rosc_0.PH5.n10 6ph_rosc_0.PH5 0.0115
R15943 6to4_0.buff_PI_d32_0.buff_PI_d16$1_0.inv_PI_d8$1_0.VOUT.n35 6to4_0.buff_PI_d32_0.buff_PI_d16$1_0.inv_PI_d8$1_0.VOUT.t3 17.6089
R15944 6to4_0.buff_PI_d32_0.buff_PI_d16$1_0.inv_PI_d8$1_0.VOUT.n38 6to4_0.buff_PI_d32_0.buff_PI_d16$1_0.inv_PI_d8$1_0.VOUT.t6 17.6089
R15945 6to4_0.buff_PI_d32_0.buff_PI_d16$1_0.inv_PI_d8$1_0.VOUT.n41 6to4_0.buff_PI_d32_0.buff_PI_d16$1_0.inv_PI_d8$1_0.VOUT.t15 17.6089
R15946 6to4_0.buff_PI_d32_0.buff_PI_d16$1_0.inv_PI_d8$1_0.VOUT.n44 6to4_0.buff_PI_d32_0.buff_PI_d16$1_0.inv_PI_d8$1_0.VOUT.t9 17.6089
R15947 6to4_0.buff_PI_d32_0.buff_PI_d16$1_0.inv_PI_d8$1_0.VOUT.n47 6to4_0.buff_PI_d32_0.buff_PI_d16$1_0.inv_PI_d8$1_0.VOUT.t21 17.6089
R15948 6to4_0.buff_PI_d32_0.buff_PI_d16$1_0.inv_PI_d8$1_0.VOUT.n50 6to4_0.buff_PI_d32_0.buff_PI_d16$1_0.inv_PI_d8$1_0.VOUT.t12 17.6089
R15949 6to4_0.buff_PI_d32_0.buff_PI_d16$1_0.inv_PI_d8$1_0.VOUT.n56 6to4_0.buff_PI_d32_0.buff_PI_d16$1_0.inv_PI_d8$1_0.VOUT.t18 17.6089
R15950 6to4_0.buff_PI_d32_0.buff_PI_d16$1_0.inv_PI_d8$1_0.VOUT.n53 6to4_0.buff_PI_d32_0.buff_PI_d16$1_0.inv_PI_d8$1_0.VOUT.t0 17.6089
R15951 6to4_0.buff_PI_d32_0.buff_PI_d16$1_0.inv_PI_d8$1_0.inv_PI_d4$1_1.inv_PI_d2$1_1.inv_PI$1_1.VOUT 6to4_0.buff_PI_d32_0.buff_PI_d16$1_0.inv_PI_d8$1_0.VOUT.t5 17.5436
R15952 6to4_0.buff_PI_d32_0.buff_PI_d16$1_0.inv_PI_d8$1_0.VOUT.n34 6to4_0.buff_PI_d32_0.buff_PI_d16$1_0.inv_PI_d8$1_0.VOUT.t20 17.2136
R15953 6to4_0.buff_PI_d32_0.buff_PI_d16$1_0.inv_PI_d8$1_0.VOUT.n55 6to4_0.buff_PI_d32_0.buff_PI_d16$1_0.inv_PI_d8$1_0.VOUT.t19 17.2136
R15954 6to4_0.buff_PI_d32_0.buff_PI_d16$1_0.inv_PI_d8$1_0.VOUT.n54 6to4_0.buff_PI_d32_0.buff_PI_d16$1_0.inv_PI_d8$1_0.VOUT.t2 17.2136
R15955 6to4_0.buff_PI_d32_0.buff_PI_d16$1_0.inv_PI_d8$1_0.VOUT.n52 6to4_0.buff_PI_d32_0.buff_PI_d16$1_0.inv_PI_d8$1_0.VOUT.t1 17.2136
R15956 6to4_0.buff_PI_d32_0.buff_PI_d16$1_0.inv_PI_d8$1_0.VOUT.n51 6to4_0.buff_PI_d32_0.buff_PI_d16$1_0.inv_PI_d8$1_0.VOUT.t14 17.2136
R15957 6to4_0.buff_PI_d32_0.buff_PI_d16$1_0.inv_PI_d8$1_0.VOUT.n49 6to4_0.buff_PI_d32_0.buff_PI_d16$1_0.inv_PI_d8$1_0.VOUT.t13 17.2136
R15958 6to4_0.buff_PI_d32_0.buff_PI_d16$1_0.inv_PI_d8$1_0.VOUT.n48 6to4_0.buff_PI_d32_0.buff_PI_d16$1_0.inv_PI_d8$1_0.VOUT.t23 17.2136
R15959 6to4_0.buff_PI_d32_0.buff_PI_d16$1_0.inv_PI_d8$1_0.VOUT.n46 6to4_0.buff_PI_d32_0.buff_PI_d16$1_0.inv_PI_d8$1_0.VOUT.t22 17.2136
R15960 6to4_0.buff_PI_d32_0.buff_PI_d16$1_0.inv_PI_d8$1_0.VOUT.n45 6to4_0.buff_PI_d32_0.buff_PI_d16$1_0.inv_PI_d8$1_0.VOUT.t10 17.2136
R15961 6to4_0.buff_PI_d32_0.buff_PI_d16$1_0.inv_PI_d8$1_0.VOUT.n43 6to4_0.buff_PI_d32_0.buff_PI_d16$1_0.inv_PI_d8$1_0.VOUT.t11 17.2136
R15962 6to4_0.buff_PI_d32_0.buff_PI_d16$1_0.inv_PI_d8$1_0.VOUT.n42 6to4_0.buff_PI_d32_0.buff_PI_d16$1_0.inv_PI_d8$1_0.VOUT.t16 17.2136
R15963 6to4_0.buff_PI_d32_0.buff_PI_d16$1_0.inv_PI_d8$1_0.VOUT.n40 6to4_0.buff_PI_d32_0.buff_PI_d16$1_0.inv_PI_d8$1_0.VOUT.t17 17.2136
R15964 6to4_0.buff_PI_d32_0.buff_PI_d16$1_0.inv_PI_d8$1_0.VOUT.n39 6to4_0.buff_PI_d32_0.buff_PI_d16$1_0.inv_PI_d8$1_0.VOUT.t7 17.2136
R15965 6to4_0.buff_PI_d32_0.buff_PI_d16$1_0.inv_PI_d8$1_0.VOUT.n37 6to4_0.buff_PI_d32_0.buff_PI_d16$1_0.inv_PI_d8$1_0.VOUT.t8 17.2136
R15966 6to4_0.buff_PI_d32_0.buff_PI_d16$1_0.inv_PI_d8$1_0.VOUT.n36 6to4_0.buff_PI_d32_0.buff_PI_d16$1_0.inv_PI_d8$1_0.VOUT.t4 17.2136
R15967 6to4_0.buff_PI_d32_0.buff_PI_d16$1_0.inv_PI_d8$1_0.VOUT.n31 6to4_0.buff_PI_d32_0.buff_PI_d16$1_0.inv_PI_d8$1_0.VOUT.t34 15.0005
R15968 6to4_0.buff_PI_d32_0.buff_PI_d16$1_0.inv_PI_d8$1_0.VOUT.n27 6to4_0.buff_PI_d32_0.buff_PI_d16$1_0.inv_PI_d8$1_0.VOUT.t24 15.0005
R15969 6to4_0.buff_PI_d32_0.buff_PI_d16$1_0.inv_PI_d8$1_0.VOUT.n25 6to4_0.buff_PI_d32_0.buff_PI_d16$1_0.inv_PI_d8$1_0.VOUT.t33 15.0005
R15970 6to4_0.buff_PI_d32_0.buff_PI_d16$1_0.inv_PI_d8$1_0.VOUT.n21 6to4_0.buff_PI_d32_0.buff_PI_d16$1_0.inv_PI_d8$1_0.VOUT.t26 15.0005
R15971 6to4_0.buff_PI_d32_0.buff_PI_d16$1_0.inv_PI_d8$1_0.VOUT.n19 6to4_0.buff_PI_d32_0.buff_PI_d16$1_0.inv_PI_d8$1_0.VOUT.t38 15.0005
R15972 6to4_0.buff_PI_d32_0.buff_PI_d16$1_0.inv_PI_d8$1_0.VOUT.n10 6to4_0.buff_PI_d32_0.buff_PI_d16$1_0.inv_PI_d8$1_0.VOUT.t31 15.0005
R15973 6to4_0.buff_PI_d32_0.buff_PI_d16$1_0.inv_PI_d8$1_0.VOUT.n9 6to4_0.buff_PI_d32_0.buff_PI_d16$1_0.inv_PI_d8$1_0.VOUT.t27 15.0005
R15974 6to4_0.buff_PI_d32_0.buff_PI_d16$1_0.inv_PI_d8$1_0.VOUT.n15 6to4_0.buff_PI_d32_0.buff_PI_d16$1_0.inv_PI_d8$1_0.VOUT.t30 15.0005
R15975 6to4_0.buff_PI_d32_0.buff_PI_d16$1_0.inv_PI_d8$1_0.VOUT.n14 6to4_0.buff_PI_d32_0.buff_PI_d16$1_0.inv_PI_d8$1_0.VOUT.t37 15.0005
R15976 6to4_0.buff_PI_d32_0.buff_PI_d16$1_0.inv_PI_d8$1_0.VOUT.n5 6to4_0.buff_PI_d32_0.buff_PI_d16$1_0.inv_PI_d8$1_0.VOUT.t35 15.0005
R15977 6to4_0.buff_PI_d32_0.buff_PI_d16$1_0.inv_PI_d8$1_0.VOUT.n12 6to4_0.buff_PI_d32_0.buff_PI_d16$1_0.inv_PI_d8$1_0.VOUT.t28 15.0005
R15978 6to4_0.buff_PI_d32_0.buff_PI_d16$1_0.inv_PI_d8$1_0.VOUT.n0 6to4_0.buff_PI_d32_0.buff_PI_d16$1_0.inv_PI_d8$1_0.VOUT.t36 15.0005
R15979 6to4_0.buff_PI_d32_0.buff_PI_d16$1_0.inv_PI_d8$1_0.VOUT.n7 6to4_0.buff_PI_d32_0.buff_PI_d16$1_0.inv_PI_d8$1_0.VOUT.t29 15.0005
R15980 6to4_0.buff_PI_d32_0.buff_PI_d16$1_0.inv_PI_d8$1_0.VOUT.n2 6to4_0.buff_PI_d32_0.buff_PI_d16$1_0.inv_PI_d8$1_0.VOUT.t39 15.0005
R15981 6to4_0.buff_PI_d32_0.buff_PI_d16$1_0.inv_PI_d8$1_0.VOUT.n3 6to4_0.buff_PI_d32_0.buff_PI_d16$1_0.inv_PI_d8$1_0.VOUT.t32 15.0005
R15982 6to4_0.buff_PI_d32_0.buff_PI_d16$1_0.inv_PI_d8$1_0.VOUT.n33 6to4_0.buff_PI_d32_0.buff_PI_d16$1_0.inv_PI_d8$1_0.VOUT.t25 15.0005
R15983 6to4_0.buff_PI_d32_0.buff_PI_d16$1_0.inv_PI_d8$1_0.VOUT.n11 6to4_0.buff_PI_d32_0.buff_PI_d16$1_0.inv_PI_d8$1_0.VOUT.n9 10.3469
R15984 6to4_0.buff_PI_d32_0.buff_PI_d16$1_0.inv_PI_d8$1_0.VOUT.n16 6to4_0.buff_PI_d32_0.buff_PI_d16$1_0.inv_PI_d8$1_0.VOUT.n14 10.3469
R15985 6to4_0.buff_PI_d32_0.buff_PI_d16$1_0.inv_PI_d8$1_0.VOUT.n4 6to4_0.buff_PI_d32_0.buff_PI_d16$1_0.inv_PI_d8$1_0.VOUT.n2 10.3469
R15986 6to4_0.buff_PI_d32_0.buff_PI_d16$1_0.inv_PI_d8$1_0.VOUT.n33 6to4_0.buff_PI_d32_0.buff_PI_d16$1_0.inv_PI_d8$1_0.VOUT.n32 10.3469
R15987 6to4_0.buff_PI_d32_0.buff_PI_d16$1_0.inv_PI_d8$1_0.VOUT.n11 6to4_0.buff_PI_d32_0.buff_PI_d16$1_0.inv_PI_d8$1_0.VOUT.n10 9.0005
R15988 6to4_0.buff_PI_d32_0.buff_PI_d16$1_0.inv_PI_d8$1_0.VOUT.n13 6to4_0.buff_PI_d32_0.buff_PI_d16$1_0.inv_PI_d8$1_0.VOUT.n12 9.0005
R15989 6to4_0.buff_PI_d32_0.buff_PI_d16$1_0.inv_PI_d8$1_0.VOUT.n6 6to4_0.buff_PI_d32_0.buff_PI_d16$1_0.inv_PI_d8$1_0.VOUT.n5 9.0005
R15990 6to4_0.buff_PI_d32_0.buff_PI_d16$1_0.inv_PI_d8$1_0.VOUT.n16 6to4_0.buff_PI_d32_0.buff_PI_d16$1_0.inv_PI_d8$1_0.VOUT.n15 9.0005
R15991 6to4_0.buff_PI_d32_0.buff_PI_d16$1_0.inv_PI_d8$1_0.VOUT.n8 6to4_0.buff_PI_d32_0.buff_PI_d16$1_0.inv_PI_d8$1_0.VOUT.n7 9.0005
R15992 6to4_0.buff_PI_d32_0.buff_PI_d16$1_0.inv_PI_d8$1_0.VOUT.n1 6to4_0.buff_PI_d32_0.buff_PI_d16$1_0.inv_PI_d8$1_0.VOUT.n0 9.0005
R15993 6to4_0.buff_PI_d32_0.buff_PI_d16$1_0.inv_PI_d8$1_0.VOUT.n20 6to4_0.buff_PI_d32_0.buff_PI_d16$1_0.inv_PI_d8$1_0.VOUT.n19 9.0005
R15994 6to4_0.buff_PI_d32_0.buff_PI_d16$1_0.inv_PI_d8$1_0.VOUT.n22 6to4_0.buff_PI_d32_0.buff_PI_d16$1_0.inv_PI_d8$1_0.VOUT.n21 9.0005
R15995 6to4_0.buff_PI_d32_0.buff_PI_d16$1_0.inv_PI_d8$1_0.VOUT.n4 6to4_0.buff_PI_d32_0.buff_PI_d16$1_0.inv_PI_d8$1_0.VOUT.n3 9.0005
R15996 6to4_0.buff_PI_d32_0.buff_PI_d16$1_0.inv_PI_d8$1_0.VOUT.n26 6to4_0.buff_PI_d32_0.buff_PI_d16$1_0.inv_PI_d8$1_0.VOUT.n25 9.0005
R15997 6to4_0.buff_PI_d32_0.buff_PI_d16$1_0.inv_PI_d8$1_0.VOUT.n28 6to4_0.buff_PI_d32_0.buff_PI_d16$1_0.inv_PI_d8$1_0.VOUT.n27 9.0005
R15998 6to4_0.buff_PI_d32_0.buff_PI_d16$1_0.inv_PI_d8$1_0.VOUT.n32 6to4_0.buff_PI_d32_0.buff_PI_d16$1_0.inv_PI_d8$1_0.VOUT.n31 9.0005
R15999 6to4_0.buff_PI_d32_0.buff_PI_d16$1_0.inv_PI_d8$1_0.VOUT.n34 6to4_0.buff_PI_d32_0.buff_PI_d16$1_0.inv_PI_d16$1_0.inv_PI_d8$1_1.inv_PI_d4$1_1.inv_PI_d2$1_1.inv_PI$1_1.VIN 1.53363
R16000 6to4_0.buff_PI_d32_0.buff_PI_d16$1_0.inv_PI_d8$1_0.VOUT.n52 6to4_0.buff_PI_d32_0.buff_PI_d16$1_0.inv_PI_d8$1_0.VOUT.n51 1.41675
R16001 6to4_0.buff_PI_d32_0.buff_PI_d16$1_0.inv_PI_d8$1_0.VOUT.n46 6to4_0.buff_PI_d32_0.buff_PI_d16$1_0.inv_PI_d8$1_0.VOUT.n45 1.41675
R16002 6to4_0.buff_PI_d32_0.buff_PI_d16$1_0.inv_PI_d8$1_0.VOUT.n40 6to4_0.buff_PI_d32_0.buff_PI_d16$1_0.inv_PI_d8$1_0.VOUT.n39 1.41675
R16003 6to4_0.buff_PI_d32_0.buff_PI_d16$1_0.inv_PI_d8$1_0.VOUT.n13 6to4_0.buff_PI_d32_0.buff_PI_d16$1_0.inv_PI_d8$1_0.VOUT.n6 1.3469
R16004 6to4_0.buff_PI_d32_0.buff_PI_d16$1_0.inv_PI_d8$1_0.VOUT.n8 6to4_0.buff_PI_d32_0.buff_PI_d16$1_0.inv_PI_d8$1_0.VOUT.n1 1.3469
R16005 6to4_0.buff_PI_d32_0.buff_PI_d16$1_0.inv_PI_d8$1_0.VOUT.n22 6to4_0.buff_PI_d32_0.buff_PI_d16$1_0.inv_PI_d8$1_0.VOUT.n20 1.3469
R16006 6to4_0.buff_PI_d32_0.buff_PI_d16$1_0.inv_PI_d8$1_0.VOUT.n28 6to4_0.buff_PI_d32_0.buff_PI_d16$1_0.inv_PI_d8$1_0.VOUT.n26 1.3469
R16007 6to4_0.buff_PI_d32_0.buff_PI_d16$1_0.inv_PI_d8$1_0.VOUT.n18 6to4_0.buff_PI_d32_0.buff_PI_d16$1_0.inv_PI_d8$1_0.VOUT.n17 0.67839
R16008 6to4_0.buff_PI_d32_0.buff_PI_d16$1_0.inv_PI_d8$1_0.VOUT.n24 6to4_0.buff_PI_d32_0.buff_PI_d16$1_0.inv_PI_d8$1_0.VOUT.n23 0.67839
R16009 6to4_0.buff_PI_d32_0.buff_PI_d16$1_0.inv_PI_d8$1_0.VOUT.n55 6to4_0.buff_PI_d32_0.buff_PI_d16$1_0.inv_PI_d8$1_0.VOUT.n54 0.633
R16010 6to4_0.buff_PI_d32_0.buff_PI_d16$1_0.inv_PI_d8$1_0.VOUT.n49 6to4_0.buff_PI_d32_0.buff_PI_d16$1_0.inv_PI_d8$1_0.VOUT.n48 0.633
R16011 6to4_0.buff_PI_d32_0.buff_PI_d16$1_0.inv_PI_d8$1_0.VOUT.n43 6to4_0.buff_PI_d32_0.buff_PI_d16$1_0.inv_PI_d8$1_0.VOUT.n42 0.633
R16012 6to4_0.buff_PI_d32_0.buff_PI_d16$1_0.inv_PI_d8$1_0.VOUT.n37 6to4_0.buff_PI_d32_0.buff_PI_d16$1_0.inv_PI_d8$1_0.VOUT.n36 0.633
R16013 6to4_0.buff_PI_d32_0.buff_PI_d16$1_0.inv_PI_d8$1_0.VOUT.n54 6to4_0.buff_PI_d32_0.buff_PI_d16$1_0.inv_PI_d8$1_0.VOUT.n53 0.392375
R16014 6to4_0.buff_PI_d32_0.buff_PI_d16$1_0.inv_PI_d8$1_0.VOUT.n48 6to4_0.buff_PI_d32_0.buff_PI_d16$1_0.inv_PI_d8$1_0.VOUT.n47 0.392375
R16015 6to4_0.buff_PI_d32_0.buff_PI_d16$1_0.inv_PI_d8$1_0.VOUT.n42 6to4_0.buff_PI_d32_0.buff_PI_d16$1_0.inv_PI_d8$1_0.VOUT.n41 0.392375
R16016 6to4_0.buff_PI_d32_0.buff_PI_d16$1_0.inv_PI_d8$1_0.VOUT.n36 6to4_0.buff_PI_d32_0.buff_PI_d16$1_0.inv_PI_d8$1_0.VOUT.n35 0.392375
R16017 6to4_0.buff_PI_d32_0.buff_PI_d16$1_0.inv_PI_d8$1_0.VOUT.n18 6to4_0.buff_PI_d32_0.buff_PI_d16$1_0.inv_PI_d8$1_0.VOUT.n11 0.3855
R16018 6to4_0.buff_PI_d32_0.buff_PI_d16$1_0.inv_PI_d8$1_0.VOUT.n24 6to4_0.buff_PI_d32_0.buff_PI_d16$1_0.inv_PI_d8$1_0.VOUT.n6 0.3855
R16019 6to4_0.buff_PI_d32_0.buff_PI_d16$1_0.inv_PI_d8$1_0.VOUT.n17 6to4_0.buff_PI_d32_0.buff_PI_d16$1_0.inv_PI_d8$1_0.VOUT.n16 0.3855
R16020 6to4_0.buff_PI_d32_0.buff_PI_d16$1_0.inv_PI_d8$1_0.VOUT.n30 6to4_0.buff_PI_d32_0.buff_PI_d16$1_0.inv_PI_d8$1_0.VOUT.n1 0.3855
R16021 6to4_0.buff_PI_d32_0.buff_PI_d16$1_0.inv_PI_d8$1_0.VOUT.n23 6to4_0.buff_PI_d32_0.buff_PI_d16$1_0.inv_PI_d8$1_0.VOUT.n22 0.3855
R16022 6to4_0.buff_PI_d32_0.buff_PI_d16$1_0.inv_PI_d8$1_0.VOUT.n29 6to4_0.buff_PI_d32_0.buff_PI_d16$1_0.inv_PI_d8$1_0.VOUT.n28 0.3855
R16023 6to4_0.buff_PI_d32_0.buff_PI_d16$1_0.inv_PI_d8$1_0.VOUT.n17 6to4_0.buff_PI_d32_0.buff_PI_d16$1_0.inv_PI_d8$1_0.VOUT.n13 0.3833
R16024 6to4_0.buff_PI_d32_0.buff_PI_d16$1_0.inv_PI_d8$1_0.VOUT.n23 6to4_0.buff_PI_d32_0.buff_PI_d16$1_0.inv_PI_d8$1_0.VOUT.n8 0.3833
R16025 6to4_0.buff_PI_d32_0.buff_PI_d16$1_0.inv_PI_d8$1_0.VOUT.n20 6to4_0.buff_PI_d32_0.buff_PI_d16$1_0.inv_PI_d8$1_0.VOUT.n18 0.3833
R16026 6to4_0.buff_PI_d32_0.buff_PI_d16$1_0.inv_PI_d8$1_0.VOUT.n29 6to4_0.buff_PI_d32_0.buff_PI_d16$1_0.inv_PI_d8$1_0.VOUT.n4 0.3833
R16027 6to4_0.buff_PI_d32_0.buff_PI_d16$1_0.inv_PI_d8$1_0.VOUT.n26 6to4_0.buff_PI_d32_0.buff_PI_d16$1_0.inv_PI_d8$1_0.VOUT.n24 0.3833
R16028 6to4_0.buff_PI_d32_0.buff_PI_d16$1_0.inv_PI_d8$1_0.VOUT.n32 6to4_0.buff_PI_d32_0.buff_PI_d16$1_0.inv_PI_d8$1_0.VOUT.n30 0.3833
R16029 6to4_0.buff_PI_d32_0.buff_PI_d16$1_0.inv_PI_d8$1_0.VOUT.n56 6to4_0.buff_PI_d32_0.buff_PI_d16$1_0.inv_PI_d8$1_0.inv_PI_d4$1_0.inv_PI_d2$1_0.VOUT 0.358
R16030 6to4_0.buff_PI_d32_0.buff_PI_d16$1_0.inv_PI_d8$1_0.VOUT.n50 6to4_0.buff_PI_d32_0.buff_PI_d16$1_0.inv_PI_d8$1_0.inv_PI_d4$1_0.inv_PI_d2$1_1.VOUT 0.358
R16031 6to4_0.buff_PI_d32_0.buff_PI_d16$1_0.inv_PI_d8$1_0.VOUT.n44 6to4_0.buff_PI_d32_0.buff_PI_d16$1_0.inv_PI_d8$1_0.inv_PI_d4$1_1.inv_PI_d2$1_0.VOUT 0.358
R16032 6to4_0.buff_PI_d32_0.buff_PI_d16$1_0.inv_PI_d8$1_0.VOUT.n38 6to4_0.buff_PI_d32_0.buff_PI_d16$1_0.inv_PI_d8$1_0.inv_PI_d4$1_1.inv_PI_d2$1_1.VOUT 0.358
R16033 6to4_0.buff_PI_d32_0.buff_PI_d16$1_0.inv_PI_d8$1_0.inv_PI_d4$1_0.inv_PI_d2$1_0.inv_PI$1_1.VOUT 6to4_0.buff_PI_d32_0.buff_PI_d16$1_0.inv_PI_d8$1_0.VOUT.n52 0.3305
R16034 6to4_0.buff_PI_d32_0.buff_PI_d16$1_0.inv_PI_d8$1_0.VOUT.n51 6to4_0.buff_PI_d32_0.buff_PI_d16$1_0.inv_PI_d8$1_0.inv_PI_d4$1_0.inv_PI_d2$1_1.inv_PI$1_0.VOUT 0.3305
R16035 6to4_0.buff_PI_d32_0.buff_PI_d16$1_0.inv_PI_d8$1_0.inv_PI_d4$1_0.inv_PI_d2$1_1.inv_PI$1_1.VOUT 6to4_0.buff_PI_d32_0.buff_PI_d16$1_0.inv_PI_d8$1_0.VOUT.n46 0.3305
R16036 6to4_0.buff_PI_d32_0.buff_PI_d16$1_0.inv_PI_d8$1_0.inv_PI_d4$1_1.inv_PI_d2$1_0.inv_PI$1_1.VOUT 6to4_0.buff_PI_d32_0.buff_PI_d16$1_0.inv_PI_d8$1_0.VOUT.n40 0.3305
R16037 6to4_0.buff_PI_d32_0.buff_PI_d16$1_0.inv_PI_d8$1_0.VOUT.n39 6to4_0.buff_PI_d32_0.buff_PI_d16$1_0.inv_PI_d8$1_0.inv_PI_d4$1_1.inv_PI_d2$1_1.inv_PI$1_0.VOUT 0.3305
R16038 6to4_0.buff_PI_d32_0.buff_PI_d16$1_0.inv_PI_d8$1_0.inv_PI_d4$1_0.VOUT 6to4_0.buff_PI_d32_0.buff_PI_d16$1_0.inv_PI_d8$1_0.inv_PI_d4$1_0.inv_PI_d2$1_0.inv_PI$1_0.VOUT 0.217062
R16039 6to4_0.buff_PI_d32_0.buff_PI_d16$1_0.inv_PI_d8$1_0.inv_PI_d4$1_1.VOUT 6to4_0.buff_PI_d32_0.buff_PI_d16$1_0.inv_PI_d8$1_0.inv_PI_d4$1_1.inv_PI_d2$1_0.inv_PI$1_0.VOUT 0.217062
R16040 6to4_0.buff_PI_d32_0.buff_PI_d16$1_0.inv_PI_d8$1_0.inv_PI_d4$1_0.VOUT 6to4_0.buff_PI_d32_0.buff_PI_d16$1_0.inv_PI_d8$1_0.VOUT.n34 0.113938
R16041 6to4_0.buff_PI_d32_0.buff_PI_d16$1_0.inv_PI_d8$1_0.VOUT.n45 6to4_0.buff_PI_d32_0.buff_PI_d16$1_0.inv_PI_d8$1_0.inv_PI_d4$1_1.VOUT 0.113938
R16042 6to4_0.buff_PI_d32_0.buff_PI_d16$1_0.inv_PI_d16$1_0.VIN 6to4_0.buff_PI_d32_0.buff_PI_d16$1_0.inv_PI_d8$1_0.VOUT.n29 0.0662582
R16043 6to4_0.buff_PI_d32_0.buff_PI_d16$1_0.inv_PI_d8$1_0.inv_PI_d4$1_0.inv_PI_d2$1_0.inv_PI$1_0.VOUT 6to4_0.buff_PI_d32_0.buff_PI_d16$1_0.inv_PI_d8$1_0.VOUT.n56 0.062375
R16044 6to4_0.buff_PI_d32_0.buff_PI_d16$1_0.inv_PI_d8$1_0.VOUT.n53 6to4_0.buff_PI_d32_0.buff_PI_d16$1_0.inv_PI_d8$1_0.inv_PI_d4$1_0.inv_PI_d2$1_0.inv_PI$1_1.VOUT 0.062375
R16045 6to4_0.buff_PI_d32_0.buff_PI_d16$1_0.inv_PI_d8$1_0.inv_PI_d4$1_0.inv_PI_d2$1_1.inv_PI$1_0.VOUT 6to4_0.buff_PI_d32_0.buff_PI_d16$1_0.inv_PI_d8$1_0.VOUT.n50 0.062375
R16046 6to4_0.buff_PI_d32_0.buff_PI_d16$1_0.inv_PI_d8$1_0.VOUT.n47 6to4_0.buff_PI_d32_0.buff_PI_d16$1_0.inv_PI_d8$1_0.inv_PI_d4$1_0.inv_PI_d2$1_1.inv_PI$1_1.VOUT 0.062375
R16047 6to4_0.buff_PI_d32_0.buff_PI_d16$1_0.inv_PI_d8$1_0.inv_PI_d4$1_1.inv_PI_d2$1_0.inv_PI$1_0.VOUT 6to4_0.buff_PI_d32_0.buff_PI_d16$1_0.inv_PI_d8$1_0.VOUT.n44 0.062375
R16048 6to4_0.buff_PI_d32_0.buff_PI_d16$1_0.inv_PI_d8$1_0.VOUT.n41 6to4_0.buff_PI_d32_0.buff_PI_d16$1_0.inv_PI_d8$1_0.inv_PI_d4$1_1.inv_PI_d2$1_0.inv_PI$1_1.VOUT 0.062375
R16049 6to4_0.buff_PI_d32_0.buff_PI_d16$1_0.inv_PI_d8$1_0.inv_PI_d4$1_1.inv_PI_d2$1_1.inv_PI$1_0.VOUT 6to4_0.buff_PI_d32_0.buff_PI_d16$1_0.inv_PI_d8$1_0.VOUT.n38 0.062375
R16050 6to4_0.buff_PI_d32_0.buff_PI_d16$1_0.inv_PI_d8$1_0.VOUT.n35 6to4_0.buff_PI_d32_0.buff_PI_d16$1_0.inv_PI_d8$1_0.inv_PI_d4$1_1.inv_PI_d2$1_1.inv_PI$1_1.VOUT 0.062375
R16051 6to4_0.buff_PI_d32_0.buff_PI_d16$1_0.inv_PI_d8$1_0.VOUT.n30 6to4_0.buff_PI_d32_0.buff_PI_d16$1_0.inv_PI_d16$1_0.VIN 0.059489
R16052 6to4_0.buff_PI_d32_0.buff_PI_d16$1_0.inv_PI_d8$1_0.VOUT.n31 6to4_0.buff_PI_d32_0.buff_PI_d16$1_0.inv_PI_d16$1_0.inv_PI_d8$1_1.inv_PI_d4$1_1.inv_PI_d2$1_1.inv_PI$1_0.VIN 0.0555
R16053 6to4_0.buff_PI_d32_0.buff_PI_d16$1_0.inv_PI_d8$1_0.VOUT.n25 6to4_0.buff_PI_d32_0.buff_PI_d16$1_0.inv_PI_d16$1_0.inv_PI_d8$1_0.inv_PI_d4$1_1.inv_PI_d2$1_0.inv_PI$1_0.VIN 0.0555
R16054 6to4_0.buff_PI_d32_0.buff_PI_d16$1_0.inv_PI_d8$1_0.VOUT.n19 6to4_0.buff_PI_d32_0.buff_PI_d16$1_0.inv_PI_d16$1_0.inv_PI_d8$1_1.inv_PI_d4$1_0.inv_PI_d2$1_1.inv_PI$1_0.VIN 0.0555
R16055 6to4_0.buff_PI_d32_0.buff_PI_d16$1_0.inv_PI_d8$1_0.VOUT.n9 6to4_0.buff_PI_d32_0.buff_PI_d16$1_0.inv_PI_d16$1_0.inv_PI_d8$1_1.inv_PI_d4$1_0.inv_PI_d2$1_0.inv_PI$1_0.VIN 0.0555
R16056 6to4_0.buff_PI_d32_0.buff_PI_d16$1_0.inv_PI_d8$1_0.VOUT.n14 6to4_0.buff_PI_d32_0.buff_PI_d16$1_0.inv_PI_d16$1_0.inv_PI_d8$1_0.inv_PI_d4$1_0.inv_PI_d2$1_0.inv_PI$1_0.VIN 0.0555
R16057 6to4_0.buff_PI_d32_0.buff_PI_d16$1_0.inv_PI_d8$1_0.VOUT.n12 6to4_0.buff_PI_d32_0.buff_PI_d16$1_0.inv_PI_d16$1_0.inv_PI_d8$1_0.inv_PI_d4$1_0.inv_PI_d2$1_1.inv_PI$1_0.VIN 0.0555
R16058 6to4_0.buff_PI_d32_0.buff_PI_d16$1_0.inv_PI_d8$1_0.VOUT.n7 6to4_0.buff_PI_d32_0.buff_PI_d16$1_0.inv_PI_d16$1_0.inv_PI_d8$1_1.inv_PI_d4$1_1.inv_PI_d2$1_0.inv_PI$1_0.VIN 0.0555
R16059 6to4_0.buff_PI_d32_0.buff_PI_d16$1_0.inv_PI_d8$1_0.VOUT.n3 6to4_0.buff_PI_d32_0.buff_PI_d16$1_0.inv_PI_d16$1_0.inv_PI_d8$1_0.inv_PI_d4$1_1.inv_PI_d2$1_1.inv_PI$1_0.VIN 0.0555
R16060 6to4_0.buff_PI_d32_0.buff_PI_d16$1_0.inv_PI_d16$1_0.inv_PI_d8$1_0.inv_PI_d4$1_1.inv_PI_d2$1_0.VIN 6to4_0.buff_PI_d32_0.buff_PI_d16$1_0.inv_PI_d16$1_0.inv_PI_d8$1_0.inv_PI_d4$1_1.inv_PI_d2$1_0.inv_PI$1_1.VIN 0.0445
R16061 6to4_0.buff_PI_d32_0.buff_PI_d16$1_0.inv_PI_d16$1_0.inv_PI_d8$1_1.inv_PI_d4$1_0.inv_PI_d2$1_0.VIN 6to4_0.buff_PI_d32_0.buff_PI_d16$1_0.inv_PI_d16$1_0.inv_PI_d8$1_1.inv_PI_d4$1_0.inv_PI_d2$1_0.inv_PI$1_1.VIN 0.0445
R16062 6to4_0.buff_PI_d32_0.buff_PI_d16$1_0.inv_PI_d16$1_0.inv_PI_d8$1_0.inv_PI_d4$1_0.inv_PI_d2$1_0.VIN 6to4_0.buff_PI_d32_0.buff_PI_d16$1_0.inv_PI_d16$1_0.inv_PI_d8$1_0.inv_PI_d4$1_0.inv_PI_d2$1_0.inv_PI$1_1.VIN 0.0445
R16063 6to4_0.buff_PI_d32_0.buff_PI_d16$1_0.inv_PI_d16$1_0.inv_PI_d8$1_1.inv_PI_d4$1_1.inv_PI_d2$1_0.VIN 6to4_0.buff_PI_d32_0.buff_PI_d16$1_0.inv_PI_d16$1_0.inv_PI_d8$1_1.inv_PI_d4$1_1.inv_PI_d2$1_0.inv_PI$1_1.VIN 0.0445
R16064 6to4_0.buff_PI_d32_0.buff_PI_d16$1_0.inv_PI_d16$1_0.inv_PI_d8$1_1.inv_PI_d4$1_0.VIN 6to4_0.buff_PI_d32_0.buff_PI_d16$1_0.inv_PI_d16$1_0.inv_PI_d8$1_1.inv_PI_d4$1_0.inv_PI_d2$1_1.inv_PI$1_1.VIN 0.0371667
R16065 6to4_0.buff_PI_d32_0.buff_PI_d16$1_0.inv_PI_d16$1_0.inv_PI_d8$1_0.inv_PI_d4$1_0.VIN 6to4_0.buff_PI_d32_0.buff_PI_d16$1_0.inv_PI_d16$1_0.inv_PI_d8$1_0.inv_PI_d4$1_0.inv_PI_d2$1_1.inv_PI$1_1.VIN 0.0371667
R16066 6to4_0.buff_PI_d32_0.buff_PI_d16$1_0.inv_PI_d16$1_0.inv_PI_d8$1_0.inv_PI_d4$1_1.VIN 6to4_0.buff_PI_d32_0.buff_PI_d16$1_0.inv_PI_d16$1_0.inv_PI_d8$1_0.inv_PI_d4$1_1.inv_PI_d2$1_1.inv_PI$1_1.VIN 0.0371667
R16067 6to4_0.buff_PI_d32_0.buff_PI_d16$1_0.inv_PI_d16$1_0.inv_PI_d8$1_1.inv_PI_d4$1_1.inv_PI_d2$1_1.inv_PI$1_1.VIN 6to4_0.buff_PI_d32_0.buff_PI_d16$1_0.inv_PI_d16$1_0.inv_PI_d8$1_1.inv_PI_d4$1_1.VIN 0.0371667
R16068 6to4_0.buff_PI_d32_0.buff_PI_d16$1_0.inv_PI_d8$1_0.inv_PI_d4$1_0.inv_PI_d2$1_0.VOUT 6to4_0.buff_PI_d32_0.buff_PI_d16$1_0.inv_PI_d8$1_0.VOUT.n55 0.034875
R16069 6to4_0.buff_PI_d32_0.buff_PI_d16$1_0.inv_PI_d8$1_0.inv_PI_d4$1_0.inv_PI_d2$1_1.VOUT 6to4_0.buff_PI_d32_0.buff_PI_d16$1_0.inv_PI_d8$1_0.VOUT.n49 0.034875
R16070 6to4_0.buff_PI_d32_0.buff_PI_d16$1_0.inv_PI_d8$1_0.inv_PI_d4$1_1.inv_PI_d2$1_0.VOUT 6to4_0.buff_PI_d32_0.buff_PI_d16$1_0.inv_PI_d8$1_0.VOUT.n43 0.034875
R16071 6to4_0.buff_PI_d32_0.buff_PI_d16$1_0.inv_PI_d8$1_0.inv_PI_d4$1_1.inv_PI_d2$1_1.VOUT 6to4_0.buff_PI_d32_0.buff_PI_d16$1_0.inv_PI_d8$1_0.VOUT.n37 0.034875
R16072 6to4_0.buff_PI_d32_0.buff_PI_d16$1_0.inv_PI_d8$1_0.VOUT.n27 6to4_0.buff_PI_d32_0.buff_PI_d16$1_0.inv_PI_d16$1_0.inv_PI_d8$1_0.inv_PI_d4$1_1.inv_PI_d2$1_0.VIN 0.0115
R16073 6to4_0.buff_PI_d32_0.buff_PI_d16$1_0.inv_PI_d8$1_0.VOUT.n21 6to4_0.buff_PI_d32_0.buff_PI_d16$1_0.inv_PI_d16$1_0.inv_PI_d8$1_1.inv_PI_d4$1_0.inv_PI_d2$1_1.VIN 0.0115
R16074 6to4_0.buff_PI_d32_0.buff_PI_d16$1_0.inv_PI_d8$1_0.VOUT.n10 6to4_0.buff_PI_d32_0.buff_PI_d16$1_0.inv_PI_d16$1_0.inv_PI_d8$1_1.inv_PI_d4$1_0.inv_PI_d2$1_0.VIN 0.0115
R16075 6to4_0.buff_PI_d32_0.buff_PI_d16$1_0.inv_PI_d8$1_0.VOUT.n15 6to4_0.buff_PI_d32_0.buff_PI_d16$1_0.inv_PI_d16$1_0.inv_PI_d8$1_0.inv_PI_d4$1_0.inv_PI_d2$1_0.VIN 0.0115
R16076 6to4_0.buff_PI_d32_0.buff_PI_d16$1_0.inv_PI_d8$1_0.VOUT.n5 6to4_0.buff_PI_d32_0.buff_PI_d16$1_0.inv_PI_d16$1_0.inv_PI_d8$1_0.inv_PI_d4$1_0.inv_PI_d2$1_1.VIN 0.0115
R16077 6to4_0.buff_PI_d32_0.buff_PI_d16$1_0.inv_PI_d8$1_0.VOUT.n0 6to4_0.buff_PI_d32_0.buff_PI_d16$1_0.inv_PI_d16$1_0.inv_PI_d8$1_1.inv_PI_d4$1_1.inv_PI_d2$1_0.VIN 0.0115
R16078 6to4_0.buff_PI_d32_0.buff_PI_d16$1_0.inv_PI_d8$1_0.VOUT.n2 6to4_0.buff_PI_d32_0.buff_PI_d16$1_0.inv_PI_d16$1_0.inv_PI_d8$1_0.inv_PI_d4$1_1.inv_PI_d2$1_1.VIN 0.0115
R16079 6to4_0.buff_PI_d32_0.buff_PI_d16$1_0.inv_PI_d16$1_0.inv_PI_d8$1_1.inv_PI_d4$1_1.inv_PI_d2$1_1.VIN 6to4_0.buff_PI_d32_0.buff_PI_d16$1_0.inv_PI_d8$1_0.VOUT.n33 0.0115
R16080 6to4_0.buff_PI_d32_0.buff_PI_d16$1_0.inv_PI_d16$1_0.inv_PI_d8$1_1.inv_PI_d4$1_0.inv_PI_d2$1_1.VIN 6to4_0.buff_PI_d32_0.buff_PI_d16$1_0.inv_PI_d16$1_0.inv_PI_d8$1_1.inv_PI_d4$1_0.VIN 0.00783333
R16081 6to4_0.buff_PI_d32_0.buff_PI_d16$1_0.inv_PI_d16$1_0.inv_PI_d8$1_0.inv_PI_d4$1_0.inv_PI_d2$1_1.VIN 6to4_0.buff_PI_d32_0.buff_PI_d16$1_0.inv_PI_d16$1_0.inv_PI_d8$1_0.inv_PI_d4$1_0.VIN 0.00783333
R16082 6to4_0.buff_PI_d32_0.buff_PI_d16$1_0.inv_PI_d16$1_0.inv_PI_d8$1_0.inv_PI_d4$1_1.inv_PI_d2$1_1.VIN 6to4_0.buff_PI_d32_0.buff_PI_d16$1_0.inv_PI_d16$1_0.inv_PI_d8$1_0.inv_PI_d4$1_1.VIN 0.00783333
R16083 6to4_0.buff_PI_d32_0.buff_PI_d16$1_0.inv_PI_d16$1_0.inv_PI_d8$1_1.inv_PI_d4$1_1.VIN 6to4_0.buff_PI_d32_0.buff_PI_d16$1_0.inv_PI_d16$1_0.inv_PI_d8$1_1.inv_PI_d4$1_1.inv_PI_d2$1_1.VIN 0.00783333
R16084 6to4_0.buff_PI_d32_1.buff_PI_d16$1_0.inv_PI_d4$1_0.VOUT.n16 6to4_0.buff_PI_d32_1.buff_PI_d16$1_0.inv_PI_d4$1_0.VOUT.t1 17.6089
R16085 6to4_0.buff_PI_d32_1.buff_PI_d16$1_0.inv_PI_d4$1_0.VOUT.n22 6to4_0.buff_PI_d32_1.buff_PI_d16$1_0.inv_PI_d4$1_0.VOUT.t0 17.6089
R16086 6to4_0.buff_PI_d32_1.buff_PI_d16$1_0.inv_PI_d4$1_0.VOUT.n25 6to4_0.buff_PI_d32_1.buff_PI_d16$1_0.inv_PI_d4$1_0.VOUT.t2 17.6089
R16087 6to4_0.buff_PI_d32_1.buff_PI_d16$1_0.inv_PI_d4$1_0.VOUT.n19 6to4_0.buff_PI_d32_1.buff_PI_d16$1_0.inv_PI_d4$1_0.VOUT.t3 17.6089
R16088 6to4_0.buff_PI_d32_1.buff_PI_d16$1_0.inv_PI_d4$1_0.VOUT 6to4_0.buff_PI_d32_1.buff_PI_d16$1_0.inv_PI_d4$1_0.VOUT.t4 17.5436
R16089 6to4_0.buff_PI_d32_1.buff_PI_d16$1_0.inv_PI_d4$1_0.VOUT.n15 6to4_0.buff_PI_d32_1.buff_PI_d16$1_0.inv_PI_d4$1_0.VOUT.t7 17.2136
R16090 6to4_0.buff_PI_d32_1.buff_PI_d16$1_0.inv_PI_d4$1_0.VOUT.n24 6to4_0.buff_PI_d32_1.buff_PI_d16$1_0.inv_PI_d4$1_0.VOUT.t5 17.2136
R16091 6to4_0.buff_PI_d32_1.buff_PI_d16$1_0.inv_PI_d4$1_0.VOUT.n23 6to4_0.buff_PI_d32_1.buff_PI_d16$1_0.inv_PI_d4$1_0.VOUT.t9 17.2136
R16092 6to4_0.buff_PI_d32_1.buff_PI_d16$1_0.inv_PI_d4$1_0.VOUT.n21 6to4_0.buff_PI_d32_1.buff_PI_d16$1_0.inv_PI_d4$1_0.VOUT.t6 17.2136
R16093 6to4_0.buff_PI_d32_1.buff_PI_d16$1_0.inv_PI_d4$1_0.VOUT.n20 6to4_0.buff_PI_d32_1.buff_PI_d16$1_0.inv_PI_d4$1_0.VOUT.t10 17.2136
R16094 6to4_0.buff_PI_d32_1.buff_PI_d16$1_0.inv_PI_d4$1_0.VOUT.n18 6to4_0.buff_PI_d32_1.buff_PI_d16$1_0.inv_PI_d4$1_0.VOUT.t8 17.2136
R16095 6to4_0.buff_PI_d32_1.buff_PI_d16$1_0.inv_PI_d4$1_0.VOUT.n17 6to4_0.buff_PI_d32_1.buff_PI_d16$1_0.inv_PI_d4$1_0.VOUT.t11 17.2136
R16096 6to4_0.buff_PI_d32_1.buff_PI_d16$1_0.inv_PI_d4$1_0.VOUT.n0 6to4_0.buff_PI_d32_1.buff_PI_d16$1_0.inv_PI_d4$1_0.VOUT.t15 15.0005
R16097 6to4_0.buff_PI_d32_1.buff_PI_d16$1_0.inv_PI_d4$1_0.VOUT.n1 6to4_0.buff_PI_d32_1.buff_PI_d16$1_0.inv_PI_d4$1_0.VOUT.t16 15.0005
R16098 6to4_0.buff_PI_d32_1.buff_PI_d16$1_0.inv_PI_d4$1_0.VOUT.n3 6to4_0.buff_PI_d32_1.buff_PI_d16$1_0.inv_PI_d4$1_0.VOUT.t14 15.0005
R16099 6to4_0.buff_PI_d32_1.buff_PI_d16$1_0.inv_PI_d4$1_0.VOUT.n5 6to4_0.buff_PI_d32_1.buff_PI_d16$1_0.inv_PI_d4$1_0.VOUT.t18 15.0005
R16100 6to4_0.buff_PI_d32_1.buff_PI_d16$1_0.inv_PI_d4$1_0.VOUT.n7 6to4_0.buff_PI_d32_1.buff_PI_d16$1_0.inv_PI_d4$1_0.VOUT.t17 15.0005
R16101 6to4_0.buff_PI_d32_1.buff_PI_d16$1_0.inv_PI_d4$1_0.VOUT.n9 6to4_0.buff_PI_d32_1.buff_PI_d16$1_0.inv_PI_d4$1_0.VOUT.t19 15.0005
R16102 6to4_0.buff_PI_d32_1.buff_PI_d16$1_0.inv_PI_d4$1_0.VOUT.n11 6to4_0.buff_PI_d32_1.buff_PI_d16$1_0.inv_PI_d4$1_0.VOUT.t12 15.0005
R16103 6to4_0.buff_PI_d32_1.buff_PI_d16$1_0.inv_PI_d4$1_0.VOUT.n13 6to4_0.buff_PI_d32_1.buff_PI_d16$1_0.inv_PI_d4$1_0.VOUT.t13 15.0005
R16104 6to4_0.buff_PI_d32_1.buff_PI_d16$1_0.inv_PI_d4$1_0.VOUT.n2 6to4_0.buff_PI_d32_1.buff_PI_d16$1_0.inv_PI_d4$1_0.VOUT.n0 10.3469
R16105 6to4_0.buff_PI_d32_1.buff_PI_d16$1_0.inv_PI_d4$1_0.VOUT.n14 6to4_0.buff_PI_d32_1.buff_PI_d16$1_0.inv_PI_d4$1_0.VOUT.n13 9.0005
R16106 6to4_0.buff_PI_d32_1.buff_PI_d16$1_0.inv_PI_d4$1_0.VOUT.n12 6to4_0.buff_PI_d32_1.buff_PI_d16$1_0.inv_PI_d4$1_0.VOUT.n11 9.0005
R16107 6to4_0.buff_PI_d32_1.buff_PI_d16$1_0.inv_PI_d4$1_0.VOUT.n10 6to4_0.buff_PI_d32_1.buff_PI_d16$1_0.inv_PI_d4$1_0.VOUT.n9 9.0005
R16108 6to4_0.buff_PI_d32_1.buff_PI_d16$1_0.inv_PI_d4$1_0.VOUT.n8 6to4_0.buff_PI_d32_1.buff_PI_d16$1_0.inv_PI_d4$1_0.VOUT.n7 9.0005
R16109 6to4_0.buff_PI_d32_1.buff_PI_d16$1_0.inv_PI_d4$1_0.VOUT.n6 6to4_0.buff_PI_d32_1.buff_PI_d16$1_0.inv_PI_d4$1_0.VOUT.n5 9.0005
R16110 6to4_0.buff_PI_d32_1.buff_PI_d16$1_0.inv_PI_d4$1_0.VOUT.n4 6to4_0.buff_PI_d32_1.buff_PI_d16$1_0.inv_PI_d4$1_0.VOUT.n3 9.0005
R16111 6to4_0.buff_PI_d32_1.buff_PI_d16$1_0.inv_PI_d4$1_0.VOUT.n2 6to4_0.buff_PI_d32_1.buff_PI_d16$1_0.inv_PI_d4$1_0.VOUT.n1 9.0005
R16112 6to4_0.buff_PI_d32_1.buff_PI_d16$1_0.inv_PI_d4$1_0.VOUT.n15 6to4_0.buff_PI_d32_1.buff_PI_d16$1_0.inv_PI_d4$1_0.VOUT.n14 7.25305
R16113 6to4_0.buff_PI_d32_1.buff_PI_d16$1_0.inv_PI_d4$1_0.VOUT.n21 6to4_0.buff_PI_d32_1.buff_PI_d16$1_0.inv_PI_d4$1_0.VOUT.n20 1.41675
R16114 6to4_0.buff_PI_d32_1.buff_PI_d16$1_0.inv_PI_d4$1_0.VOUT.n14 6to4_0.buff_PI_d32_1.buff_PI_d16$1_0.inv_PI_d4$1_0.VOUT.n12 1.3469
R16115 6to4_0.buff_PI_d32_1.buff_PI_d16$1_0.inv_PI_d4$1_0.VOUT.n10 6to4_0.buff_PI_d32_1.buff_PI_d16$1_0.inv_PI_d4$1_0.VOUT.n8 1.3469
R16116 6to4_0.buff_PI_d32_1.buff_PI_d16$1_0.inv_PI_d4$1_0.VOUT.n6 6to4_0.buff_PI_d32_1.buff_PI_d16$1_0.inv_PI_d4$1_0.VOUT.n4 1.3469
R16117 6to4_0.buff_PI_d32_1.buff_PI_d16$1_0.inv_PI_d4$1_0.VOUT.n12 6to4_0.buff_PI_d32_1.buff_PI_d16$1_0.inv_PI_d4$1_0.VOUT.n10 0.9685
R16118 6to4_0.buff_PI_d32_1.buff_PI_d16$1_0.inv_PI_d4$1_0.VOUT.n8 6to4_0.buff_PI_d32_1.buff_PI_d16$1_0.inv_PI_d4$1_0.VOUT.n6 0.9685
R16119 6to4_0.buff_PI_d32_1.buff_PI_d16$1_0.inv_PI_d4$1_0.VOUT.n4 6to4_0.buff_PI_d32_1.buff_PI_d16$1_0.inv_PI_d4$1_0.VOUT.n2 0.9685
R16120 6to4_0.buff_PI_d32_1.buff_PI_d16$1_0.inv_PI_d4$1_0.VOUT.n24 6to4_0.buff_PI_d32_1.buff_PI_d16$1_0.inv_PI_d4$1_0.VOUT.n23 0.633
R16121 6to4_0.buff_PI_d32_1.buff_PI_d16$1_0.inv_PI_d4$1_0.VOUT.n18 6to4_0.buff_PI_d32_1.buff_PI_d16$1_0.inv_PI_d4$1_0.VOUT.n17 0.633
R16122 6to4_0.buff_PI_d32_1.buff_PI_d16$1_0.inv_PI_d4$1_0.VOUT.n23 6to4_0.buff_PI_d32_1.buff_PI_d16$1_0.inv_PI_d4$1_0.VOUT.n22 0.392375
R16123 6to4_0.buff_PI_d32_1.buff_PI_d16$1_0.inv_PI_d4$1_0.VOUT.n17 6to4_0.buff_PI_d32_1.buff_PI_d16$1_0.inv_PI_d4$1_0.VOUT.n16 0.392375
R16124 6to4_0.buff_PI_d32_1.buff_PI_d16$1_0.inv_PI_d4$1_0.VOUT.n25 6to4_0.buff_PI_d32_1.buff_PI_d16$1_0.inv_PI_d4$1_0.VOUT 0.358
R16125 6to4_0.buff_PI_d32_1.buff_PI_d16$1_0.inv_PI_d4$1_0.VOUT.n19 6to4_0.buff_PI_d32_1.buff_PI_d16$1_0.inv_PI_d4$1_0.VOUT 0.358
R16126 6to4_0.buff_PI_d32_1.buff_PI_d16$1_0.inv_PI_d4$1_0.VOUT 6to4_0.buff_PI_d32_1.buff_PI_d16$1_0.inv_PI_d4$1_0.VOUT.n21 0.3305
R16127 6to4_0.buff_PI_d32_1.buff_PI_d16$1_0.inv_PI_d4$1_0.VOUT.n20 6to4_0.buff_PI_d32_1.buff_PI_d16$1_0.inv_PI_d4$1_0.VOUT 0.3305
R16128 6to4_0.buff_PI_d32_1.buff_PI_d16$1_0.inv_PI_d4$1_0.VOUT 6to4_0.buff_PI_d32_1.buff_PI_d16$1_0.inv_PI_d4$1_0.VOUT.n15 0.113938
R16129 6to4_0.buff_PI_d32_1.buff_PI_d16$1_0.inv_PI_d4$1_0.VOUT 6to4_0.buff_PI_d32_1.buff_PI_d16$1_0.inv_PI_d4$1_0.VOUT.n25 0.062375
R16130 6to4_0.buff_PI_d32_1.buff_PI_d16$1_0.inv_PI_d4$1_0.VOUT.n22 6to4_0.buff_PI_d32_1.buff_PI_d16$1_0.inv_PI_d4$1_0.VOUT 0.062375
R16131 6to4_0.buff_PI_d32_1.buff_PI_d16$1_0.inv_PI_d4$1_0.VOUT 6to4_0.buff_PI_d32_1.buff_PI_d16$1_0.inv_PI_d4$1_0.VOUT.n19 0.062375
R16132 6to4_0.buff_PI_d32_1.buff_PI_d16$1_0.inv_PI_d4$1_0.VOUT.n16 6to4_0.buff_PI_d32_1.buff_PI_d16$1_0.inv_PI_d4$1_0.VOUT 0.062375
R16133 6to4_0.buff_PI_d32_1.buff_PI_d16$1_0.inv_PI_d4$1_0.VOUT.n1 6to4_0.buff_PI_d32_1.buff_PI_d16$1_0.inv_PI_d4$1_0.VOUT 0.0555
R16134 6to4_0.buff_PI_d32_1.buff_PI_d16$1_0.inv_PI_d4$1_0.VOUT.n5 6to4_0.buff_PI_d32_1.buff_PI_d16$1_0.inv_PI_d4$1_0.VOUT 0.0555
R16135 6to4_0.buff_PI_d32_1.buff_PI_d16$1_0.inv_PI_d4$1_0.VOUT.n9 6to4_0.buff_PI_d32_1.buff_PI_d16$1_0.inv_PI_d4$1_0.VOUT 0.0555
R16136 6to4_0.buff_PI_d32_1.buff_PI_d16$1_0.inv_PI_d4$1_0.VOUT.n13 6to4_0.buff_PI_d32_1.buff_PI_d16$1_0.inv_PI_d4$1_0.VOUT 0.0555
R16137 6to4_0.buff_PI_d32_1.buff_PI_d16$1_0.inv_PI_d4$1_0.VOUT 6to4_0.buff_PI_d32_1.buff_PI_d16$1_0.inv_PI_d4$1_0.VOUT.n24 0.034875
R16138 6to4_0.buff_PI_d32_1.buff_PI_d16$1_0.inv_PI_d4$1_0.VOUT 6to4_0.buff_PI_d32_1.buff_PI_d16$1_0.inv_PI_d4$1_0.VOUT.n18 0.034875
R16139 6to4_0.buff_PI_d32_1.buff_PI_d16$1_0.inv_PI_d4$1_0.VOUT.n0 6to4_0.buff_PI_d32_1.buff_PI_d16$1_0.inv_PI_d4$1_0.VOUT 0.0115
R16140 6to4_0.buff_PI_d32_1.buff_PI_d16$1_0.inv_PI_d4$1_0.VOUT.n3 6to4_0.buff_PI_d32_1.buff_PI_d16$1_0.inv_PI_d4$1_0.VOUT 0.0115
R16141 6to4_0.buff_PI_d32_1.buff_PI_d16$1_0.inv_PI_d4$1_0.VOUT.n7 6to4_0.buff_PI_d32_1.buff_PI_d16$1_0.inv_PI_d4$1_0.VOUT 0.0115
R16142 6to4_0.buff_PI_d32_1.buff_PI_d16$1_0.inv_PI_d4$1_0.VOUT.n11 6to4_0.buff_PI_d32_1.buff_PI_d16$1_0.inv_PI_d4$1_0.VOUT 0.0115
R16143 6ph_rosc_0.psdiff_2.buff_d8$1_0.VIN.n21 6ph_rosc_0.psdiff_2.buff_d8$1_0.VIN.n20 36.6537
R16144 6ph_rosc_0.psdiff_2.buff_d8$1_0.VIN.n29 6ph_rosc_0.psdiff_2.buff_d8$1_0.VIN.n28 19.5243
R16145 6ph_rosc_0.psdiff_2.buff_d8$1_0.VIN.n6 6ph_rosc_0.psdiff_2.buff_d8$1_0.VIN.t26 17.3511
R16146 6ph_rosc_0.psdiff_2.buff_d8$1_0.VIN.n4 6ph_rosc_0.psdiff_2.buff_d8$1_0.VIN.t13 17.3511
R16147 6ph_rosc_0.psdiff_2.buff_d8$1_0.VIN.n2 6ph_rosc_0.psdiff_2.buff_d8$1_0.VIN.t15 17.3511
R16148 6ph_rosc_0.psdiff_2.buff_d8$1_0.VIN.n0 6ph_rosc_0.psdiff_2.buff_d8$1_0.VIN.t12 17.3511
R16149 6ph_rosc_0.psdiff_2.buff_d8$1_0.VIN.n8 6ph_rosc_0.psdiff_2.buff_d8$1_0.VIN.t0 17.3511
R16150 6ph_rosc_0.psdiff_2.buff_d8$1_0.VIN.n9 6ph_rosc_0.psdiff_2.buff_d8$1_0.VIN.t8 17.3511
R16151 6ph_rosc_0.psdiff_2.buff_d8$1_0.VIN.n11 6ph_rosc_0.psdiff_2.buff_d8$1_0.VIN.t5 17.3511
R16152 6ph_rosc_0.psdiff_2.buff_d8$1_0.VIN.n13 6ph_rosc_0.psdiff_2.buff_d8$1_0.VIN.t1 17.3511
R16153 6ph_rosc_0.psdiff_2.buff_d8$1_0.VIN.n15 6ph_rosc_0.psdiff_2.buff_d8$1_0.VIN.t9 17.3511
R16154 6ph_rosc_0.psdiff_2.buff_d8$1_0.VIN.n23 6ph_rosc_0.psdiff_2.buff_d8$1_0.VIN.t10 17.2171
R16155 6ph_rosc_0.psdiff_2.buff_d8$1_0.VIN.n6 6ph_rosc_0.psdiff_2.buff_d8$1_0.VIN.t17 17.0005
R16156 6ph_rosc_0.psdiff_2.buff_d8$1_0.VIN.n7 6ph_rosc_0.psdiff_2.buff_d8$1_0.VIN.t24 17.0005
R16157 6ph_rosc_0.psdiff_2.buff_d8$1_0.VIN.n4 6ph_rosc_0.psdiff_2.buff_d8$1_0.VIN.t20 17.0005
R16158 6ph_rosc_0.psdiff_2.buff_d8$1_0.VIN.n5 6ph_rosc_0.psdiff_2.buff_d8$1_0.VIN.t22 17.0005
R16159 6ph_rosc_0.psdiff_2.buff_d8$1_0.VIN.n2 6ph_rosc_0.psdiff_2.buff_d8$1_0.VIN.t23 17.0005
R16160 6ph_rosc_0.psdiff_2.buff_d8$1_0.VIN.n3 6ph_rosc_0.psdiff_2.buff_d8$1_0.VIN.t14 17.0005
R16161 6ph_rosc_0.psdiff_2.buff_d8$1_0.VIN.n0 6ph_rosc_0.psdiff_2.buff_d8$1_0.VIN.t19 17.0005
R16162 6ph_rosc_0.psdiff_2.buff_d8$1_0.VIN.n1 6ph_rosc_0.psdiff_2.buff_d8$1_0.VIN.t21 17.0005
R16163 6ph_rosc_0.psdiff_2.buff_d8$1_0.VIN.n28 6ph_rosc_0.psdiff_2.buff_d8$1_0.VIN.t18 17.0005
R16164 6ph_rosc_0.psdiff_2.buff_d8$1_0.VIN.n27 6ph_rosc_0.psdiff_2.buff_d8$1_0.VIN.t25 17.0005
R16165 6ph_rosc_0.psdiff_2.buff_d8$1_0.VIN.n26 6ph_rosc_0.psdiff_2.buff_d8$1_0.VIN.t16 17.0005
R16166 6ph_rosc_0.psdiff_2.buff_d8$1_0.VIN.n21 6ph_rosc_0.psdiff_2.buff_d8$1_0.VIN.t11 17.0005
R16167 6ph_rosc_0.psdiff_2.buff_d8$1_0.VIN.n8 6ph_rosc_0.psdiff_2.buff_d8$1_0.VIN.t6 17.0005
R16168 6ph_rosc_0.psdiff_2.buff_d8$1_0.VIN.n20 6ph_rosc_0.psdiff_2.buff_d8$1_0.VIN.t31 17.0005
R16169 6ph_rosc_0.psdiff_2.buff_d8$1_0.VIN.n10 6ph_rosc_0.psdiff_2.buff_d8$1_0.VIN.t29 17.0005
R16170 6ph_rosc_0.psdiff_2.buff_d8$1_0.VIN.n9 6ph_rosc_0.psdiff_2.buff_d8$1_0.VIN.t3 17.0005
R16171 6ph_rosc_0.psdiff_2.buff_d8$1_0.VIN.n12 6ph_rosc_0.psdiff_2.buff_d8$1_0.VIN.t28 17.0005
R16172 6ph_rosc_0.psdiff_2.buff_d8$1_0.VIN.n11 6ph_rosc_0.psdiff_2.buff_d8$1_0.VIN.t2 17.0005
R16173 6ph_rosc_0.psdiff_2.buff_d8$1_0.VIN.n14 6ph_rosc_0.psdiff_2.buff_d8$1_0.VIN.t27 17.0005
R16174 6ph_rosc_0.psdiff_2.buff_d8$1_0.VIN.n13 6ph_rosc_0.psdiff_2.buff_d8$1_0.VIN.t7 17.0005
R16175 6ph_rosc_0.psdiff_2.buff_d8$1_0.VIN.n16 6ph_rosc_0.psdiff_2.buff_d8$1_0.VIN.t30 17.0005
R16176 6ph_rosc_0.psdiff_2.buff_d8$1_0.VIN.n15 6ph_rosc_0.psdiff_2.buff_d8$1_0.VIN.t4 17.0005
R16177 6ph_rosc_0.psdiff_2.buff_d8$1_0.VIN.n29 6ph_rosc_0.psdiff_2.buff_d8$1_0.VIN.t32 15.0005
R16178 6ph_rosc_0.psdiff_2.buff_d8$1_0.VIN.n26 6ph_rosc_0.psdiff_2.buff_d8$1_0.VIN.n25 0.997375
R16179 6ph_rosc_0.psdiff_2.buff_d8$1_0.VIN.n17 6ph_rosc_0.psdiff_2.buff_d8$1_0.VIN.n14 0.997375
R16180 6ph_rosc_0.psdiff_2.buff_d8$1_0.VIN.n20 6ph_rosc_0.psdiff_2.buff_d8$1_0.VIN.n19 0.965015
R16181 6ph_rosc_0.psdiff_2.buff_d8$1_0.VIN.n25 6ph_rosc_0.psdiff_2.buff_d8$1_0.VIN.n24 0.78425
R16182 6ph_rosc_0.psdiff_2.buff_d8$1_0.VIN.n24 6ph_rosc_0.psdiff_2.buff_d8$1_0.VIN.n23 0.78425
R16183 6ph_rosc_0.psdiff_2.buff_d8$1_0.VIN.n23 6ph_rosc_0.psdiff_2.buff_d8$1_0.VIN.n22 0.78425
R16184 6ph_rosc_0.psdiff_2.buff_d8$1_0.VIN.n19 6ph_rosc_0.psdiff_2.buff_d8$1_0.VIN.n18 0.78425
R16185 6ph_rosc_0.psdiff_2.buff_d8$1_0.VIN.n18 6ph_rosc_0.psdiff_2.buff_d8$1_0.VIN.n17 0.78425
R16186 6ph_rosc_0.psdiff_2.buff_d8$1_0.VIN.n10 6ph_rosc_0.psdiff_2.buff_d8$1_0.VIN.n9 0.622687
R16187 6ph_rosc_0.psdiff_2.buff_d8$1_0.VIN.n12 6ph_rosc_0.psdiff_2.buff_d8$1_0.VIN.n11 0.622687
R16188 6ph_rosc_0.psdiff_2.buff_d8$1_0.VIN.n14 6ph_rosc_0.psdiff_2.buff_d8$1_0.VIN.n13 0.622687
R16189 6ph_rosc_0.psdiff_2.buff_d8$1_0.VIN.n16 6ph_rosc_0.psdiff_2.buff_d8$1_0.VIN.n15 0.622687
R16190 6ph_rosc_0.psdiff_2.buff_d8$1_0.VIN.n20 6ph_rosc_0.psdiff_2.buff_d8$1_0.VIN.n8 0.590328
R16191 6ph_rosc_0.psdiff_2.buff_d8$1_0.VIN.n7 6ph_rosc_0.psdiff_2.buff_d8$1_0.VIN.n6 0.351125
R16192 6ph_rosc_0.psdiff_2.buff_d8$1_0.VIN.n5 6ph_rosc_0.psdiff_2.buff_d8$1_0.VIN.n4 0.351125
R16193 6ph_rosc_0.psdiff_2.buff_d8$1_0.VIN.n3 6ph_rosc_0.psdiff_2.buff_d8$1_0.VIN.n2 0.351125
R16194 6ph_rosc_0.psdiff_2.buff_d8$1_0.VIN.n1 6ph_rosc_0.psdiff_2.buff_d8$1_0.VIN.n0 0.351125
R16195 6ph_rosc_0.psdiff_2.buff_d8$1_0.VIN.n27 6ph_rosc_0.psdiff_2.buff_d8$1_0.VIN.n26 0.351125
R16196 6ph_rosc_0.psdiff_2.buff_d8$1_0.VIN.n28 6ph_rosc_0.psdiff_2.buff_d8$1_0.VIN.n27 0.318765
R16197 6ph_rosc_0.psdiff_2.buff_d8$1_0.VIN.n22 6ph_rosc_0.psdiff_2.buff_d8$1_0.VIN.n7 0.213625
R16198 6ph_rosc_0.psdiff_2.buff_d8$1_0.VIN.n23 6ph_rosc_0.psdiff_2.buff_d8$1_0.VIN.n5 0.213625
R16199 6ph_rosc_0.psdiff_2.buff_d8$1_0.VIN.n24 6ph_rosc_0.psdiff_2.buff_d8$1_0.VIN.n3 0.213625
R16200 6ph_rosc_0.psdiff_2.buff_d8$1_0.VIN.n25 6ph_rosc_0.psdiff_2.buff_d8$1_0.VIN.n1 0.213625
R16201 6ph_rosc_0.psdiff_2.buff_d8$1_0.VIN.n19 6ph_rosc_0.psdiff_2.buff_d8$1_0.VIN.n10 0.213625
R16202 6ph_rosc_0.psdiff_2.buff_d8$1_0.VIN.n18 6ph_rosc_0.psdiff_2.buff_d8$1_0.VIN.n12 0.213625
R16203 6ph_rosc_0.psdiff_2.buff_d8$1_0.VIN.n17 6ph_rosc_0.psdiff_2.buff_d8$1_0.VIN.n16 0.213625
R16204 6ph_rosc_0.psdiff_2.buff_d8$1_0.VIN.n22 6ph_rosc_0.psdiff_2.buff_d8$1_0.VIN.n21 0.184703
R16205 6ph_rosc_0.psdiff_2.buff_d8$1_0.inv$3_0.VIN 6ph_rosc_0.psdiff_2.buff_d8$1_0.VIN.n29 0.0555
R16206 6ph_rosc_0.psdiff_2.buff_d8$1_0.VIN.n29 6ph_rosc_0.psdiff_2.buff_d8$1_0.inv$3_0.VIN 0.0151667
R16207 6to4_0.buff_PI_d32_0.buff_PI_d16$1_0.inv_PI_d4$1_0.VOUT.n16 6to4_0.buff_PI_d32_0.buff_PI_d16$1_0.inv_PI_d4$1_0.VOUT.t1 17.6089
R16208 6to4_0.buff_PI_d32_0.buff_PI_d16$1_0.inv_PI_d4$1_0.VOUT.n22 6to4_0.buff_PI_d32_0.buff_PI_d16$1_0.inv_PI_d4$1_0.VOUT.t0 17.6089
R16209 6to4_0.buff_PI_d32_0.buff_PI_d16$1_0.inv_PI_d4$1_0.VOUT.n25 6to4_0.buff_PI_d32_0.buff_PI_d16$1_0.inv_PI_d4$1_0.VOUT.t2 17.6089
R16210 6to4_0.buff_PI_d32_0.buff_PI_d16$1_0.inv_PI_d4$1_0.VOUT.n19 6to4_0.buff_PI_d32_0.buff_PI_d16$1_0.inv_PI_d4$1_0.VOUT.t3 17.6089
R16211 6to4_0.buff_PI_d32_0.buff_PI_d16$1_0.inv_PI_d4$1_0.VOUT 6to4_0.buff_PI_d32_0.buff_PI_d16$1_0.inv_PI_d4$1_0.VOUT.t6 17.5436
R16212 6to4_0.buff_PI_d32_0.buff_PI_d16$1_0.inv_PI_d4$1_0.VOUT.n15 6to4_0.buff_PI_d32_0.buff_PI_d16$1_0.inv_PI_d4$1_0.VOUT.t8 17.2136
R16213 6to4_0.buff_PI_d32_0.buff_PI_d16$1_0.inv_PI_d4$1_0.VOUT.n24 6to4_0.buff_PI_d32_0.buff_PI_d16$1_0.inv_PI_d4$1_0.VOUT.t7 17.2136
R16214 6to4_0.buff_PI_d32_0.buff_PI_d16$1_0.inv_PI_d4$1_0.VOUT.n23 6to4_0.buff_PI_d32_0.buff_PI_d16$1_0.inv_PI_d4$1_0.VOUT.t10 17.2136
R16215 6to4_0.buff_PI_d32_0.buff_PI_d16$1_0.inv_PI_d4$1_0.VOUT.n21 6to4_0.buff_PI_d32_0.buff_PI_d16$1_0.inv_PI_d4$1_0.VOUT.t5 17.2136
R16216 6to4_0.buff_PI_d32_0.buff_PI_d16$1_0.inv_PI_d4$1_0.VOUT.n20 6to4_0.buff_PI_d32_0.buff_PI_d16$1_0.inv_PI_d4$1_0.VOUT.t4 17.2136
R16217 6to4_0.buff_PI_d32_0.buff_PI_d16$1_0.inv_PI_d4$1_0.VOUT.n18 6to4_0.buff_PI_d32_0.buff_PI_d16$1_0.inv_PI_d4$1_0.VOUT.t9 17.2136
R16218 6to4_0.buff_PI_d32_0.buff_PI_d16$1_0.inv_PI_d4$1_0.VOUT.n17 6to4_0.buff_PI_d32_0.buff_PI_d16$1_0.inv_PI_d4$1_0.VOUT.t11 17.2136
R16219 6to4_0.buff_PI_d32_0.buff_PI_d16$1_0.inv_PI_d4$1_0.VOUT.n0 6to4_0.buff_PI_d32_0.buff_PI_d16$1_0.inv_PI_d4$1_0.VOUT.t13 15.0005
R16220 6to4_0.buff_PI_d32_0.buff_PI_d16$1_0.inv_PI_d4$1_0.VOUT.n1 6to4_0.buff_PI_d32_0.buff_PI_d16$1_0.inv_PI_d4$1_0.VOUT.t14 15.0005
R16221 6to4_0.buff_PI_d32_0.buff_PI_d16$1_0.inv_PI_d4$1_0.VOUT.n3 6to4_0.buff_PI_d32_0.buff_PI_d16$1_0.inv_PI_d4$1_0.VOUT.t17 15.0005
R16222 6to4_0.buff_PI_d32_0.buff_PI_d16$1_0.inv_PI_d4$1_0.VOUT.n5 6to4_0.buff_PI_d32_0.buff_PI_d16$1_0.inv_PI_d4$1_0.VOUT.t15 15.0005
R16223 6to4_0.buff_PI_d32_0.buff_PI_d16$1_0.inv_PI_d4$1_0.VOUT.n7 6to4_0.buff_PI_d32_0.buff_PI_d16$1_0.inv_PI_d4$1_0.VOUT.t19 15.0005
R16224 6to4_0.buff_PI_d32_0.buff_PI_d16$1_0.inv_PI_d4$1_0.VOUT.n9 6to4_0.buff_PI_d32_0.buff_PI_d16$1_0.inv_PI_d4$1_0.VOUT.t16 15.0005
R16225 6to4_0.buff_PI_d32_0.buff_PI_d16$1_0.inv_PI_d4$1_0.VOUT.n11 6to4_0.buff_PI_d32_0.buff_PI_d16$1_0.inv_PI_d4$1_0.VOUT.t12 15.0005
R16226 6to4_0.buff_PI_d32_0.buff_PI_d16$1_0.inv_PI_d4$1_0.VOUT.n13 6to4_0.buff_PI_d32_0.buff_PI_d16$1_0.inv_PI_d4$1_0.VOUT.t18 15.0005
R16227 6to4_0.buff_PI_d32_0.buff_PI_d16$1_0.inv_PI_d4$1_0.VOUT.n2 6to4_0.buff_PI_d32_0.buff_PI_d16$1_0.inv_PI_d4$1_0.VOUT.n0 10.3469
R16228 6to4_0.buff_PI_d32_0.buff_PI_d16$1_0.inv_PI_d4$1_0.VOUT.n14 6to4_0.buff_PI_d32_0.buff_PI_d16$1_0.inv_PI_d4$1_0.VOUT.n13 9.0005
R16229 6to4_0.buff_PI_d32_0.buff_PI_d16$1_0.inv_PI_d4$1_0.VOUT.n12 6to4_0.buff_PI_d32_0.buff_PI_d16$1_0.inv_PI_d4$1_0.VOUT.n11 9.0005
R16230 6to4_0.buff_PI_d32_0.buff_PI_d16$1_0.inv_PI_d4$1_0.VOUT.n10 6to4_0.buff_PI_d32_0.buff_PI_d16$1_0.inv_PI_d4$1_0.VOUT.n9 9.0005
R16231 6to4_0.buff_PI_d32_0.buff_PI_d16$1_0.inv_PI_d4$1_0.VOUT.n8 6to4_0.buff_PI_d32_0.buff_PI_d16$1_0.inv_PI_d4$1_0.VOUT.n7 9.0005
R16232 6to4_0.buff_PI_d32_0.buff_PI_d16$1_0.inv_PI_d4$1_0.VOUT.n6 6to4_0.buff_PI_d32_0.buff_PI_d16$1_0.inv_PI_d4$1_0.VOUT.n5 9.0005
R16233 6to4_0.buff_PI_d32_0.buff_PI_d16$1_0.inv_PI_d4$1_0.VOUT.n4 6to4_0.buff_PI_d32_0.buff_PI_d16$1_0.inv_PI_d4$1_0.VOUT.n3 9.0005
R16234 6to4_0.buff_PI_d32_0.buff_PI_d16$1_0.inv_PI_d4$1_0.VOUT.n2 6to4_0.buff_PI_d32_0.buff_PI_d16$1_0.inv_PI_d4$1_0.VOUT.n1 9.0005
R16235 6to4_0.buff_PI_d32_0.buff_PI_d16$1_0.inv_PI_d4$1_0.VOUT.n15 6to4_0.buff_PI_d32_0.buff_PI_d16$1_0.inv_PI_d4$1_0.VOUT.n14 7.25305
R16236 6to4_0.buff_PI_d32_0.buff_PI_d16$1_0.inv_PI_d4$1_0.VOUT.n21 6to4_0.buff_PI_d32_0.buff_PI_d16$1_0.inv_PI_d4$1_0.VOUT.n20 1.41675
R16237 6to4_0.buff_PI_d32_0.buff_PI_d16$1_0.inv_PI_d4$1_0.VOUT.n14 6to4_0.buff_PI_d32_0.buff_PI_d16$1_0.inv_PI_d4$1_0.VOUT.n12 1.3469
R16238 6to4_0.buff_PI_d32_0.buff_PI_d16$1_0.inv_PI_d4$1_0.VOUT.n10 6to4_0.buff_PI_d32_0.buff_PI_d16$1_0.inv_PI_d4$1_0.VOUT.n8 1.3469
R16239 6to4_0.buff_PI_d32_0.buff_PI_d16$1_0.inv_PI_d4$1_0.VOUT.n6 6to4_0.buff_PI_d32_0.buff_PI_d16$1_0.inv_PI_d4$1_0.VOUT.n4 1.3469
R16240 6to4_0.buff_PI_d32_0.buff_PI_d16$1_0.inv_PI_d4$1_0.VOUT.n12 6to4_0.buff_PI_d32_0.buff_PI_d16$1_0.inv_PI_d4$1_0.VOUT.n10 0.9685
R16241 6to4_0.buff_PI_d32_0.buff_PI_d16$1_0.inv_PI_d4$1_0.VOUT.n8 6to4_0.buff_PI_d32_0.buff_PI_d16$1_0.inv_PI_d4$1_0.VOUT.n6 0.9685
R16242 6to4_0.buff_PI_d32_0.buff_PI_d16$1_0.inv_PI_d4$1_0.VOUT.n4 6to4_0.buff_PI_d32_0.buff_PI_d16$1_0.inv_PI_d4$1_0.VOUT.n2 0.9685
R16243 6to4_0.buff_PI_d32_0.buff_PI_d16$1_0.inv_PI_d4$1_0.VOUT.n24 6to4_0.buff_PI_d32_0.buff_PI_d16$1_0.inv_PI_d4$1_0.VOUT.n23 0.633
R16244 6to4_0.buff_PI_d32_0.buff_PI_d16$1_0.inv_PI_d4$1_0.VOUT.n18 6to4_0.buff_PI_d32_0.buff_PI_d16$1_0.inv_PI_d4$1_0.VOUT.n17 0.633
R16245 6to4_0.buff_PI_d32_0.buff_PI_d16$1_0.inv_PI_d4$1_0.VOUT.n23 6to4_0.buff_PI_d32_0.buff_PI_d16$1_0.inv_PI_d4$1_0.VOUT.n22 0.392375
R16246 6to4_0.buff_PI_d32_0.buff_PI_d16$1_0.inv_PI_d4$1_0.VOUT.n17 6to4_0.buff_PI_d32_0.buff_PI_d16$1_0.inv_PI_d4$1_0.VOUT.n16 0.392375
R16247 6to4_0.buff_PI_d32_0.buff_PI_d16$1_0.inv_PI_d4$1_0.VOUT.n25 6to4_0.buff_PI_d32_0.buff_PI_d16$1_0.inv_PI_d4$1_0.VOUT 0.358
R16248 6to4_0.buff_PI_d32_0.buff_PI_d16$1_0.inv_PI_d4$1_0.VOUT.n19 6to4_0.buff_PI_d32_0.buff_PI_d16$1_0.inv_PI_d4$1_0.VOUT 0.358
R16249 6to4_0.buff_PI_d32_0.buff_PI_d16$1_0.inv_PI_d4$1_0.VOUT 6to4_0.buff_PI_d32_0.buff_PI_d16$1_0.inv_PI_d4$1_0.VOUT.n21 0.3305
R16250 6to4_0.buff_PI_d32_0.buff_PI_d16$1_0.inv_PI_d4$1_0.VOUT.n20 6to4_0.buff_PI_d32_0.buff_PI_d16$1_0.inv_PI_d4$1_0.VOUT 0.3305
R16251 6to4_0.buff_PI_d32_0.buff_PI_d16$1_0.inv_PI_d4$1_0.VOUT 6to4_0.buff_PI_d32_0.buff_PI_d16$1_0.inv_PI_d4$1_0.VOUT.n15 0.113938
R16252 6to4_0.buff_PI_d32_0.buff_PI_d16$1_0.inv_PI_d4$1_0.VOUT 6to4_0.buff_PI_d32_0.buff_PI_d16$1_0.inv_PI_d4$1_0.VOUT.n25 0.062375
R16253 6to4_0.buff_PI_d32_0.buff_PI_d16$1_0.inv_PI_d4$1_0.VOUT.n22 6to4_0.buff_PI_d32_0.buff_PI_d16$1_0.inv_PI_d4$1_0.VOUT 0.062375
R16254 6to4_0.buff_PI_d32_0.buff_PI_d16$1_0.inv_PI_d4$1_0.VOUT 6to4_0.buff_PI_d32_0.buff_PI_d16$1_0.inv_PI_d4$1_0.VOUT.n19 0.062375
R16255 6to4_0.buff_PI_d32_0.buff_PI_d16$1_0.inv_PI_d4$1_0.VOUT.n16 6to4_0.buff_PI_d32_0.buff_PI_d16$1_0.inv_PI_d4$1_0.VOUT 0.062375
R16256 6to4_0.buff_PI_d32_0.buff_PI_d16$1_0.inv_PI_d4$1_0.VOUT.n1 6to4_0.buff_PI_d32_0.buff_PI_d16$1_0.inv_PI_d4$1_0.VOUT 0.0555
R16257 6to4_0.buff_PI_d32_0.buff_PI_d16$1_0.inv_PI_d4$1_0.VOUT.n5 6to4_0.buff_PI_d32_0.buff_PI_d16$1_0.inv_PI_d4$1_0.VOUT 0.0555
R16258 6to4_0.buff_PI_d32_0.buff_PI_d16$1_0.inv_PI_d4$1_0.VOUT.n9 6to4_0.buff_PI_d32_0.buff_PI_d16$1_0.inv_PI_d4$1_0.VOUT 0.0555
R16259 6to4_0.buff_PI_d32_0.buff_PI_d16$1_0.inv_PI_d4$1_0.VOUT.n13 6to4_0.buff_PI_d32_0.buff_PI_d16$1_0.inv_PI_d4$1_0.VOUT 0.0555
R16260 6to4_0.buff_PI_d32_0.buff_PI_d16$1_0.inv_PI_d4$1_0.VOUT 6to4_0.buff_PI_d32_0.buff_PI_d16$1_0.inv_PI_d4$1_0.VOUT.n24 0.034875
R16261 6to4_0.buff_PI_d32_0.buff_PI_d16$1_0.inv_PI_d4$1_0.VOUT 6to4_0.buff_PI_d32_0.buff_PI_d16$1_0.inv_PI_d4$1_0.VOUT.n18 0.034875
R16262 6to4_0.buff_PI_d32_0.buff_PI_d16$1_0.inv_PI_d4$1_0.VOUT.n0 6to4_0.buff_PI_d32_0.buff_PI_d16$1_0.inv_PI_d4$1_0.VOUT 0.0115
R16263 6to4_0.buff_PI_d32_0.buff_PI_d16$1_0.inv_PI_d4$1_0.VOUT.n3 6to4_0.buff_PI_d32_0.buff_PI_d16$1_0.inv_PI_d4$1_0.VOUT 0.0115
R16264 6to4_0.buff_PI_d32_0.buff_PI_d16$1_0.inv_PI_d4$1_0.VOUT.n7 6to4_0.buff_PI_d32_0.buff_PI_d16$1_0.inv_PI_d4$1_0.VOUT 0.0115
R16265 6to4_0.buff_PI_d32_0.buff_PI_d16$1_0.inv_PI_d4$1_0.VOUT.n11 6to4_0.buff_PI_d32_0.buff_PI_d16$1_0.inv_PI_d4$1_0.VOUT 0.0115
R16266 6ph_rosc_0.psdiff_1.buff_d8$1_0.VIN.n19 6ph_rosc_0.psdiff_1.buff_d8$1_0.VIN.n18 36.6537
R16267 6ph_rosc_0.psdiff_1.buff_d8$1_0.VIN.n29 6ph_rosc_0.psdiff_1.buff_d8$1_0.VIN.n28 19.5243
R16268 6ph_rosc_0.psdiff_1.buff_d8$1_0.VIN.n4 6ph_rosc_0.psdiff_1.buff_d8$1_0.VIN.t5 17.3511
R16269 6ph_rosc_0.psdiff_1.buff_d8$1_0.VIN.n6 6ph_rosc_0.psdiff_1.buff_d8$1_0.VIN.t19 17.3511
R16270 6ph_rosc_0.psdiff_1.buff_d8$1_0.VIN.n7 6ph_rosc_0.psdiff_1.buff_d8$1_0.VIN.t17 17.3511
R16271 6ph_rosc_0.psdiff_1.buff_d8$1_0.VIN.n9 6ph_rosc_0.psdiff_1.buff_d8$1_0.VIN.t20 17.3511
R16272 6ph_rosc_0.psdiff_1.buff_d8$1_0.VIN.n11 6ph_rosc_0.psdiff_1.buff_d8$1_0.VIN.t22 17.3511
R16273 6ph_rosc_0.psdiff_1.buff_d8$1_0.VIN.n13 6ph_rosc_0.psdiff_1.buff_d8$1_0.VIN.t21 17.3511
R16274 6ph_rosc_0.psdiff_1.buff_d8$1_0.VIN.n20 6ph_rosc_0.psdiff_1.buff_d8$1_0.VIN.t11 17.3511
R16275 6ph_rosc_0.psdiff_1.buff_d8$1_0.VIN.n2 6ph_rosc_0.psdiff_1.buff_d8$1_0.VIN.t10 17.3511
R16276 6ph_rosc_0.psdiff_1.buff_d8$1_0.VIN.n0 6ph_rosc_0.psdiff_1.buff_d8$1_0.VIN.t13 17.3511
R16277 6ph_rosc_0.psdiff_1.buff_d8$1_0.VIN.n23 6ph_rosc_0.psdiff_1.buff_d8$1_0.VIN.t30 17.2171
R16278 6ph_rosc_0.psdiff_1.buff_d8$1_0.VIN.n4 6ph_rosc_0.psdiff_1.buff_d8$1_0.VIN.t7 17.0005
R16279 6ph_rosc_0.psdiff_1.buff_d8$1_0.VIN.n5 6ph_rosc_0.psdiff_1.buff_d8$1_0.VIN.t3 17.0005
R16280 6ph_rosc_0.psdiff_1.buff_d8$1_0.VIN.n6 6ph_rosc_0.psdiff_1.buff_d8$1_0.VIN.t23 17.0005
R16281 6ph_rosc_0.psdiff_1.buff_d8$1_0.VIN.n8 6ph_rosc_0.psdiff_1.buff_d8$1_0.VIN.t29 17.0005
R16282 6ph_rosc_0.psdiff_1.buff_d8$1_0.VIN.n7 6ph_rosc_0.psdiff_1.buff_d8$1_0.VIN.t16 17.0005
R16283 6ph_rosc_0.psdiff_1.buff_d8$1_0.VIN.n10 6ph_rosc_0.psdiff_1.buff_d8$1_0.VIN.t28 17.0005
R16284 6ph_rosc_0.psdiff_1.buff_d8$1_0.VIN.n9 6ph_rosc_0.psdiff_1.buff_d8$1_0.VIN.t24 17.0005
R16285 6ph_rosc_0.psdiff_1.buff_d8$1_0.VIN.n12 6ph_rosc_0.psdiff_1.buff_d8$1_0.VIN.t26 17.0005
R16286 6ph_rosc_0.psdiff_1.buff_d8$1_0.VIN.n11 6ph_rosc_0.psdiff_1.buff_d8$1_0.VIN.t15 17.0005
R16287 6ph_rosc_0.psdiff_1.buff_d8$1_0.VIN.n14 6ph_rosc_0.psdiff_1.buff_d8$1_0.VIN.t25 17.0005
R16288 6ph_rosc_0.psdiff_1.buff_d8$1_0.VIN.n13 6ph_rosc_0.psdiff_1.buff_d8$1_0.VIN.t18 17.0005
R16289 6ph_rosc_0.psdiff_1.buff_d8$1_0.VIN.n18 6ph_rosc_0.psdiff_1.buff_d8$1_0.VIN.t27 17.0005
R16290 6ph_rosc_0.psdiff_1.buff_d8$1_0.VIN.n19 6ph_rosc_0.psdiff_1.buff_d8$1_0.VIN.t31 17.0005
R16291 6ph_rosc_0.psdiff_1.buff_d8$1_0.VIN.n20 6ph_rosc_0.psdiff_1.buff_d8$1_0.VIN.t1 17.0005
R16292 6ph_rosc_0.psdiff_1.buff_d8$1_0.VIN.n21 6ph_rosc_0.psdiff_1.buff_d8$1_0.VIN.t9 17.0005
R16293 6ph_rosc_0.psdiff_1.buff_d8$1_0.VIN.n2 6ph_rosc_0.psdiff_1.buff_d8$1_0.VIN.t2 17.0005
R16294 6ph_rosc_0.psdiff_1.buff_d8$1_0.VIN.n3 6ph_rosc_0.psdiff_1.buff_d8$1_0.VIN.t8 17.0005
R16295 6ph_rosc_0.psdiff_1.buff_d8$1_0.VIN.n0 6ph_rosc_0.psdiff_1.buff_d8$1_0.VIN.t6 17.0005
R16296 6ph_rosc_0.psdiff_1.buff_d8$1_0.VIN.n1 6ph_rosc_0.psdiff_1.buff_d8$1_0.VIN.t12 17.0005
R16297 6ph_rosc_0.psdiff_1.buff_d8$1_0.VIN.n28 6ph_rosc_0.psdiff_1.buff_d8$1_0.VIN.t4 17.0005
R16298 6ph_rosc_0.psdiff_1.buff_d8$1_0.VIN.n26 6ph_rosc_0.psdiff_1.buff_d8$1_0.VIN.t0 17.0005
R16299 6ph_rosc_0.psdiff_1.buff_d8$1_0.VIN.n27 6ph_rosc_0.psdiff_1.buff_d8$1_0.VIN.t14 17.0005
R16300 6ph_rosc_0.psdiff_1.buff_d8$1_0.VIN.n29 6ph_rosc_0.psdiff_1.buff_d8$1_0.VIN.t32 15.0005
R16301 6ph_rosc_0.psdiff_1.buff_d8$1_0.VIN.n15 6ph_rosc_0.psdiff_1.buff_d8$1_0.VIN.n14 0.997375
R16302 6ph_rosc_0.psdiff_1.buff_d8$1_0.VIN.n26 6ph_rosc_0.psdiff_1.buff_d8$1_0.VIN.n25 0.997375
R16303 6ph_rosc_0.psdiff_1.buff_d8$1_0.VIN.n18 6ph_rosc_0.psdiff_1.buff_d8$1_0.VIN.n17 0.965015
R16304 6ph_rosc_0.psdiff_1.buff_d8$1_0.VIN.n17 6ph_rosc_0.psdiff_1.buff_d8$1_0.VIN.n16 0.78425
R16305 6ph_rosc_0.psdiff_1.buff_d8$1_0.VIN.n16 6ph_rosc_0.psdiff_1.buff_d8$1_0.VIN.n15 0.78425
R16306 6ph_rosc_0.psdiff_1.buff_d8$1_0.VIN.n25 6ph_rosc_0.psdiff_1.buff_d8$1_0.VIN.n24 0.78425
R16307 6ph_rosc_0.psdiff_1.buff_d8$1_0.VIN.n24 6ph_rosc_0.psdiff_1.buff_d8$1_0.VIN.n23 0.78425
R16308 6ph_rosc_0.psdiff_1.buff_d8$1_0.VIN.n23 6ph_rosc_0.psdiff_1.buff_d8$1_0.VIN.n22 0.78425
R16309 6ph_rosc_0.psdiff_1.buff_d8$1_0.VIN.n8 6ph_rosc_0.psdiff_1.buff_d8$1_0.VIN.n7 0.622687
R16310 6ph_rosc_0.psdiff_1.buff_d8$1_0.VIN.n10 6ph_rosc_0.psdiff_1.buff_d8$1_0.VIN.n9 0.622687
R16311 6ph_rosc_0.psdiff_1.buff_d8$1_0.VIN.n12 6ph_rosc_0.psdiff_1.buff_d8$1_0.VIN.n11 0.622687
R16312 6ph_rosc_0.psdiff_1.buff_d8$1_0.VIN.n14 6ph_rosc_0.psdiff_1.buff_d8$1_0.VIN.n13 0.622687
R16313 6ph_rosc_0.psdiff_1.buff_d8$1_0.VIN.n18 6ph_rosc_0.psdiff_1.buff_d8$1_0.VIN.n6 0.590328
R16314 6ph_rosc_0.psdiff_1.buff_d8$1_0.VIN.n5 6ph_rosc_0.psdiff_1.buff_d8$1_0.VIN.n4 0.351125
R16315 6ph_rosc_0.psdiff_1.buff_d8$1_0.VIN.n21 6ph_rosc_0.psdiff_1.buff_d8$1_0.VIN.n20 0.351125
R16316 6ph_rosc_0.psdiff_1.buff_d8$1_0.VIN.n3 6ph_rosc_0.psdiff_1.buff_d8$1_0.VIN.n2 0.351125
R16317 6ph_rosc_0.psdiff_1.buff_d8$1_0.VIN.n1 6ph_rosc_0.psdiff_1.buff_d8$1_0.VIN.n0 0.351125
R16318 6ph_rosc_0.psdiff_1.buff_d8$1_0.VIN.n27 6ph_rosc_0.psdiff_1.buff_d8$1_0.VIN.n26 0.351125
R16319 6ph_rosc_0.psdiff_1.buff_d8$1_0.VIN.n28 6ph_rosc_0.psdiff_1.buff_d8$1_0.VIN.n27 0.318765
R16320 6ph_rosc_0.psdiff_1.buff_d8$1_0.VIN.n23 6ph_rosc_0.psdiff_1.buff_d8$1_0.VIN.n5 0.213625
R16321 6ph_rosc_0.psdiff_1.buff_d8$1_0.VIN.n17 6ph_rosc_0.psdiff_1.buff_d8$1_0.VIN.n8 0.213625
R16322 6ph_rosc_0.psdiff_1.buff_d8$1_0.VIN.n16 6ph_rosc_0.psdiff_1.buff_d8$1_0.VIN.n10 0.213625
R16323 6ph_rosc_0.psdiff_1.buff_d8$1_0.VIN.n15 6ph_rosc_0.psdiff_1.buff_d8$1_0.VIN.n12 0.213625
R16324 6ph_rosc_0.psdiff_1.buff_d8$1_0.VIN.n22 6ph_rosc_0.psdiff_1.buff_d8$1_0.VIN.n21 0.213625
R16325 6ph_rosc_0.psdiff_1.buff_d8$1_0.VIN.n24 6ph_rosc_0.psdiff_1.buff_d8$1_0.VIN.n3 0.213625
R16326 6ph_rosc_0.psdiff_1.buff_d8$1_0.VIN.n25 6ph_rosc_0.psdiff_1.buff_d8$1_0.VIN.n1 0.213625
R16327 6ph_rosc_0.psdiff_1.buff_d8$1_0.VIN.n22 6ph_rosc_0.psdiff_1.buff_d8$1_0.VIN.n19 0.184703
R16328 6ph_rosc_0.psdiff_1.buff_d8$1_0.inv$3_0.VIN 6ph_rosc_0.psdiff_1.buff_d8$1_0.VIN.n29 0.0555
R16329 6ph_rosc_0.psdiff_1.buff_d8$1_0.VIN.n29 6ph_rosc_0.psdiff_1.buff_d8$1_0.inv$3_0.VIN 0.0151667
C0 CTRL 6ph_rosc_0.psdiff_2.buff_d8$1_1.inv_d8$1_0.VIN 0.00496f
C1 6ph_rosc_0.PH4 6ph_rosc_0.PH1 7.7361f
C2 a_16058_8859# VDD 0
C3 6ph_rosc_0.buff_d8$1_2.inv_d2$1_0.VIN 6ph_rosc_0.psdiff_1.VOUTDN 0.17391f
C4 a_6064_5604# VDD 0
C5 a_4999_2194# VDD 0.62345f
C6 a_17110_11663# VDD 0
C7 6ph_rosc_0.buff_d8$1_0.inv_d4$1_0.VIN 6ph_rosc_0.psdiff_2.CLKP 0.04552f
C8 6ph_rosc_0.buff_d8$1_0.inv_d2$1_0.VIN 6ph_rosc_0.psdiff_0.buff_d8$1_1.inv_d8$1_0.VIN 0.00139f
C9 6to4_0.PI_clk_1.inv_PI_d2$1_0.VOUT a_3434_13065# -0
C10 CTRL 6ph_rosc_0.psdiff_1.buff_d8$1_1.inv_d2$1_0.VIN 0.01288f
C11 6to4_0.buff_PI_d32_3.buff_PI_d16$1_0.inv_PI_d4$1_0.VOUT VDD 3.69561f
C12 6ph_rosc_0.PH3 6ph_rosc_0.buff_d8$1_3.inv_d8$1_0.VIN 0
C13 6ph_rosc_0.psdiff_2.VOUTDP 6ph_rosc_0.buff_d8$1_3.inv_d2$1_0.VIN 0.05924f
C14 6ph_rosc_0.psdiff_2.VOUTDN a_4999_2194# 0
C15 6ph_rosc_0.PH5 6ph_rosc_0.PH3 0.13791f
C16 6ph_rosc_0.buff_d8$1_2.inv_d8$1_0.VIN 6ph_rosc_0.psdiff_1.buff_d8$1_1.inv_d2$1_0.VIN 0.01857f
C17 6ph_rosc_0.PH1 6ph_rosc_0.PH3 0.09961f
C18 a_8671_1011# VDD 0
C19 6ph_rosc_0.psdiff_1.VOUTDN 6ph_rosc_0.buff_d8$1_1.inv_d4$1_0.VIN 0
C20 a_17110_10261# VDD 0
C21 CTRL 6ph_rosc_0.buff_d8$1_1.inv_d2$1_0.VIN 0
C22 6ph_rosc_0.buff_d8$1_5.inv_d8$1_0.VIN 6ph_rosc_0.buff_d8$1_5.inv_d4$1_0.VIN 0.49436f
C23 a_3960_15869# VDD -0
C24 6to4_0.buff_PI_d32_0.buff_PI_d16$1_0.inv_PI_d4$1_0.VIN VDD 1.56067f
C25 a_19214_12364# PH270 -0
C26 6to4_0.buff_PI_d32_2.buff_PI_d16$1_0.inv_PI_d4$1_0.VIN 6to4_0.buff_PI_d32_2.inv_PI_d16$1_0.VIN 0
C27 6to4_0.PI_clk_0.inv_PI_d2$1_0.VOUT 6to4_0.buff_PI_d32_2.buff_PI_d16$1_0.inv_PI_d4$1_0.VOUT 0
C28 6ph_rosc_0.psdiff_1.VOUTDP 6ph_rosc_0.psdiff_0.buff_d8$1_0.inv_d8$1_0.VIN 0.00881f
C29 6ph_rosc_0.psdiff_2.buff_d8$1_1.inv_d4$1_0.VIN VDD 0.66998f
C30 6ph_rosc_0.psdiff_1.VOUTDP 6ph_rosc_0.buff_d8$1_3.inv_d8$1_0.VIN 0.02378f
C31 6to4_0.buff_PI_d32_2.VIN 6ph_rosc_0.PH2 0.00334f
C32 6ph_rosc_0.PH4 6to4_0.buff_PI_d32_3.buff_PI_d16$1_0.inv_PI_d4$1_0.VOUT 0
C33 6to4_0.buff_PI_d32_0.inv_PI_d32_0.VIN PH90 7.50825f
C34 a_5538_10962# VDD 0
C35 6ph_rosc_0.PH5 6ph_rosc_0.psdiff_1.VOUTDP 0.13629f
C36 a_19214_15168# VDD 0
C37 6ph_rosc_0.psdiff_1.VOUTDN a_7973_2194# 0
C38 6ph_rosc_0.PH1 6ph_rosc_0.buff_d8$1_2.inv_d4$1_0.VIN 0.02225f
C39 6ph_rosc_0.psdiff_2.VOUTDN 6ph_rosc_0.psdiff_2.buff_d8$1_1.inv_d4$1_0.VIN 0
C40 6ph_rosc_0.PH1 6ph_rosc_0.psdiff_1.VOUTDP 0.01068f
C41 a_9220_10962# VDD 0
C42 CTRL 6ph_rosc_0.buff_d8$1_5.inv_d8$1_0.VIN 0.04515f
C43 6ph_rosc_0.psdiff_2.CLKP a_12794_3640# -0
C44 6ph_rosc_0.psdiff_1.buff_d8$1_1.inv_d4$1_0.VIN 6ph_rosc_0.psdiff_1.buff_d8$1_1.inv_d8$1_0.VIN 0.49436f
C45 6ph_rosc_0.psdiff_2.CLKN 6ph_rosc_0.buff_d8$1_1.inv_d4$1_0.VIN 0.01516f
C46 a_18688_15869# VDD 0
C47 a_5012_13766# VDD 0
C48 a_12902_10962# VDD 0
C49 6ph_rosc_0.psdiff_2.buff_d8$1_1.inv_d2$1_0.VIN a_4999_2194# 0.00545f
C50 6ph_rosc_0.psdiff_2.buff_d8$1_1.inv_d8$1_0.VIN VDD 1.41281f
C51 6to4_0.inv_PI_d2$1_2.VOUT 6to4_0.buff_PI_d32_3.buff_PI_d16$1_0.inv_PI_d4$1_0.VIN 0.46013f
C52 a_8694_13766# VDD 0
C53 6ph_rosc_0.buff_d8$1_5.inv_d8$1_0.VIN 6ph_rosc_0.buff_d8$1_2.inv_d8$1_0.VIN 0
C54 a_16584_10962# VDD 0
C55 6ph_rosc_0.psdiff_2.CLKP 6ph_rosc_0.psdiff_1.buff_d8$1_1.inv_d4$1_0.VIN 0.00179f
C56 6ph_rosc_0.psdiff_1.buff_d8$1_1.inv_d2$1_0.VIN VDD 0.34786f
C57 a_12376_13766# VDD 0
C58 6to4_0.buff_PI_d32_3.inv_PI_d32_0.VIN PH180 7.50825f
C59 6ph_rosc_0.PH5 6to4_0.flywheel_clk_1.PH0 0
C60 6ph_rosc_0.psdiff_2.CLKN 6ph_rosc_0.buff_d8$1_3.inv_d2$1_0.VIN 0.01748f
C61 6ph_rosc_0.psdiff_2.VOUTDN 6ph_rosc_0.psdiff_2.buff_d8$1_1.inv_d8$1_0.VIN 1.01209f
C62 6to4_0.buff_PI_d32_0.inv_PI_d16$1_0.VIN VDD 9.92937f
C63 6ph_rosc_0.psdiff_2.CLKP 6ph_rosc_0.buff_d8$1_4.inv_d8$1_0.VIN 0
C64 a_4999_2194# a_6156_2338# 0.01277f
C65 6ph_rosc_0.psdiff_2.VOUTDN 6ph_rosc_0.psdiff_1.buff_d8$1_1.inv_d2$1_0.VIN 0.02057f
C66 a_7642_16570# VDD 0
C67 6ph_rosc_0.psdiff_0.buff_d8$1_0.inv_d4$1_0.VIN VDD 0.59837f
C68 a_15006_13766# 6to4_0.buff_PI_d32_2.inv_PI_d32_0.VIN -0
C69 6to4_0.buff_PI_d32_2.buff_PI_d16$1_0.inv_PI_d4$1_0.VOUT 6to4_0.buff_PI_d32_2.inv_PI_d16$1_0.VIN 0.02662f
C70 6ph_rosc_0.PH5 6ph_rosc_0.PH2 5.66407f
C71 PH0 a_19214_9560# -0
C72 6ph_rosc_0.PH5 6ph_rosc_0.buff_d8$1_0.inv_d8$1_0.VIN 0.01375f
C73 6ph_rosc_0.PH1 6ph_rosc_0.PH2 9.16059f
C74 6ph_rosc_0.psdiff_1.buff_d8$1_1.inv_d8$1_0.VIN 6ph_rosc_0.psdiff_0.buff_d8$1_1.inv_d2$1_0.VIN 0
C75 CTRL a_12104_2338# 0.08681f
C76 6ph_rosc_0.buff_d8$1_3.inv_d2$1_0.VIN 6ph_rosc_0.buff_d8$1_3.inv_d4$1_0.VIN 0.25118f
C77 6ph_rosc_0.PH1 6ph_rosc_0.buff_d8$1_0.inv_d8$1_0.VIN 0.00419f
C78 6ph_rosc_0.psdiff_0.buff_d8$1_1.inv_d2$1_0.VIN a_10947_2194# 0.00545f
C79 a_11324_16570# VDD 0
C80 6to4_0.buff_PI_d32_3.inv_PI_d16$1_0.VIN VDD 9.93533f
C81 6ph_rosc_0.psdiff_2.CLKP 6ph_rosc_0.psdiff_1.buff_d8$1_1.inv_d8$1_0.VIN 0.00464f
C82 a_19214_13065# VDD 0
C83 6ph_rosc_0.psdiff_2.CLKP a_10947_2194# 0.00647f
C84 a_15006_16570# VDD 0
C85 6ph_rosc_0.buff_d8$1_1.inv_d2$1_0.VIN VDD 0.24844f
C86 6ph_rosc_0.psdiff_2.CLKP 6ph_rosc_0.psdiff_0.buff_d8$1_1.inv_d2$1_0.VIN 0
C87 a_18688_12364# VDD 0
C88 a_18688_16570# VDD 0
C89 6to4_0.buff_PI_d32_2.buff_PI_d16$1_0.inv_PI_d4$1_0.VOUT a_7116_13766# -0
C90 a_16584_14467# VDD 0
C91 6ph_rosc_0.psdiff_0.buff_d8$1_0.inv_d2$1_0.VIN VDD 0.25495f
C92 a_7968_3640# VDD 0
C93 a_9130_2338# 6ph_rosc_0.psdiff_1.buff_d8$1_0.inv_d8$1_0.VIN 0.01471f
C94 a_14480_13766# VDD 0
C95 CTRL 6ph_rosc_0.psdiff_1.buff_d8$1_0.inv_d8$1_0.VIN 0.03646f
C96 6ph_rosc_0.psdiff_2.buff_d8$1_1.inv_d2$1_0.VIN 6ph_rosc_0.psdiff_2.buff_d8$1_1.inv_d4$1_0.VIN 0.25118f
C97 6ph_rosc_0.psdiff_2.VOUTDP 6ph_rosc_0.psdiff_0.buff_d8$1_0.inv_d8$1_0.VIN 0.05035f
C98 6ph_rosc_0.psdiff_2.VOUTDP 6ph_rosc_0.buff_d8$1_3.inv_d8$1_0.VIN 0.19927f
C99 a_7116_8158# VDD 0
C100 a_18162_13766# VDD 0
C101 6ph_rosc_0.psdiff_1.buff_d8$1_0.inv_d8$1_0.VIN 6ph_rosc_0.psdiff_1.buff_d8$1_0.inv_d4$1_0.VIN 0.49436f
C102 6ph_rosc_0.PH4 6ph_rosc_0.psdiff_1.buff_d8$1_1.inv_d2$1_0.VIN 0
C103 a_10798_8158# VDD 0
C104 6to4_0.inv_PI_d2$1_2.VOUT 6to4_0.inv_PI_d2$1_3.VOUT 0.44819f
C105 6ph_rosc_0.buff_d8$1_0.inv_d8$1_0.VIN 6ph_rosc_0.buff_d8$1_0.inv_d2$1_0.VIN 0
C106 6ph_rosc_0.PH1 6ph_rosc_0.psdiff_2.VOUTDP 0.12986f
C107 6to4_0.PI_clk_0.inv_PI_d2$1_0.VOUT a_3434_15168# -0
C108 a_14480_8158# VDD 0
C109 6ph_rosc_0.buff_d8$1_5.inv_d8$1_0.VIN VDD 1.5213f
C110 6ph_rosc_0.PH3 6ph_rosc_0.psdiff_2.buff_d8$1_1.inv_d8$1_0.VIN 0.03874f
C111 6ph_rosc_0.psdiff_2.buff_d8$1_1.inv_d2$1_0.VIN 6ph_rosc_0.psdiff_2.buff_d8$1_1.inv_d8$1_0.VIN 0
C112 6ph_rosc_0.PH5 6to4_0.inv_PI_d2$1_1.VIN 0.00511f
C113 6to4_0.flywheel_clk_1.PH0 6to4_0.buff_PI_d32_3.buff_PI_d16$1_0.inv_PI_d4$1_0.VOUT 0.0259f
C114 a_18162_8158# VDD 0
C115 6ph_rosc_0.PH1 6to4_0.inv_PI_d2$1_1.VIN 0
C116 CTRL 6ph_rosc_0.buff_d8$1_1.inv_d8$1_0.VIN 0
C117 6ph_rosc_0.PH3 6ph_rosc_0.psdiff_1.buff_d8$1_1.inv_d2$1_0.VIN 0.00297f
C118 a_18688_7457# VDD 0
C119 6ph_rosc_0.psdiff_1.buff_d8$1_0.inv_d8$1_0.VIN 6ph_rosc_0.psdiff_1.buff_d8$1_0.inv_d2$1_0.VIN 0
C120 6ph_rosc_0.PH2 6to4_0.buff_PI_d32_3.buff_PI_d16$1_0.inv_PI_d4$1_0.VOUT 0.00102f
C121 6to4_0.buff_PI_d32_1.buff_PI_d16$1_0.inv_PI_d4$1_0.VOUT a_7116_10962# -0
C122 6ph_rosc_0.buff_d8$1_5.inv_d8$1_0.VIN 6ph_rosc_0.psdiff_2.VOUTDN 0.00179f
C123 a_18688_6756# VDD 0
C124 6ph_rosc_0.psdiff_1.VOUTDN a_10530_2939# -0
C125 6ph_rosc_0.psdiff_1.VOUTDN 6ph_rosc_0.psdiff_0.buff_d8$1_0.inv_d8$1_0.VIN 0.01332f
C126 6ph_rosc_0.psdiff_2.buff_d8$1_1.inv_d8$1_0.VIN a_6156_2338# 0.02805f
C127 6ph_rosc_0.PH1 a_10942_3640# 0
C128 a_18688_9560# VDD 0
C129 a_16058_11663# VDD 0
C130 a_18688_8859# VDD 0
C131 a_12104_2338# VDD 0.58751f
C132 a_5012_10261# VDD 0
C133 6ph_rosc_0.PH1 6ph_rosc_0.psdiff_1.VOUTDN 0.1399f
C134 6to4_0.buff_PI_d32_1.buff_PI_d16$1_0.inv_PI_d4$1_0.VOUT VDD 3.68536f
C135 6to4_0.buff_PI_d32_1.inv_PI_d32_0.VIN a_16584_10261# 0
C136 6to4_0.PI_clk_1.inv_PI_d2$1_0.VOUT VDD 1.68001f
C137 6ph_rosc_0.psdiff_1.VOUTDN a_11302_3640# -0
C138 6ph_rosc_0.PH3 a_7968_3640# 0
C139 6ph_rosc_0.PH4 6ph_rosc_0.buff_d8$1_5.inv_d8$1_0.VIN 0.00313f
C140 6ph_rosc_0.psdiff_0.buff_d8$1_1.inv_d8$1_0.VIN a_12104_2338# 0.02805f
C141 6ph_rosc_0.psdiff_1.buff_d8$1_0.inv_d8$1_0.VIN VDD 1.46753f
C142 6ph_rosc_0.buff_d8$1_2.inv_d2$1_0.VIN 6ph_rosc_0.psdiff_1.buff_d8$1_1.inv_d8$1_0.VIN 0.00139f
C143 6ph_rosc_0.psdiff_2.CLKN 6ph_rosc_0.psdiff_0.buff_d8$1_0.inv_d8$1_0.VIN 1.00591f
C144 a_16058_10261# VDD 0
C145 6ph_rosc_0.psdiff_2.CLKN 6ph_rosc_0.buff_d8$1_3.inv_d8$1_0.VIN 0.06484f
C146 6ph_rosc_0.psdiff_1.VOUTDP 6ph_rosc_0.psdiff_0.buff_d8$1_0.inv_d4$1_0.VIN 0.01299f
C147 6to4_0.inv_PI_d2$1_2.VOUT VDD 1.93257f
C148 6ph_rosc_0.psdiff_2.VOUTDN 6ph_rosc_0.psdiff_1.buff_d8$1_0.inv_d8$1_0.VIN 0.01332f
C149 6ph_rosc_0.PH5 6ph_rosc_0.psdiff_2.CLKN 0
C150 6ph_rosc_0.PH3 6ph_rosc_0.buff_d8$1_5.inv_d8$1_0.VIN 0.01375f
C151 6ph_rosc_0.buff_d8$1_5.inv_d8$1_0.VIN 6ph_rosc_0.psdiff_2.buff_d8$1_1.inv_d2$1_0.VIN 0.01857f
C152 6ph_rosc_0.PH1 6ph_rosc_0.psdiff_2.CLKN 0.02397f
C153 PH90 VDD 10.0771f
C154 6ph_rosc_0.buff_d8$1_3.inv_d4$1_0.VIN 6ph_rosc_0.buff_d8$1_3.inv_d8$1_0.VIN 0.49436f
C155 6to4_0.inv_PI_d2$1_3.VOUT 6to4_0.buff_PI_d32_3.buff_PI_d16$1_0.inv_PI_d4$1_0.VIN 0
C156 6ph_rosc_0.psdiff_2.CLKP a_6846_3640# -0
C157 a_3960_15168# VDD -0
C158 6to4_0.buff_PI_d32_2.inv_PI_d16$1_0.VIN a_10798_13766# -0
C159 a_4486_10962# VDD 0
C160 6ph_rosc_0.psdiff_1.VOUTDP 6ph_rosc_0.buff_d8$1_1.inv_d2$1_0.VIN 0.00942f
C161 a_18162_15168# VDD 0
C162 6ph_rosc_0.PH1 6ph_rosc_0.buff_d8$1_3.inv_d4$1_0.VIN 0
C163 PH180 VDD 9.94055f
C164 6ph_rosc_0.buff_d8$1_1.inv_d8$1_0.VIN VDD 1.21278f
C165 6ph_rosc_0.psdiff_1.VOUTDP 6ph_rosc_0.psdiff_0.buff_d8$1_0.inv_d2$1_0.VIN 0.01074f
C166 6ph_rosc_0.PH4 6to4_0.PI_clk_1.inv_PI_d2$1_0.VOUT 0.51063f
C167 a_8168_10962# VDD 0
C168 6to4_0.flywheel_clk_0.PH0 VDD 1.63914f
C169 6to4_0.buff_PI_d32_2.buff_PI_d16$1_0.inv_PI_d4$1_0.VIN 6to4_0.buff_PI_d32_2.VIN 0.46062f
C170 6ph_rosc_0.buff_d8$1_4.inv_d8$1_0.VIN 6ph_rosc_0.buff_d8$1_3.inv_d2$1_0.VIN 0
C171 6ph_rosc_0.psdiff_1.buff_d8$1_1.inv_d4$1_0.VIN a_7973_2194# 0.01613f
C172 a_17636_15869# VDD 0
C173 a_11850_10962# VDD 0
C174 CTRL 6ph_rosc_0.buff_d8$1_5.inv_d4$1_0.VIN 0.01928f
C175 a_3434_13065# VDD -0
C176 a_7642_13766# VDD 0
C177 6ph_rosc_0.psdiff_2.CLKP 6ph_rosc_0.buff_d8$1_1.inv_d4$1_0.VIN 0.00195f
C178 6to4_0.buff_PI_d32_0.inv_PI_d32_0.VIN a_16584_15869# 0
C179 a_15532_10962# VDD 0
C180 6ph_rosc_0.buff_d8$1_5.inv_d4$1_0.VIN 6ph_rosc_0.buff_d8$1_2.inv_d8$1_0.VIN 0
C181 a_11324_13766# VDD 0
C182 a_19214_10962# VDD 0
C183 6ph_rosc_0.PH4 6to4_0.inv_PI_d2$1_2.VOUT 0.00126f
C184 a_6590_16570# VDD 0
C185 6to4_0.buff_PI_d32_0.inv_PI_d32_0.VIN VDD 16.5187f
C186 6ph_rosc_0.psdiff_1.buff_d8$1_1.inv_d8$1_0.VIN a_7973_2194# 0
C187 6ph_rosc_0.psdiff_2.CLKP 6ph_rosc_0.buff_d8$1_3.inv_d2$1_0.VIN 0
C188 CTRL a_9130_2338# 0.08994f
C189 6ph_rosc_0.PH3 6ph_rosc_0.psdiff_1.buff_d8$1_0.inv_d8$1_0.VIN 0.00429f
C190 a_10272_16570# VDD 0
C191 6to4_0.buff_PI_d32_1.buff_PI_d16$1_0.inv_PI_d4$1_0.VOUT 6to4_0.buff_PI_d32_1.buff_PI_d16$1_0.inv_PI_d4$1_0.VIN 0.99121f
C192 a_9038_2939# VDD 0
C193 6ph_rosc_0.PH5 6ph_rosc_0.buff_d8$1_0.inv_d4$1_0.VIN 0.02225f
C194 a_18162_13065# VDD 0
C195 6ph_rosc_0.psdiff_2.CLKP a_7973_2194# 0.00645f
C196 a_9130_2338# 6ph_rosc_0.psdiff_1.buff_d8$1_0.inv_d4$1_0.VIN 0.01515f
C197 a_13954_16570# VDD 0
C198 6to4_0.buff_PI_d32_3.inv_PI_d32_0.VIN VDD 15.9752f
C199 CTRL 6ph_rosc_0.psdiff_1.buff_d8$1_0.inv_d4$1_0.VIN 0.00498f
C200 6to4_0.inv_PI_d2$1_2.VOUT 6ph_rosc_0.PH3 0.00157f
C201 a_17636_12364# VDD 0
C202 CTRL 6ph_rosc_0.buff_d8$1_2.inv_d8$1_0.VIN 0.06594f
C203 6ph_rosc_0.psdiff_2.VOUTDP 6ph_rosc_0.psdiff_0.buff_d8$1_0.inv_d4$1_0.VIN 0
C204 6to4_0.buff_PI_d32_2.VIN 6to4_0.buff_PI_d32_2.buff_PI_d16$1_0.inv_PI_d4$1_0.VOUT 0.09935f
C205 a_17636_16570# VDD 0
C206 a_12104_2338# 6ph_rosc_0.psdiff_1.VOUTDP 0.08242f
C207 6to4_0.buff_PI_d32_3.buff_PI_d16$1_0.inv_PI_d4$1_0.VIN VDD 1.64422f
C208 6ph_rosc_0.PH5 6ph_rosc_0.PH0 1.90232f
C209 a_19214_14467# VDD 0
C210 6ph_rosc_0.PH1 6ph_rosc_0.PH0 0.08967f
C211 a_9820_3640# VDD -0
C212 a_6064_8158# VDD 0
C213 a_17110_13766# VDD 0
C214 6ph_rosc_0.psdiff_2.VOUTDN a_7258_3640# -0
C215 6ph_rosc_0.psdiff_2.CLKN a_11285_1011# 0
C216 6to4_0.buff_PI_d32_1.buff_PI_d16$1_0.inv_PI_d4$1_0.VIN 6to4_0.inv_PI_d2$1_2.VOUT 0.00104f
C217 a_9746_8158# VDD 0
C218 CTRL 6ph_rosc_0.psdiff_1.buff_d8$1_0.inv_d2$1_0.VIN 0.00172f
C219 6ph_rosc_0.psdiff_2.VOUTDP 6ph_rosc_0.buff_d8$1_1.inv_d2$1_0.VIN 0.00628f
C220 a_12434_3640# VDD -0
C221 6ph_rosc_0.psdiff_1.VOUTDP a_7951_1011# -0
C222 PH0 a_19214_10261# -0
C223 a_13428_8158# VDD 0
C224 6ph_rosc_0.psdiff_1.VOUTDP 6ph_rosc_0.psdiff_1.buff_d8$1_0.inv_d8$1_0.VIN 1.00829f
C225 6ph_rosc_0.psdiff_1.buff_d8$1_0.inv_d4$1_0.VIN 6ph_rosc_0.psdiff_1.buff_d8$1_0.inv_d2$1_0.VIN 0.25118f
C226 6ph_rosc_0.buff_d8$1_0.inv_d4$1_0.VIN 6ph_rosc_0.buff_d8$1_0.inv_d2$1_0.VIN 0.25118f
C227 a_17110_8158# VDD 0
C228 6ph_rosc_0.buff_d8$1_5.inv_d4$1_0.VIN VDD 0.62468f
C229 6to4_0.buff_PI_d32_1.buff_PI_d16$1_0.inv_PI_d4$1_0.VOUT 6to4_0.flywheel_clk_1.PH0 0.06124f
C230 6ph_rosc_0.psdiff_1.VOUTDP a_13189_1011# -0
C231 a_17636_7457# VDD 0
C232 6to4_0.buff_PI_d32_2.inv_PI_d16$1_0.VIN PH270 0
C233 6to4_0.buff_PI_d32_1.inv_PI_d16$1_0.VIN PH0 0
C234 a_17636_6756# VDD 0
C235 6ph_rosc_0.buff_d8$1_5.inv_d4$1_0.VIN 6ph_rosc_0.psdiff_2.VOUTDN 0.04552f
C236 CTRL 6ph_rosc_0.buff_d8$1_4.inv_d4$1_0.VIN 0.00274f
C237 6to4_0.PI_clk_1.inv_PI_d2$1_0.VOUT 6ph_rosc_0.PH2 0
C238 a_17636_9560# VDD 0
C239 6to4_0.PI_clk_0.inv_PI_d2$1_0.VOUT 6to4_0.buff_PI_d32_2.VIN 0.00916f
C240 CTRL 6ph_rosc_0.psdiff_0.buff_d8$1_1.inv_d4$1_0.VIN 0.0038f
C241 6ph_rosc_0.PH4 6to4_0.buff_PI_d32_3.buff_PI_d16$1_0.inv_PI_d4$1_0.VIN 0.00309f
C242 6ph_rosc_0.psdiff_2.buff_d8$1_1.inv_d8$1_0.VIN 6ph_rosc_0.psdiff_2.CLKN 0.00273f
C243 a_17636_8859# VDD 0
C244 6to4_0.buff_PI_d32_0.buff_PI_d16$1_0.inv_PI_d4$1_0.VOUT a_7116_16570# -0
C245 6ph_rosc_0.psdiff_1.VOUTDN 6ph_rosc_0.buff_d8$1_1.inv_d2$1_0.VIN 0.00112f
C246 6ph_rosc_0.psdiff_1.VOUTDP 6ph_rosc_0.buff_d8$1_1.inv_d8$1_0.VIN 0.07631f
C247 6to4_0.buff_PI_d32_3.inv_PI_d32_0.VIN a_16584_7457# 0
C248 a_9130_2338# VDD 0.58802f
C249 CTRL VDD 8.15832f
C250 a_18688_11663# VDD 0
C251 6to4_0.inv_PI_d2$1_3.VOUT VDD 1.02009f
C252 6ph_rosc_0.PH0 6to4_0.buff_PI_d32_3.buff_PI_d16$1_0.inv_PI_d4$1_0.VOUT 0
C253 6to4_0.flywheel_clk_1.PH0 6to4_0.inv_PI_d2$1_2.VOUT 0.87892f
C254 6ph_rosc_0.psdiff_1.buff_d8$1_0.inv_d4$1_0.VIN VDD 0.59837f
C255 CTRL 6ph_rosc_0.psdiff_2.VOUTDN 0.13703f
C256 6ph_rosc_0.PH2 6to4_0.inv_PI_d2$1_2.VOUT 0.00213f
C257 6ph_rosc_0.psdiff_2.CLKN 6ph_rosc_0.psdiff_0.buff_d8$1_0.inv_d4$1_0.VIN 0
C258 6ph_rosc_0.buff_d8$1_2.inv_d8$1_0.VIN VDD 1.52683f
C259 CTRL a_8266_2939# -0
C260 6ph_rosc_0.PH3 6to4_0.buff_PI_d32_3.buff_PI_d16$1_0.inv_PI_d4$1_0.VIN 0.00214f
C261 CTRL 6ph_rosc_0.psdiff_0.buff_d8$1_1.inv_d8$1_0.VIN 0
C262 6ph_rosc_0.PH4 6ph_rosc_0.buff_d8$1_5.inv_d4$1_0.VIN 0.00282f
C263 6to4_0.buff_PI_d32_2.inv_PI_d16$1_0.VIN 6to4_0.buff_PI_d32_2.inv_PI_d32_0.VIN 3.70287f
C264 6ph_rosc_0.psdiff_2.VOUTDN 6ph_rosc_0.buff_d8$1_2.inv_d8$1_0.VIN 0.04405f
C265 6to4_0.buff_PI_d32_1.inv_PI_d16$1_0.VIN 6to4_0.buff_PI_d32_1.inv_PI_d32_0.VIN 3.70287f
C266 PH90 a_19214_15869# -0
C267 6ph_rosc_0.psdiff_2.VOUTDP a_5337_1011# 0
C268 a_12417_1011# VDD 0
C269 a_18688_10261# VDD 0
C270 6ph_rosc_0.psdiff_2.CLKN 6ph_rosc_0.buff_d8$1_1.inv_d2$1_0.VIN 0.15482f
C271 6ph_rosc_0.psdiff_2.CLKP 6ph_rosc_0.psdiff_0.buff_d8$1_0.inv_d8$1_0.VIN 0.00696f
C272 6to4_0.buff_PI_d32_1.buff_PI_d16$1_0.inv_PI_d4$1_0.VOUT 6to4_0.inv_PI_d2$1_1.VIN 0.06379f
C273 6to4_0.PI_clk_1.inv_PI_d2$1_0.VOUT a_3434_12364# -0
C274 6ph_rosc_0.psdiff_1.buff_d8$1_0.inv_d2$1_0.VIN VDD 0.25752f
C275 6to4_0.buff_PI_d32_2.VIN a_3434_15168# -0
C276 6ph_rosc_0.PH1 6ph_rosc_0.psdiff_1.buff_d8$1_1.inv_d8$1_0.VIN 0.03874f
C277 6ph_rosc_0.psdiff_2.CLKP 6ph_rosc_0.buff_d8$1_3.inv_d8$1_0.VIN 0
C278 CTRL 6ph_rosc_0.psdiff_2.buff_d8$1_0.inv_d8$1_0.VIN 0.03636f
C279 6ph_rosc_0.PH1 6to4_0.PI_clk_0.inv_PI_d2$1_0.VOUT 0.51063f
C280 6to4_0.flywheel_clk_0.PH0 6ph_rosc_0.PH2 0
C281 6ph_rosc_0.PH1 a_10947_2194# 0.00121f
C282 6ph_rosc_0.psdiff_2.VOUTDP 6ph_rosc_0.psdiff_1.buff_d8$1_0.inv_d8$1_0.VIN 0.00561f
C283 6ph_rosc_0.PH1 6ph_rosc_0.psdiff_0.buff_d8$1_1.inv_d2$1_0.VIN 0.00297f
C284 6ph_rosc_0.PH3 6ph_rosc_0.buff_d8$1_5.inv_d4$1_0.VIN 0.02225f
C285 6ph_rosc_0.PH5 6ph_rosc_0.psdiff_2.CLKP 0.18066f
C286 6ph_rosc_0.PH1 6ph_rosc_0.psdiff_2.CLKP 0.018f
C287 6ph_rosc_0.PH4 CTRL 0.87137f
C288 6to4_0.buff_PI_d32_1.inv_PI_d32_0.VIN a_15006_10962# -0
C289 6ph_rosc_0.PH0 6ph_rosc_0.psdiff_2.buff_d8$1_1.inv_d4$1_0.VIN 0
C290 a_17110_15168# VDD 0
C291 6ph_rosc_0.buff_d8$1_5.inv_d2$1_0.VIN 6ph_rosc_0.psdiff_2.buff_d8$1_1.inv_d8$1_0.VIN 0.00139f
C292 6ph_rosc_0.PH4 6to4_0.inv_PI_d2$1_3.VOUT 0.00187f
C293 a_7116_10962# VDD 0
C294 a_16584_15869# VDD 0
C295 6ph_rosc_0.PH4 6ph_rosc_0.buff_d8$1_2.inv_d8$1_0.VIN 0.94899f
C296 a_10798_10962# VDD 0
C297 6ph_rosc_0.buff_d8$1_4.inv_d4$1_0.VIN VDD 0.52326f
C298 a_6590_13766# VDD 0
C299 6ph_rosc_0.PH3 CTRL 0.77911f
C300 6ph_rosc_0.psdiff_0.buff_d8$1_1.inv_d4$1_0.VIN VDD 0.6697f
C301 6ph_rosc_0.psdiff_2.buff_d8$1_0.inv_d2$1_0.VIN 6ph_rosc_0.psdiff_1.buff_d8$1_0.inv_d8$1_0.VIN 0
C302 a_14480_10962# VDD 0
C303 CTRL 6ph_rosc_0.psdiff_2.buff_d8$1_1.inv_d2$1_0.VIN 0.00105f
C304 6ph_rosc_0.psdiff_1.VOUTDP a_7179_310# -0
C305 6ph_rosc_0.psdiff_2.VOUTDP 6ph_rosc_0.buff_d8$1_1.inv_d8$1_0.VIN 0
C306 6ph_rosc_0.PH0 6ph_rosc_0.psdiff_2.buff_d8$1_1.inv_d8$1_0.VIN 0.00123f
C307 6ph_rosc_0.PH3 6to4_0.inv_PI_d2$1_3.VOUT 0.43737f
C308 6to4_0.buff_PI_d32_0.buff_PI_d16$1_0.inv_PI_d4$1_0.VOUT 6to4_0.PI_clk_0.inv_PI_d2$1_0.VOUT 0.00245f
C309 a_10272_13766# VDD 0
C310 PH90 a_19214_16570# -0
C311 a_18162_10962# VDD 0
C312 6ph_rosc_0.buff_d8$1_0.inv_d2$1_0.VIN 6ph_rosc_0.psdiff_2.CLKP 0.17391f
C313 6ph_rosc_0.PH3 6ph_rosc_0.buff_d8$1_2.inv_d8$1_0.VIN 0.00419f
C314 a_5538_16570# VDD 0
C315 6ph_rosc_0.psdiff_0.buff_d8$1_1.inv_d4$1_0.VIN 6ph_rosc_0.psdiff_0.buff_d8$1_1.inv_d8$1_0.VIN 0.49436f
C316 CTRL a_6156_2338# 0.08994f
C317 6ph_rosc_0.psdiff_2.VOUTDN VDD 1.28481f
C318 a_9220_16570# VDD 0
C319 6ph_rosc_0.PH2 6to4_0.buff_PI_d32_3.buff_PI_d16$1_0.inv_PI_d4$1_0.VIN 0.00525f
C320 6ph_rosc_0.psdiff_0.buff_d8$1_1.inv_d8$1_0.VIN VDD 1.40639f
C321 a_17110_13065# VDD 0
C322 6ph_rosc_0.psdiff_2.CLKP a_4999_2194# 0.08404f
C323 6ph_rosc_0.psdiff_2.buff_d8$1_0.inv_d8$1_0.VIN 6ph_rosc_0.buff_d8$1_4.inv_d4$1_0.VIN 0.02576f
C324 a_12902_16570# VDD 0
C325 a_16584_12364# VDD 0
C326 6to4_0.buff_PI_d32_0.inv_PI_d16$1_0.VIN a_10798_16570# -0
C327 PH270 PH0 0.00319f
C328 a_16584_16570# VDD 0
C329 a_6486_3640# VDD -0
C330 CTRL 6ph_rosc_0.buff_d8$1_2.inv_d4$1_0.VIN 0.01928f
C331 CTRL 6ph_rosc_0.psdiff_1.VOUTDP 0.15174f
C332 6ph_rosc_0.psdiff_1.VOUTDN 6ph_rosc_0.buff_d8$1_1.inv_d8$1_0.VIN 0
C333 6ph_rosc_0.psdiff_2.buff_d8$1_0.inv_d8$1_0.VIN VDD 1.46194f
C334 a_9048_3640# VDD 0
C335 a_5012_8158# VDD 0
C336 a_18162_14467# VDD 0
C337 6ph_rosc_0.psdiff_2.CLKN 6ph_rosc_0.psdiff_1.buff_d8$1_0.inv_d8$1_0.VIN 0.05771f
C338 a_16058_13766# VDD 0
C339 6ph_rosc_0.psdiff_2.CLKN a_10513_1011# 0
C340 a_5538_7457# VDD 0
C341 6ph_rosc_0.buff_d8$1_5.inv_d8$1_0.VIN 6ph_rosc_0.buff_d8$1_5.inv_d2$1_0.VIN 0
C342 6ph_rosc_0.psdiff_1.VOUTDP 6ph_rosc_0.psdiff_1.buff_d8$1_0.inv_d4$1_0.VIN 0.00265f
C343 6ph_rosc_0.buff_d8$1_2.inv_d8$1_0.VIN 6ph_rosc_0.buff_d8$1_2.inv_d4$1_0.VIN 0.49436f
C344 a_11662_3640# VDD -0
C345 a_8694_8158# VDD 0
C346 6ph_rosc_0.PH4 VDD 3.90306f
C347 6to4_0.PI_clk_0.inv_PI_d2$1_0.VOUT 6to4_0.buff_PI_d32_0.buff_PI_d16$1_0.inv_PI_d4$1_0.VIN 0.00968f
C348 PH180 a_19214_7457# -0
C349 6ph_rosc_0.psdiff_1.buff_d8$1_0.inv_d8$1_0.VIN 6ph_rosc_0.buff_d8$1_3.inv_d4$1_0.VIN 0.02568f
C350 a_12376_8158# VDD 0
C351 6ph_rosc_0.PH3 6ph_rosc_0.buff_d8$1_4.inv_d4$1_0.VIN 0
C352 PH180 a_19214_6756# -0
C353 6ph_rosc_0.PH4 6ph_rosc_0.psdiff_2.VOUTDN 0.0042f
C354 6to4_0.PI_clk_0.inv_PI_d2$1_0.VOUT a_4732_15168# -0
C355 a_16058_8158# VDD 0
C356 6ph_rosc_0.psdiff_1.buff_d8$1_1.inv_d2$1_0.VIN 6ph_rosc_0.psdiff_1.buff_d8$1_1.inv_d4$1_0.VIN 0.25118f
C357 6ph_rosc_0.PH1 6ph_rosc_0.buff_d8$1_2.inv_d2$1_0.VIN 0.04119f
C358 6ph_rosc_0.PH0 6ph_rosc_0.buff_d8$1_5.inv_d8$1_0.VIN 0.94899f
C359 a_16584_7457# VDD 0
C360 6ph_rosc_0.psdiff_2.CLKP 6ph_rosc_0.psdiff_2.buff_d8$1_1.inv_d4$1_0.VIN 0.00194f
C361 6ph_rosc_0.psdiff_1.VOUTDP 6ph_rosc_0.psdiff_1.buff_d8$1_0.inv_d2$1_0.VIN 0
C362 6to4_0.buff_PI_d32_2.inv_PI_d32_0.VIN PH270 7.50825f
C363 6ph_rosc_0.PH3 VDD 4.15625f
C364 6ph_rosc_0.PH2 CTRL 0.86604f
C365 6ph_rosc_0.psdiff_2.buff_d8$1_1.inv_d2$1_0.VIN VDD 0.34536f
C366 6ph_rosc_0.psdiff_2.CLKN 6ph_rosc_0.buff_d8$1_1.inv_d8$1_0.VIN 0.00515f
C367 6to4_0.buff_PI_d32_2.inv_PI_d32_0.VIN PH0 0.01008f
C368 PH270 6to4_0.buff_PI_d32_1.inv_PI_d32_0.VIN 0.00164f
C369 CTRL 6ph_rosc_0.buff_d8$1_0.inv_d8$1_0.VIN 0.06517f
C370 a_16584_6756# VDD 0
C371 6ph_rosc_0.PH2 6to4_0.inv_PI_d2$1_3.VOUT 0.00267f
C372 6to4_0.buff_PI_d32_1.inv_PI_d32_0.VIN PH0 7.50825f
C373 a_16584_9560# VDD 0
C374 6ph_rosc_0.PH3 6ph_rosc_0.psdiff_2.VOUTDN 0.1399f
C375 6ph_rosc_0.psdiff_0.buff_d8$1_0.inv_d8$1_0.VIN 6ph_rosc_0.buff_d8$1_1.inv_d4$1_0.VIN 0.02576f
C376 6to4_0.buff_PI_d32_3.inv_PI_d32_0.VIN a_15006_8158# -0
C377 6ph_rosc_0.PH2 6ph_rosc_0.buff_d8$1_2.inv_d8$1_0.VIN 0.00313f
C378 a_16584_8859# VDD 0
C379 6ph_rosc_0.buff_d8$1_2.inv_d8$1_0.VIN 6ph_rosc_0.buff_d8$1_0.inv_d8$1_0.VIN 0
C380 6ph_rosc_0.psdiff_1.buff_d8$1_1.inv_d2$1_0.VIN 6ph_rosc_0.psdiff_1.buff_d8$1_1.inv_d8$1_0.VIN 0
C381 a_9038_5604# VDD 0
C382 a_6156_2338# VDD 0.58802f
C383 a_17636_11663# VDD 0
C384 6to4_0.buff_PI_d32_1.buff_PI_d16$1_0.inv_PI_d4$1_0.VIN VDD 1.59141f
C385 6to4_0.PI_clk_1.inv_PI_d2$1_0.VOUT 6to4_0.buff_PI_d32_2.buff_PI_d16$1_0.inv_PI_d4$1_0.VIN 0.0099f
C386 6ph_rosc_0.PH5 6ph_rosc_0.buff_d8$1_1.inv_d4$1_0.VIN 0
C387 6ph_rosc_0.psdiff_2.CLKP 6ph_rosc_0.psdiff_2.buff_d8$1_1.inv_d8$1_0.VIN 0.00464f
C388 6ph_rosc_0.psdiff_2.VOUTDN a_6156_2338# 0.009f
C389 6ph_rosc_0.psdiff_2.CLKP 6ph_rosc_0.psdiff_1.buff_d8$1_1.inv_d2$1_0.VIN 0
C390 6ph_rosc_0.buff_d8$1_3.inv_d2$1_0.VIN 6ph_rosc_0.buff_d8$1_3.inv_d8$1_0.VIN 0
C391 a_6469_1011# VDD 0
C392 6to4_0.flywheel_clk_0.PH0 a_3434_15869# 0
C393 6ph_rosc_0.PH3 6ph_rosc_0.psdiff_2.buff_d8$1_0.inv_d8$1_0.VIN 0
C394 CTRL 6ph_rosc_0.psdiff_2.VOUTDP 0.18984f
C395 a_9130_2338# 6ph_rosc_0.psdiff_2.VOUTDP 0.08242f
C396 6ph_rosc_0.buff_d8$1_2.inv_d4$1_0.VIN VDD 0.62468f
C397 6ph_rosc_0.psdiff_1.VOUTDP VDD 1.57846f
C398 6ph_rosc_0.psdiff_2.CLKP 6ph_rosc_0.psdiff_0.buff_d8$1_0.inv_d4$1_0.VIN 0.00398f
C399 CTRL 6ph_rosc_0.psdiff_2.buff_d8$1_0.inv_d4$1_0.VIN 0.00498f
C400 6ph_rosc_0.PH4 6ph_rosc_0.PH3 2.93596f
C401 6to4_0.buff_PI_d32_2.inv_PI_d32_0.VIN 6to4_0.buff_PI_d32_1.inv_PI_d32_0.VIN 0.24833f
C402 a_11645_1011# VDD 0
C403 a_17636_10261# VDD 0
C404 6ph_rosc_0.psdiff_2.VOUTDP 6ph_rosc_0.psdiff_1.buff_d8$1_0.inv_d4$1_0.VIN 0.01111f
C405 6ph_rosc_0.psdiff_2.VOUTDN 6ph_rosc_0.psdiff_1.VOUTDP 0.00405f
C406 a_6156_2338# 6ph_rosc_0.psdiff_2.buff_d8$1_0.inv_d8$1_0.VIN 0.01471f
C407 CTRL a_8328_3640# -0
C408 6ph_rosc_0.psdiff_0.buff_d8$1_1.inv_d8$1_0.VIN 6ph_rosc_0.psdiff_1.VOUTDP 0.00273f
C409 6ph_rosc_0.PH0 6to4_0.inv_PI_d2$1_2.VOUT 0
C410 6ph_rosc_0.psdiff_2.CLKP 6ph_rosc_0.buff_d8$1_1.inv_d2$1_0.VIN 0
C411 6ph_rosc_0.psdiff_2.CLKP 6ph_rosc_0.psdiff_0.buff_d8$1_0.inv_d2$1_0.VIN 0.00138f
C412 CTRL 6ph_rosc_0.psdiff_2.buff_d8$1_0.inv_d2$1_0.VIN 0.00172f
C413 6ph_rosc_0.PH2 6ph_rosc_0.psdiff_0.buff_d8$1_1.inv_d4$1_0.VIN 0
C414 a_16058_15168# VDD 0
C415 6to4_0.flywheel_clk_1.PH0 VDD 1.63832f
C416 6to4_0.PI_clk_1.inv_PI_d2$1_0.VOUT 6to4_0.buff_PI_d32_2.buff_PI_d16$1_0.inv_PI_d4$1_0.VOUT 0.00245f
C417 a_19214_13766# PH270 -0
C418 6ph_rosc_0.buff_d8$1_0.inv_d8$1_0.VIN 6ph_rosc_0.psdiff_0.buff_d8$1_1.inv_d4$1_0.VIN 0.02575f
C419 6ph_rosc_0.psdiff_2.VOUTDP 6ph_rosc_0.psdiff_1.buff_d8$1_0.inv_d2$1_0.VIN 0.01f
C420 a_6064_10962# VDD 0
C421 6ph_rosc_0.psdiff_1.VOUTDN a_9130_2338# 0.009f
C422 6ph_rosc_0.PH2 VDD 3.8472f
C423 CTRL 6ph_rosc_0.psdiff_1.VOUTDN 0.13404f
C424 6ph_rosc_0.buff_d8$1_0.inv_d8$1_0.VIN VDD 1.52624f
C425 a_9746_10962# VDD 0
C426 6ph_rosc_0.psdiff_2.CLKP a_13206_3640# -0
C427 a_19214_15869# VDD 0
C428 a_5538_13766# VDD 0
C429 6ph_rosc_0.PH3 a_6156_2338# 0.00874f
C430 6ph_rosc_0.PH4 6ph_rosc_0.buff_d8$1_2.inv_d4$1_0.VIN 0
C431 a_16584_13065# 6to4_0.buff_PI_d32_2.inv_PI_d32_0.VIN 0
C432 a_13428_10962# VDD 0
C433 6ph_rosc_0.buff_d8$1_2.inv_d8$1_0.VIN 6ph_rosc_0.psdiff_1.VOUTDN 0.00179f
C434 6ph_rosc_0.buff_d8$1_5.inv_d8$1_0.VIN 6ph_rosc_0.psdiff_2.CLKP 0
C435 6ph_rosc_0.PH2 6ph_rosc_0.psdiff_0.buff_d8$1_1.inv_d8$1_0.VIN 0.00123f
C436 a_9220_13766# VDD 0
C437 6ph_rosc_0.buff_d8$1_0.inv_d8$1_0.VIN 6ph_rosc_0.psdiff_0.buff_d8$1_1.inv_d8$1_0.VIN 0.04417f
C438 a_17110_10962# VDD 0
C439 6ph_rosc_0.psdiff_2.VOUTDP a_4863_310# -0
C440 a_12902_13766# VDD 0
C441 a_4486_16570# VDD 0
C442 6ph_rosc_0.psdiff_2.VOUTDP 6ph_rosc_0.buff_d8$1_4.inv_d4$1_0.VIN 0.09061f
C443 6ph_rosc_0.PH3 6ph_rosc_0.psdiff_1.VOUTDP 0.01254f
C444 a_8168_16570# VDD 0
C445 a_10947_2194# a_12104_2338# 0.01277f
C446 a_16058_13065# VDD 0
C447 CTRL 6ph_rosc_0.psdiff_2.CLKN 0.31851f
C448 6ph_rosc_0.psdiff_2.VOUTDP VDD 1.50625f
C449 a_11850_16570# VDD 0
C450 6to4_0.flywheel_clk_0.PH0 6to4_0.buff_PI_d32_2.buff_PI_d16$1_0.inv_PI_d4$1_0.VOUT 0.03047f
C451 6ph_rosc_0.PH5 6to4_0.buff_PI_d32_2.VIN 0
C452 6ph_rosc_0.psdiff_2.buff_d8$1_0.inv_d4$1_0.VIN VDD 0.5982f
C453 a_3434_12364# VDD -0
C454 6ph_rosc_0.psdiff_2.VOUTDN a_7556_2939# -0
C455 6ph_rosc_0.PH4 6ph_rosc_0.PH2 0.20744f
C456 6ph_rosc_0.psdiff_2.CLKP a_12104_2338# 0.01643f
C457 6ph_rosc_0.psdiff_2.CLKN 6ph_rosc_0.psdiff_1.buff_d8$1_0.inv_d4$1_0.VIN 0.00378f
C458 a_15532_16570# VDD 0
C459 a_5714_3640# VDD -0
C460 6to4_0.inv_PI_d2$1_1.VIN VDD 1.02281f
C461 6ph_rosc_0.psdiff_2.VOUTDN 6ph_rosc_0.psdiff_2.VOUTDP 0.03282f
C462 CTRL 6ph_rosc_0.buff_d8$1_3.inv_d4$1_0.VIN 0.00135f
C463 a_19214_12364# VDD 0
C464 6ph_rosc_0.psdiff_2.CLKN a_7241_1011# -0
C465 a_19214_16570# VDD 0
C466 a_17110_14467# VDD 0
C467 a_15006_13766# VDD 0
C468 6ph_rosc_0.PH0 6to4_0.buff_PI_d32_3.buff_PI_d16$1_0.inv_PI_d4$1_0.VIN 0
C469 a_7642_8158# VDD 0
C470 a_10942_3640# VDD 0
C471 a_18688_13766# VDD 0
C472 6ph_rosc_0.psdiff_2.CLKP 6ph_rosc_0.psdiff_1.buff_d8$1_0.inv_d8$1_0.VIN 0
C473 6ph_rosc_0.buff_d8$1_5.inv_d4$1_0.VIN 6ph_rosc_0.buff_d8$1_5.inv_d2$1_0.VIN 0.25118f
C474 6ph_rosc_0.psdiff_2.VOUTDN a_8328_3640# -0
C475 6ph_rosc_0.psdiff_2.buff_d8$1_0.inv_d2$1_0.VIN VDD 0.25757f
C476 CTRL 6ph_rosc_0.buff_d8$1_4.inv_d2$1_0.VIN 0.00241f
C477 6ph_rosc_0.psdiff_1.VOUTDN 6ph_rosc_0.psdiff_0.buff_d8$1_1.inv_d4$1_0.VIN 0.01001f
C478 6ph_rosc_0.PH2 6ph_rosc_0.PH3 0.0981f
C479 a_11324_8158# VDD 0
C480 6ph_rosc_0.psdiff_2.CLKN 6ph_rosc_0.psdiff_1.buff_d8$1_0.inv_d2$1_0.VIN 0.01541f
C481 6ph_rosc_0.psdiff_2.VOUTDP 6ph_rosc_0.psdiff_2.buff_d8$1_0.inv_d8$1_0.VIN 1.00502f
C482 6ph_rosc_0.PH5 6ph_rosc_0.psdiff_0.buff_d8$1_0.inv_d8$1_0.VIN 0
C483 6ph_rosc_0.psdiff_1.VOUTDN VDD 1.28481f
C484 6to4_0.PI_clk_0.inv_PI_d2$1_0.VOUT a_3960_15168# 0
C485 6ph_rosc_0.psdiff_2.buff_d8$1_0.inv_d8$1_0.VIN 6ph_rosc_0.psdiff_2.buff_d8$1_0.inv_d4$1_0.VIN 0.49436f
C486 6ph_rosc_0.PH1 6ph_rosc_0.psdiff_0.buff_d8$1_0.inv_d8$1_0.VIN 0.00429f
C487 a_15006_8158# VDD 0
C488 6to4_0.flywheel_clk_1.PH0 6to4_0.buff_PI_d32_1.buff_PI_d16$1_0.inv_PI_d4$1_0.VIN 0.44724f
C489 6ph_rosc_0.PH1 6ph_rosc_0.buff_d8$1_3.inv_d8$1_0.VIN 0.93117f
C490 6to4_0.buff_PI_d32_0.buff_PI_d16$1_0.inv_PI_d4$1_0.VOUT 6to4_0.buff_PI_d32_2.VIN 0.00783f
C491 a_18688_8158# VDD 0
C492 6to4_0.buff_PI_d32_1.buff_PI_d16$1_0.inv_PI_d4$1_0.VOUT 6to4_0.buff_PI_d32_1.inv_PI_d16$1_0.VIN 0.02662f
C493 6ph_rosc_0.PH0 6ph_rosc_0.buff_d8$1_5.inv_d4$1_0.VIN 0
C494 6ph_rosc_0.PH5 6ph_rosc_0.PH1 0.00708f
C495 6to4_0.PI_clk_0.inv_PI_d2$1_0.VOUT 6to4_0.flywheel_clk_0.PH0 0.53408f
C496 a_19214_7457# VDD 0
C497 6ph_rosc_0.psdiff_1.VOUTDN 6ph_rosc_0.psdiff_0.buff_d8$1_1.inv_d8$1_0.VIN 0.00391f
C498 CTRL 6ph_rosc_0.buff_d8$1_5.inv_d2$1_0.VIN 0.00555f
C499 6ph_rosc_0.PH4 6to4_0.inv_PI_d2$1_1.VIN 0
C500 CTRL 6ph_rosc_0.buff_d8$1_0.inv_d4$1_0.VIN 0.01437f
C501 a_19214_6756# VDD 0
C502 6ph_rosc_0.psdiff_2.CLKP 6ph_rosc_0.buff_d8$1_1.inv_d8$1_0.VIN 0.00396f
C503 6ph_rosc_0.psdiff_2.CLKN 6ph_rosc_0.buff_d8$1_4.inv_d4$1_0.VIN 0
C504 a_19214_9560# VDD 0
C505 6ph_rosc_0.psdiff_2.buff_d8$1_0.inv_d8$1_0.VIN 6ph_rosc_0.psdiff_2.buff_d8$1_0.inv_d2$1_0.VIN 0
C506 6ph_rosc_0.buff_d8$1_5.inv_d2$1_0.VIN 6ph_rosc_0.buff_d8$1_2.inv_d8$1_0.VIN 0
C507 6ph_rosc_0.PH3 6ph_rosc_0.psdiff_2.VOUTDP 0.00391f
C508 a_16584_11663# VDD 0
C509 6ph_rosc_0.psdiff_1.buff_d8$1_1.inv_d2$1_0.VIN a_7973_2194# 0.00545f
C510 6ph_rosc_0.PH2 6ph_rosc_0.buff_d8$1_2.inv_d4$1_0.VIN 0.00282f
C511 6ph_rosc_0.buff_d8$1_1.inv_d2$1_0.VIN 6ph_rosc_0.buff_d8$1_1.inv_d4$1_0.VIN 0.25118f
C512 a_19214_8859# VDD 0
C513 6ph_rosc_0.buff_d8$1_2.inv_d4$1_0.VIN 6ph_rosc_0.buff_d8$1_0.inv_d8$1_0.VIN 0
C514 6ph_rosc_0.PH3 6ph_rosc_0.psdiff_2.buff_d8$1_0.inv_d4$1_0.VIN 0.04895f
C515 6ph_rosc_0.psdiff_2.CLKN VDD 1.6217f
C516 6ph_rosc_0.PH0 CTRL 0.58148f
C517 6ph_rosc_0.PH0 6to4_0.inv_PI_d2$1_3.VOUT 0.00407f
C518 a_5697_1011# VDD 0
C519 6ph_rosc_0.PH4 6ph_rosc_0.psdiff_1.VOUTDN 0
C520 6ph_rosc_0.psdiff_2.VOUTDN 6ph_rosc_0.psdiff_2.CLKN 0.05199f
C521 6ph_rosc_0.PH5 6ph_rosc_0.buff_d8$1_0.inv_d2$1_0.VIN 0.04119f
C522 6ph_rosc_0.buff_d8$1_3.inv_d4$1_0.VIN VDD 0.5268f
C523 6ph_rosc_0.psdiff_2.VOUTDP a_11223_310# -0
C524 6ph_rosc_0.buff_d8$1_4.inv_d2$1_0.VIN 6ph_rosc_0.buff_d8$1_4.inv_d4$1_0.VIN 0.25118f
C525 a_6156_2338# 6ph_rosc_0.psdiff_2.buff_d8$1_0.inv_d4$1_0.VIN 0.01515f
C526 6to4_0.buff_PI_d32_0.buff_PI_d16$1_0.inv_PI_d4$1_0.VOUT 6ph_rosc_0.PH1 0.05402f
C527 6to4_0.buff_PI_d32_0.buff_PI_d16$1_0.inv_PI_d4$1_0.VIN 6to4_0.buff_PI_d32_2.VIN 0.00161f
C528 6ph_rosc_0.PH3 6ph_rosc_0.psdiff_2.buff_d8$1_0.inv_d2$1_0.VIN 0.06557f
C529 a_16584_10261# VDD 0
C530 a_19214_13065# PH270 -0
C531 6ph_rosc_0.psdiff_2.VOUTDN 6ph_rosc_0.buff_d8$1_3.inv_d4$1_0.VIN 0
C532 6to4_0.inv_PI_d2$1_1.VIN 6to4_0.buff_PI_d32_1.buff_PI_d16$1_0.inv_PI_d4$1_0.VIN 0
C533 6ph_rosc_0.PH5 6to4_0.buff_PI_d32_3.buff_PI_d16$1_0.inv_PI_d4$1_0.VOUT 0.01993f
C534 a_3434_15869# VDD -0
C535 6ph_rosc_0.buff_d8$1_4.inv_d2$1_0.VIN VDD 0.24588f
C536 6ph_rosc_0.PH2 6ph_rosc_0.buff_d8$1_0.inv_d8$1_0.VIN 0.94899f
C537 6ph_rosc_0.PH1 6to4_0.buff_PI_d32_3.buff_PI_d16$1_0.inv_PI_d4$1_0.VOUT 0
C538 6ph_rosc_0.psdiff_2.CLKN 6ph_rosc_0.psdiff_2.buff_d8$1_0.inv_d8$1_0.VIN 0.00542f
C539 6ph_rosc_0.psdiff_2.VOUTDP 6ph_rosc_0.psdiff_1.VOUTDP 0.30802f
C540 a_5012_10962# VDD 0
C541 6ph_rosc_0.psdiff_2.CLKP a_9820_3640# -0
C542 a_18688_15168# VDD 0
C543 a_8694_10962# VDD 0
C544 a_4486_13065# 6to4_0.buff_PI_d32_2.VIN -0
C545 6ph_rosc_0.buff_d8$1_5.inv_d2$1_0.VIN VDD 0.26044f
C546 CTRL 6ph_rosc_0.psdiff_1.buff_d8$1_1.inv_d4$1_0.VIN 0.0038f
C547 6ph_rosc_0.buff_d8$1_0.inv_d4$1_0.VIN VDD 0.62357f
C548 a_18162_15869# VDD 0
C549 a_12376_10962# VDD 0
C550 a_3960_13065# VDD -0
C551 6ph_rosc_0.psdiff_1.VOUTDP 6ph_rosc_0.psdiff_2.buff_d8$1_0.inv_d2$1_0.VIN 0.01386f
C552 6to4_0.buff_PI_d32_2.buff_PI_d16$1_0.inv_PI_d4$1_0.VIN VDD 1.56067f
C553 6ph_rosc_0.psdiff_2.buff_d8$1_0.inv_d8$1_0.VIN 6ph_rosc_0.buff_d8$1_4.inv_d2$1_0.VIN 0.01564f
C554 a_8168_13766# VDD 0
C555 6ph_rosc_0.PH1 6to4_0.buff_PI_d32_0.buff_PI_d16$1_0.inv_PI_d4$1_0.VIN 0
C556 6ph_rosc_0.buff_d8$1_5.inv_d2$1_0.VIN 6ph_rosc_0.psdiff_2.VOUTDN 0.17391f
C557 6ph_rosc_0.PH3 6ph_rosc_0.psdiff_2.CLKN 0.11974f
C558 a_16058_10962# VDD 0
C559 CTRL 6ph_rosc_0.buff_d8$1_4.inv_d8$1_0.VIN 0.00546f
C560 6ph_rosc_0.buff_d8$1_2.inv_d4$1_0.VIN 6ph_rosc_0.psdiff_1.VOUTDN 0.04552f
C561 6ph_rosc_0.psdiff_1.VOUTDN 6ph_rosc_0.psdiff_1.VOUTDP 0.03297f
C562 6ph_rosc_0.buff_d8$1_2.inv_d8$1_0.VIN 6ph_rosc_0.psdiff_1.buff_d8$1_1.inv_d4$1_0.VIN 0.02575f
C563 a_11850_13766# VDD 0
C564 6to4_0.inv_PI_d2$1_1.VIN 6to4_0.flywheel_clk_1.PH0 0.45273f
C565 6ph_rosc_0.buff_d8$1_0.inv_d4$1_0.VIN 6ph_rosc_0.psdiff_0.buff_d8$1_1.inv_d8$1_0.VIN 0.00782f
C566 6ph_rosc_0.PH0 VDD 3.52327f
C567 6ph_rosc_0.PH2 6to4_0.inv_PI_d2$1_1.VIN 0
C568 a_7116_16570# VDD 0
C569 CTRL 6ph_rosc_0.psdiff_1.buff_d8$1_1.inv_d8$1_0.VIN 0.00518f
C570 6ph_rosc_0.psdiff_1.buff_d8$1_1.inv_d8$1_0.VIN a_9130_2338# 0.02805f
C571 CTRL a_10947_2194# 0.2274f
C572 a_6156_2338# 6ph_rosc_0.psdiff_2.CLKN 0.08242f
C573 a_9130_2338# a_10947_2194# 0.00571f
C574 6ph_rosc_0.PH0 6ph_rosc_0.psdiff_2.VOUTDN 0
C575 a_10798_16570# VDD 0
C576 CTRL 6ph_rosc_0.psdiff_0.buff_d8$1_1.inv_d2$1_0.VIN 0.01288f
C577 a_18688_13065# VDD 0
C578 6ph_rosc_0.psdiff_1.buff_d8$1_0.inv_d8$1_0.VIN 6ph_rosc_0.buff_d8$1_3.inv_d2$1_0.VIN 0.01571f
C579 CTRL 6ph_rosc_0.psdiff_2.CLKP 2.19073f
C580 6ph_rosc_0.psdiff_2.CLKP a_9130_2338# 0.00743f
C581 6ph_rosc_0.buff_d8$1_2.inv_d8$1_0.VIN 6ph_rosc_0.psdiff_1.buff_d8$1_1.inv_d8$1_0.VIN 0.04417f
C582 a_12012_2939# VDD 0
C583 a_4994_3640# VDD 0
C584 a_14480_16570# VDD 0
C585 a_18162_12364# VDD 0
C586 6ph_rosc_0.PH4 6ph_rosc_0.buff_d8$1_5.inv_d2$1_0.VIN 0.01457f
C587 a_16058_14467# VDD 0
C588 6ph_rosc_0.psdiff_0.buff_d8$1_0.inv_d8$1_0.VIN 6ph_rosc_0.psdiff_0.buff_d8$1_0.inv_d4$1_0.VIN 0.49436f
C589 a_18162_16570# VDD 0
C590 6to4_0.buff_PI_d32_0.buff_PI_d16$1_0.inv_PI_d4$1_0.VOUT 6to4_0.buff_PI_d32_0.buff_PI_d16$1_0.inv_PI_d4$1_0.VIN 0.99121f
C591 a_13954_13766# VDD 0
C592 6ph_rosc_0.psdiff_2.CLKP 6ph_rosc_0.psdiff_1.buff_d8$1_0.inv_d4$1_0.VIN 0
C593 6ph_rosc_0.psdiff_2.CLKN 6ph_rosc_0.psdiff_1.VOUTDP 0.81782f
C594 6ph_rosc_0.PH2 6ph_rosc_0.psdiff_1.VOUTDN 0.0042f
C595 6ph_rosc_0.buff_d8$1_1.inv_d4$1_0.VIN 6ph_rosc_0.buff_d8$1_1.inv_d8$1_0.VIN 0.49436f
C596 6ph_rosc_0.PH4 6to4_0.buff_PI_d32_2.buff_PI_d16$1_0.inv_PI_d4$1_0.VIN 0
C597 6ph_rosc_0.psdiff_1.VOUTDN 6ph_rosc_0.buff_d8$1_0.inv_d8$1_0.VIN 0.04405f
C598 6to4_0.buff_PI_d32_2.buff_PI_d16$1_0.inv_PI_d4$1_0.VOUT VDD 3.68857f
C599 6ph_rosc_0.psdiff_2.VOUTDP 6ph_rosc_0.psdiff_2.buff_d8$1_0.inv_d4$1_0.VIN 0
C600 a_6590_8158# VDD 0
C601 6ph_rosc_0.PH5 6ph_rosc_0.psdiff_0.buff_d8$1_0.inv_d4$1_0.VIN 0.04895f
C602 a_17636_13766# VDD 0
C603 a_10272_8158# VDD 0
C604 6ph_rosc_0.psdiff_1.VOUTDP 6ph_rosc_0.buff_d8$1_3.inv_d4$1_0.VIN 0.0253f
C605 a_12794_3640# VDD -0
C606 6ph_rosc_0.PH4 6ph_rosc_0.PH0 0.24132f
C607 6ph_rosc_0.psdiff_0.buff_d8$1_0.inv_d8$1_0.VIN 6ph_rosc_0.buff_d8$1_1.inv_d2$1_0.VIN 0.01564f
C608 6ph_rosc_0.PH3 6ph_rosc_0.buff_d8$1_5.inv_d2$1_0.VIN 0.04119f
C609 6ph_rosc_0.psdiff_1.VOUTDP a_8311_1011# 0
C610 6ph_rosc_0.PH5 6to4_0.buff_PI_d32_3.inv_PI_d16$1_0.VIN 0.0472f
C611 6ph_rosc_0.psdiff_2.buff_d8$1_1.inv_d4$1_0.VIN a_4999_2194# 0.01613f
C612 6ph_rosc_0.buff_d8$1_3.inv_d8$1_0.VIN 6ph_rosc_0.buff_d8$1_1.inv_d2$1_0.VIN 0
C613 a_13954_8158# VDD 0
C614 6ph_rosc_0.psdiff_0.buff_d8$1_0.inv_d8$1_0.VIN 6ph_rosc_0.psdiff_0.buff_d8$1_0.inv_d2$1_0.VIN 0
C615 6ph_rosc_0.PH1 6to4_0.buff_PI_d32_3.inv_PI_d16$1_0.VIN 0
C616 PH90 PH270 0.00319f
C617 6ph_rosc_0.psdiff_2.CLKP 6ph_rosc_0.psdiff_1.buff_d8$1_0.inv_d2$1_0.VIN 0
C618 6ph_rosc_0.buff_d8$1_4.inv_d4$1_0.VIN 6ph_rosc_0.buff_d8$1_4.inv_d8$1_0.VIN 0.49436f
C619 6ph_rosc_0.psdiff_1.buff_d8$1_1.inv_d4$1_0.VIN VDD 0.6697f
C620 a_17636_8158# VDD 0
C621 6ph_rosc_0.psdiff_2.VOUTDP 6ph_rosc_0.psdiff_2.buff_d8$1_0.inv_d2$1_0.VIN 0
C622 6ph_rosc_0.PH1 6ph_rosc_0.buff_d8$1_1.inv_d2$1_0.VIN 0.01386f
C623 a_18162_7457# VDD 0
C624 6ph_rosc_0.PH5 6ph_rosc_0.psdiff_0.buff_d8$1_0.inv_d2$1_0.VIN 0.06582f
C625 6ph_rosc_0.psdiff_2.buff_d8$1_0.inv_d4$1_0.VIN 6ph_rosc_0.psdiff_2.buff_d8$1_0.inv_d2$1_0.VIN 0.25118f
C626 6ph_rosc_0.buff_d8$1_4.inv_d8$1_0.VIN VDD 1.19774f
C627 6ph_rosc_0.PH0 6ph_rosc_0.PH3 3.24296f
C628 6ph_rosc_0.psdiff_1.VOUTDN 6ph_rosc_0.psdiff_2.VOUTDP 0.05107f
C629 6ph_rosc_0.PH0 6ph_rosc_0.psdiff_2.buff_d8$1_1.inv_d2$1_0.VIN 0
C630 6ph_rosc_0.psdiff_2.VOUTDN 6ph_rosc_0.psdiff_1.buff_d8$1_1.inv_d4$1_0.VIN 0.01001f
C631 PH0 PH180 0.00319f
C632 a_18162_6756# VDD 0
C633 6ph_rosc_0.psdiff_2.buff_d8$1_1.inv_d8$1_0.VIN a_4999_2194# 0
C634 a_18162_9560# VDD 0
C635 6to4_0.buff_PI_d32_0.buff_PI_d16$1_0.inv_PI_d4$1_0.VOUT 6to4_0.buff_PI_d32_0.inv_PI_d16$1_0.VIN 0.02662f
C636 6ph_rosc_0.psdiff_0.buff_d8$1_1.inv_d4$1_0.VIN a_10947_2194# 0.01613f
C637 6to4_0.buff_PI_d32_1.buff_PI_d16$1_0.inv_PI_d4$1_0.VOUT 6to4_0.buff_PI_d32_2.VIN 0.00196f
C638 6ph_rosc_0.PH4 6to4_0.buff_PI_d32_2.buff_PI_d16$1_0.inv_PI_d4$1_0.VOUT 0.05402f
C639 6ph_rosc_0.psdiff_1.buff_d8$1_1.inv_d8$1_0.VIN VDD 1.41268f
C640 6ph_rosc_0.psdiff_0.buff_d8$1_1.inv_d2$1_0.VIN 6ph_rosc_0.psdiff_0.buff_d8$1_1.inv_d4$1_0.VIN 0.25118f
C641 a_18162_8859# VDD 0
C642 6ph_rosc_0.psdiff_2.CLKP 6ph_rosc_0.buff_d8$1_4.inv_d4$1_0.VIN 0
C643 6to4_0.PI_clk_1.inv_PI_d2$1_0.VOUT 6to4_0.buff_PI_d32_2.VIN 0.4742f
C644 6to4_0.PI_clk_0.inv_PI_d2$1_0.VOUT VDD 1.68608f
C645 a_10947_2194# VDD 0.62396f
C646 a_4486_10261# VDD 0
C647 a_19214_11663# VDD 0
C648 6ph_rosc_0.psdiff_2.CLKP 6ph_rosc_0.psdiff_0.buff_d8$1_1.inv_d4$1_0.VIN 0.0025f
C649 6ph_rosc_0.psdiff_0.buff_d8$1_1.inv_d2$1_0.VIN VDD 0.34786f
C650 6ph_rosc_0.psdiff_2.VOUTDN 6ph_rosc_0.psdiff_1.buff_d8$1_1.inv_d8$1_0.VIN 0.00391f
C651 6ph_rosc_0.psdiff_2.CLKP VDD 1.79398f
C652 PH0 a_19214_10962# -0
C653 6to4_0.buff_PI_d32_0.inv_PI_d32_0.VIN PH270 0.01008f
C654 PH90 6to4_0.buff_PI_d32_2.inv_PI_d32_0.VIN 0.00164f
C655 6ph_rosc_0.psdiff_2.VOUTDP a_10513_310# -0
C656 6ph_rosc_0.psdiff_2.buff_d8$1_0.inv_d8$1_0.VIN 6ph_rosc_0.buff_d8$1_4.inv_d8$1_0.VIN 0.04306f
C657 6ph_rosc_0.psdiff_0.buff_d8$1_1.inv_d8$1_0.VIN a_10947_2194# 0
C658 6ph_rosc_0.PH4 6ph_rosc_0.psdiff_1.buff_d8$1_1.inv_d4$1_0.VIN 0
C659 6ph_rosc_0.psdiff_2.CLKN 6ph_rosc_0.psdiff_2.VOUTDP 0.62558f
C660 6ph_rosc_0.psdiff_0.buff_d8$1_1.inv_d2$1_0.VIN 6ph_rosc_0.psdiff_0.buff_d8$1_1.inv_d8$1_0.VIN 0
C661 6to4_0.buff_PI_d32_3.buff_PI_d16$1_0.inv_PI_d4$1_0.VOUT 6to4_0.buff_PI_d32_3.inv_PI_d16$1_0.VIN 0.02662f
C662 6ph_rosc_0.psdiff_2.VOUTDN 6ph_rosc_0.psdiff_2.CLKP 0.01698f
C663 CTRL a_11240_2939# -0
C664 a_12104_2338# 6ph_rosc_0.psdiff_0.buff_d8$1_0.inv_d8$1_0.VIN 0.01471f
C665 6ph_rosc_0.psdiff_2.CLKN 6ph_rosc_0.psdiff_2.buff_d8$1_0.inv_d4$1_0.VIN 0.01108f
C666 6ph_rosc_0.psdiff_2.CLKP 6ph_rosc_0.psdiff_0.buff_d8$1_1.inv_d8$1_0.VIN 1.01673f
C667 CTRL 6ph_rosc_0.buff_d8$1_2.inv_d2$1_0.VIN 0.00555f
C668 a_19214_10261# VDD 0
C669 6to4_0.buff_PI_d32_1.inv_PI_d32_0.VIN PH180 0.01008f
C670 PH0 6to4_0.buff_PI_d32_3.inv_PI_d32_0.VIN 0.00164f
C671 6ph_rosc_0.PH5 a_12104_2338# 0.00874f
C672 6ph_rosc_0.psdiff_2.VOUTDP 6ph_rosc_0.buff_d8$1_3.inv_d4$1_0.VIN 0.07546f
C673 6ph_rosc_0.PH5 6to4_0.buff_PI_d32_1.buff_PI_d16$1_0.inv_PI_d4$1_0.VOUT 0.05402f
C674 6to4_0.buff_PI_d32_1.inv_PI_d16$1_0.VIN a_10798_10962# -0
C675 6ph_rosc_0.psdiff_2.buff_d8$1_1.inv_d4$1_0.VIN 6ph_rosc_0.psdiff_2.buff_d8$1_1.inv_d8$1_0.VIN 0.49436f
C676 6ph_rosc_0.buff_d8$1_2.inv_d8$1_0.VIN 6ph_rosc_0.buff_d8$1_2.inv_d2$1_0.VIN 0
C677 6to4_0.buff_PI_d32_0.inv_PI_d16$1_0.VIN 6to4_0.buff_PI_d32_0.buff_PI_d16$1_0.inv_PI_d4$1_0.VIN 0
C678 6to4_0.PI_clk_1.inv_PI_d2$1_0.VOUT 6ph_rosc_0.PH5 0.46644f
C679 6ph_rosc_0.PH2 6ph_rosc_0.buff_d8$1_0.inv_d4$1_0.VIN 0
C680 6to4_0.buff_PI_d32_3.buff_PI_d16$1_0.inv_PI_d4$1_0.VOUT a_7116_8158# -0
C681 a_3434_15168# VDD -0
C682 6ph_rosc_0.PH4 6ph_rosc_0.psdiff_1.buff_d8$1_1.inv_d8$1_0.VIN 0.00123f
C683 6ph_rosc_0.buff_d8$1_0.inv_d8$1_0.VIN 6ph_rosc_0.buff_d8$1_0.inv_d4$1_0.VIN 0.49436f
C684 6ph_rosc_0.psdiff_2.CLKP 6ph_rosc_0.psdiff_2.buff_d8$1_0.inv_d8$1_0.VIN 0.01465f
C685 6to4_0.buff_PI_d32_2.inv_PI_d16$1_0.VIN VDD 9.92937f
C686 6ph_rosc_0.psdiff_1.buff_d8$1_0.inv_d8$1_0.VIN 6ph_rosc_0.buff_d8$1_3.inv_d8$1_0.VIN 0.04306f
C687 6to4_0.flywheel_clk_0.PH0 6to4_0.buff_PI_d32_2.VIN 0.90764f
C688 6ph_rosc_0.psdiff_2.CLKN 6ph_rosc_0.psdiff_2.buff_d8$1_0.inv_d2$1_0.VIN 0.00993f
C689 6to4_0.buff_PI_d32_1.inv_PI_d16$1_0.VIN VDD 9.92937f
C690 a_17636_15168# VDD 0
C691 6ph_rosc_0.PH3 6ph_rosc_0.buff_d8$1_4.inv_d8$1_0.VIN 0.93132f
C692 6ph_rosc_0.psdiff_2.VOUTDP 6ph_rosc_0.buff_d8$1_4.inv_d2$1_0.VIN 0.20899f
C693 6ph_rosc_0.PH0 6to4_0.flywheel_clk_1.PH0 0
C694 a_7642_10962# VDD 0
C695 6ph_rosc_0.PH1 6ph_rosc_0.psdiff_1.buff_d8$1_0.inv_d8$1_0.VIN 0
C696 6ph_rosc_0.psdiff_1.VOUTDN 6ph_rosc_0.psdiff_2.CLKN 0.00398f
C697 6ph_rosc_0.PH2 6ph_rosc_0.PH0 0.08778f
C698 CTRL 6ph_rosc_0.buff_d8$1_1.inv_d4$1_0.VIN 0
C699 6to4_0.buff_PI_d32_0.inv_PI_d32_0.VIN 6to4_0.buff_PI_d32_2.inv_PI_d32_0.VIN 0.24833f
C700 a_17110_15869# VDD 0
C701 6ph_rosc_0.PH1 a_10513_1011# 0
C702 a_11324_10962# VDD 0
C703 6ph_rosc_0.PH5 6to4_0.inv_PI_d2$1_2.VOUT 0.01388f
C704 6ph_rosc_0.psdiff_2.buff_d8$1_1.inv_d8$1_0.VIN 6ph_rosc_0.psdiff_1.buff_d8$1_1.inv_d2$1_0.VIN 0
C705 a_7116_13766# VDD 0
C706 6ph_rosc_0.PH1 6to4_0.inv_PI_d2$1_2.VOUT 0.00163f
C707 a_15006_10962# VDD 0
C708 6ph_rosc_0.psdiff_0.buff_d8$1_0.inv_d8$1_0.VIN 6ph_rosc_0.buff_d8$1_1.inv_d8$1_0.VIN 0.04306f
C709 a_10798_13766# VDD 0
C710 a_18688_10962# VDD 0
C711 CTRL 6ph_rosc_0.buff_d8$1_3.inv_d2$1_0.VIN 0.00109f
C712 6to4_0.buff_PI_d32_1.inv_PI_d32_0.VIN 6to4_0.buff_PI_d32_3.inv_PI_d32_0.VIN 0.24833f
C713 6ph_rosc_0.PH3 6ph_rosc_0.psdiff_2.CLKP 0.018f
C714 6ph_rosc_0.psdiff_2.CLKP 6ph_rosc_0.psdiff_2.buff_d8$1_1.inv_d2$1_0.VIN 0.00167f
C715 a_6064_16570# VDD 0
C716 a_6064_2939# VDD 0
C717 6ph_rosc_0.PH3 a_7539_1011# 0
C718 6ph_rosc_0.PH5 6ph_rosc_0.buff_d8$1_1.inv_d8$1_0.VIN 0.93117f
C719 a_7973_2194# a_9130_2338# 0.01277f
C720 CTRL a_7973_2194# 0.2274f
C721 6ph_rosc_0.PH1 6ph_rosc_0.buff_d8$1_1.inv_d8$1_0.VIN 0
C722 a_9746_16570# VDD 0
C723 6ph_rosc_0.psdiff_1.VOUTDP 6ph_rosc_0.buff_d8$1_4.inv_d8$1_0.VIN 0.01948f
C724 6ph_rosc_0.PH1 6to4_0.flywheel_clk_0.PH0 0.03441f
C725 a_17636_13065# VDD 0
C726 6ph_rosc_0.PH2 6to4_0.buff_PI_d32_2.buff_PI_d16$1_0.inv_PI_d4$1_0.VOUT 0.05402f
C727 6to4_0.buff_PI_d32_2.VIN a_3434_14467# -0
C728 6ph_rosc_0.psdiff_2.CLKP a_6156_2338# 0.00743f
C729 a_13428_16570# VDD 0
C730 a_17110_12364# VDD 0
C731 6ph_rosc_0.buff_d8$1_5.inv_d8$1_0.VIN 6ph_rosc_0.psdiff_2.buff_d8$1_1.inv_d4$1_0.VIN 0.02575f
C732 6ph_rosc_0.buff_d8$1_2.inv_d2$1_0.VIN VDD 0.26044f
C733 6ph_rosc_0.buff_d8$1_2.inv_d4$1_0.VIN 6ph_rosc_0.psdiff_1.buff_d8$1_1.inv_d8$1_0.VIN 0.00782f
C734 a_6846_3640# VDD -0
C735 a_17110_16570# VDD 0
C736 6ph_rosc_0.psdiff_2.CLKN 6ph_rosc_0.buff_d8$1_3.inv_d4$1_0.VIN 0.01442f
C737 6ph_rosc_0.PH0 6to4_0.inv_PI_d2$1_1.VIN 0.43639f
C738 a_18688_14467# VDD 0
C739 a_5538_8158# VDD 0
C740 a_9460_3640# VDD -0
C741 a_16584_13766# VDD 0
C742 a_6064_7457# VDD 0
C743 6ph_rosc_0.psdiff_2.CLKN a_10925_1011# -0
C744 6ph_rosc_0.psdiff_2.CLKP 6ph_rosc_0.psdiff_1.VOUTDP 0.0727f
C745 PH180 a_19214_8158# -0
C746 6ph_rosc_0.psdiff_0.buff_d8$1_0.inv_d4$1_0.VIN 6ph_rosc_0.psdiff_0.buff_d8$1_0.inv_d2$1_0.VIN 0.25118f
C747 a_12022_3640# VDD 0
C748 a_9220_8158# VDD 0
C749 6to4_0.inv_PI_d2$1_2.VOUT 6to4_0.buff_PI_d32_3.buff_PI_d16$1_0.inv_PI_d4$1_0.VOUT 0.10111f
C750 6ph_rosc_0.buff_d8$1_5.inv_d8$1_0.VIN 6ph_rosc_0.psdiff_2.buff_d8$1_1.inv_d8$1_0.VIN 0.04417f
C751 a_12902_8158# VDD 0
C752 6ph_rosc_0.PH5 6to4_0.buff_PI_d32_3.inv_PI_d32_0.VIN 0.00726f
C753 6to4_0.buff_PI_d32_0.buff_PI_d16$1_0.inv_PI_d4$1_0.VOUT 6to4_0.flywheel_clk_0.PH0 0.05827f
C754 6ph_rosc_0.buff_d8$1_1.inv_d4$1_0.VIN VDD 0.52648f
C755 a_16584_8158# VDD 0
C756 6to4_0.buff_PI_d32_1.inv_PI_d16$1_0.VIN 6to4_0.buff_PI_d32_1.buff_PI_d16$1_0.inv_PI_d4$1_0.VIN 0
C757 a_17110_7457# VDD 0
C758 6to4_0.PI_clk_0.inv_PI_d2$1_0.VOUT 6ph_rosc_0.PH2 0.46644f
C759 6ph_rosc_0.PH5 6to4_0.buff_PI_d32_3.buff_PI_d16$1_0.inv_PI_d4$1_0.VIN 0.01873f
C760 6to4_0.buff_PI_d32_3.inv_PI_d16$1_0.VIN a_10798_8158# -0
C761 a_17110_6756# VDD 0
C762 6ph_rosc_0.PH1 6to4_0.buff_PI_d32_3.buff_PI_d16$1_0.inv_PI_d4$1_0.VIN 0.00399f
C763 6ph_rosc_0.PH2 6ph_rosc_0.psdiff_0.buff_d8$1_1.inv_d2$1_0.VIN 0
C764 6ph_rosc_0.buff_d8$1_3.inv_d2$1_0.VIN VDD 0.24829f
C765 6ph_rosc_0.buff_d8$1_0.inv_d8$1_0.VIN 6ph_rosc_0.psdiff_0.buff_d8$1_1.inv_d2$1_0.VIN 0.01857f
C766 a_17110_9560# VDD 0
C767 6ph_rosc_0.PH2 6ph_rosc_0.psdiff_2.CLKP 0
C768 6ph_rosc_0.buff_d8$1_0.inv_d8$1_0.VIN 6ph_rosc_0.psdiff_2.CLKP 0.00179f
C769 a_17110_8859# VDD 0
C770 a_7973_2194# VDD 0.62396f
C771 6ph_rosc_0.psdiff_2.VOUTDN 6ph_rosc_0.buff_d8$1_3.inv_d2$1_0.VIN 0.00112f
C772 a_12012_5604# VDD 0
C773 6ph_rosc_0.psdiff_2.VOUTDP 6ph_rosc_0.buff_d8$1_4.inv_d8$1_0.VIN 0.15238f
C774 a_18162_11663# VDD 0
C775 PH270 VDD 10.0771f
C776 6ph_rosc_0.psdiff_2.buff_d8$1_0.inv_d4$1_0.VIN 6ph_rosc_0.buff_d8$1_4.inv_d8$1_0.VIN 0.00869f
C777 PH0 VDD 10.0771f
C778 6ph_rosc_0.psdiff_1.VOUTDN a_10232_3640# -0
C779 6ph_rosc_0.psdiff_2.VOUTDN a_7973_2194# 0.0785f
C780 a_12104_2338# 6ph_rosc_0.psdiff_0.buff_d8$1_0.inv_d4$1_0.VIN 0.01515f
C781 6ph_rosc_0.PH3 a_2382_7457# -0
C782 6to4_0.flywheel_clk_0.PH0 6to4_0.buff_PI_d32_0.buff_PI_d16$1_0.inv_PI_d4$1_0.VIN 0.43182f
C783 6ph_rosc_0.psdiff_1.buff_d8$1_1.inv_d8$1_0.VIN 6ph_rosc_0.psdiff_2.VOUTDP 0.00273f
C784 PH90 a_19214_15168# -0
C785 a_9443_1011# VDD 0
C786 CTRL 6ph_rosc_0.psdiff_0.buff_d8$1_0.inv_d8$1_0.VIN 0.02782f
C787 CTRL 6ph_rosc_0.buff_d8$1_3.inv_d8$1_0.VIN 0.00276f
C788 6ph_rosc_0.psdiff_2.VOUTDP a_4977_1011# -0
C789 6ph_rosc_0.psdiff_2.CLKP 6ph_rosc_0.psdiff_2.VOUTDP 0.01585f
C790 6ph_rosc_0.psdiff_1.VOUTDN 6ph_rosc_0.psdiff_1.buff_d8$1_1.inv_d4$1_0.VIN 0
C791 6ph_rosc_0.psdiff_2.buff_d8$1_0.inv_d2$1_0.VIN 6ph_rosc_0.buff_d8$1_4.inv_d8$1_0.VIN 0.00147f
C792 a_18162_10261# VDD 0
C793 6ph_rosc_0.PH5 CTRL 0.51946f
C794 6ph_rosc_0.psdiff_2.CLKP 6ph_rosc_0.psdiff_2.buff_d8$1_0.inv_d4$1_0.VIN 0
C795 6ph_rosc_0.psdiff_1.buff_d8$1_0.inv_d4$1_0.VIN 6ph_rosc_0.buff_d8$1_3.inv_d8$1_0.VIN 0.00869f
C796 6ph_rosc_0.PH5 6to4_0.inv_PI_d2$1_3.VOUT 0.01393f
C797 6ph_rosc_0.PH1 CTRL 0.7636f
C798 6ph_rosc_0.PH1 a_9130_2338# 0.00874f
C799 6to4_0.buff_PI_d32_3.buff_PI_d16$1_0.inv_PI_d4$1_0.VOUT 6to4_0.buff_PI_d32_3.buff_PI_d16$1_0.inv_PI_d4$1_0.VIN 0.99121f
C800 6ph_rosc_0.PH1 6to4_0.inv_PI_d2$1_3.VOUT 0.00222f
C801 6ph_rosc_0.psdiff_2.VOUTDP a_10215_1011# -0
C802 CTRL a_11302_3640# -0
C803 6ph_rosc_0.buff_d8$1_2.inv_d4$1_0.VIN 6ph_rosc_0.buff_d8$1_2.inv_d2$1_0.VIN 0.25118f
C804 6to4_0.buff_PI_d32_0.inv_PI_d16$1_0.VIN PH90 0
C805 6ph_rosc_0.PH1 6ph_rosc_0.psdiff_1.buff_d8$1_0.inv_d4$1_0.VIN 0.04895f
C806 a_16584_15168# VDD 0
C807 6to4_0.buff_PI_d32_2.inv_PI_d32_0.VIN VDD 16.5251f
C808 6ph_rosc_0.PH1 6ph_rosc_0.buff_d8$1_2.inv_d8$1_0.VIN 0.01375f
C809 a_6590_10962# VDD 0
C810 6to4_0.buff_PI_d32_1.inv_PI_d32_0.VIN VDD 16.5251f
C811 6ph_rosc_0.psdiff_1.VOUTDN 6ph_rosc_0.psdiff_1.buff_d8$1_1.inv_d8$1_0.VIN 1.01209f
C812 6ph_rosc_0.PH3 6ph_rosc_0.buff_d8$1_3.inv_d2$1_0.VIN 0.01292f
C813 6ph_rosc_0.psdiff_1.buff_d8$1_0.inv_d2$1_0.VIN 6ph_rosc_0.psdiff_0.buff_d8$1_0.inv_d8$1_0.VIN 0
C814 6ph_rosc_0.psdiff_1.VOUTDN a_10947_2194# 0.0785f
C815 6ph_rosc_0.psdiff_2.CLKP 6ph_rosc_0.psdiff_2.buff_d8$1_0.inv_d2$1_0.VIN 0
C816 a_16058_15869# VDD 0
C817 6ph_rosc_0.psdiff_1.buff_d8$1_0.inv_d2$1_0.VIN 6ph_rosc_0.buff_d8$1_3.inv_d8$1_0.VIN 0.00147f
C818 a_10272_10962# VDD 0
C819 6ph_rosc_0.psdiff_1.VOUTDN 6ph_rosc_0.psdiff_0.buff_d8$1_1.inv_d2$1_0.VIN 0.02057f
C820 6ph_rosc_0.psdiff_0.buff_d8$1_0.inv_d4$1_0.VIN 6ph_rosc_0.buff_d8$1_1.inv_d8$1_0.VIN 0.00869f
C821 a_6064_13766# VDD 0
C822 6to4_0.buff_PI_d32_2.VIN VDD 1.92749f
C823 6ph_rosc_0.psdiff_1.VOUTDN 6ph_rosc_0.psdiff_2.CLKP 0.01805f
C824 6ph_rosc_0.PH3 a_7973_2194# 0.00121f
C825 a_13954_10962# VDD 0
C826 6ph_rosc_0.PH1 6ph_rosc_0.psdiff_1.buff_d8$1_0.inv_d2$1_0.VIN 0.06582f
C827 a_9746_13766# VDD 0
C828 6ph_rosc_0.psdiff_2.CLKN 6ph_rosc_0.buff_d8$1_4.inv_d8$1_0.VIN 0.13522f
C829 a_17636_10962# VDD 0
C830 6to4_0.buff_PI_d32_3.inv_PI_d16$1_0.VIN PH180 0
C831 6ph_rosc_0.psdiff_1.VOUTDP 6ph_rosc_0.buff_d8$1_1.inv_d4$1_0.VIN 0.01273f
C832 a_5012_16570# VDD 0
C833 a_13428_13766# VDD 0
C834 6ph_rosc_0.PH2 6ph_rosc_0.buff_d8$1_2.inv_d2$1_0.VIN 0.01457f
C835 6ph_rosc_0.buff_d8$1_1.inv_d2$1_0.VIN 6ph_rosc_0.buff_d8$1_1.inv_d8$1_0.VIN 0
C836 6ph_rosc_0.buff_d8$1_2.inv_d2$1_0.VIN 6ph_rosc_0.buff_d8$1_0.inv_d8$1_0.VIN 0
C837 a_6156_2338# a_7973_2194# 0.00571f
C838 CTRL a_4999_2194# 0.22352f
C839 6ph_rosc_0.psdiff_0.buff_d8$1_0.inv_d2$1_0.VIN 6ph_rosc_0.buff_d8$1_1.inv_d8$1_0.VIN 0.00147f
C840 a_8694_16570# VDD 0
C841 6to4_0.buff_PI_d32_0.inv_PI_d16$1_0.VIN 6to4_0.buff_PI_d32_0.inv_PI_d32_0.VIN 3.70287f
C842 a_16584_13065# VDD 0
C843 6to4_0.buff_PI_d32_3.buff_PI_d16$1_0.inv_PI_d4$1_0.VOUT 6to4_0.inv_PI_d2$1_3.VOUT 0.06379f
C844 6ph_rosc_0.psdiff_1.VOUTDP 6ph_rosc_0.buff_d8$1_3.inv_d2$1_0.VIN 0.15757f
C845 a_12376_16570# VDD 0
C846 6ph_rosc_0.psdiff_0.buff_d8$1_0.inv_d8$1_0.VIN VDD 1.46755f
C847 6ph_rosc_0.buff_d8$1_3.inv_d8$1_0.VIN VDD 1.21792f
C848 a_16058_12364# VDD 0
C849 6ph_rosc_0.psdiff_2.CLKP 6ph_rosc_0.psdiff_2.CLKN 0.04542f
C850 6to4_0.PI_clk_1.inv_PI_d2$1_0.VOUT 6to4_0.buff_PI_d32_1.buff_PI_d16$1_0.inv_PI_d4$1_0.VOUT 0
C851 a_16058_16570# VDD 0
C852 a_6074_3640# VDD 0
C853 6ph_rosc_0.buff_d8$1_4.inv_d2$1_0.VIN 6ph_rosc_0.buff_d8$1_4.inv_d8$1_0.VIN 0
C854 6to4_0.buff_PI_d32_2.buff_PI_d16$1_0.inv_PI_d4$1_0.VIN 6to4_0.buff_PI_d32_2.buff_PI_d16$1_0.inv_PI_d4$1_0.VOUT 0.99121f
C855 6ph_rosc_0.PH5 VDD 3.945f
C856 6to4_0.buff_PI_d32_0.inv_PI_d32_0.VIN a_15006_16570# -0
C857 6ph_rosc_0.PH1 VDD 4.27988f
C858 a_17636_14467# VDD 0
C859 6ph_rosc_0.psdiff_2.VOUTDN 6ph_rosc_0.buff_d8$1_3.inv_d8$1_0.VIN 0
C860 a_8688_3640# VDD -0
C861 6ph_rosc_0.PH4 6to4_0.buff_PI_d32_2.VIN 0.02589f
C862 a_15532_13766# VDD 0
C863 6ph_rosc_0.psdiff_2.CLKP 6ph_rosc_0.buff_d8$1_3.inv_d4$1_0.VIN 0
C864 a_8168_8158# VDD 0
C865 6to4_0.buff_PI_d32_3.inv_PI_d16$1_0.VIN 6to4_0.buff_PI_d32_3.inv_PI_d32_0.VIN 3.70287f
C866 a_19214_13766# VDD 0
C867 6to4_0.PI_clk_0.inv_PI_d2$1_0.VOUT a_3434_15869# -0
C868 6ph_rosc_0.PH5 6ph_rosc_0.psdiff_0.buff_d8$1_1.inv_d8$1_0.VIN 0.03875f
C869 6to4_0.buff_PI_d32_1.buff_PI_d16$1_0.inv_PI_d4$1_0.VOUT 6to4_0.inv_PI_d2$1_2.VOUT 0.00783f
C870 a_11850_8158# VDD 0
C871 6ph_rosc_0.buff_d8$1_5.inv_d4$1_0.VIN 6ph_rosc_0.psdiff_2.buff_d8$1_1.inv_d8$1_0.VIN 0.00782f
C872 CTRL 6ph_rosc_0.psdiff_2.buff_d8$1_1.inv_d4$1_0.VIN 0.00193f
C873 6to4_0.buff_PI_d32_3.inv_PI_d16$1_0.VIN 6to4_0.buff_PI_d32_3.buff_PI_d16$1_0.inv_PI_d4$1_0.VIN 0
C874 6to4_0.PI_clk_0.inv_PI_d2$1_0.VOUT a_4372_15168# -0
C875 6ph_rosc_0.psdiff_2.CLKP 6ph_rosc_0.buff_d8$1_4.inv_d2$1_0.VIN 0.0012f
C876 a_15532_8158# VDD 0
C877 a_16058_7457# VDD 0
C878 a_19214_8158# VDD 0
C879 6ph_rosc_0.buff_d8$1_0.inv_d2$1_0.VIN VDD 0.25754f
C880 a_16058_6756# VDD 0
C881 a_16058_9560# VDD 0
C882 6to4_0.buff_PI_d32_0.buff_PI_d16$1_0.inv_PI_d4$1_0.VOUT VDD 3.6947f
C883 6ph_rosc_0.psdiff_2.VOUTDP 6ph_rosc_0.buff_d8$1_1.inv_d4$1_0.VIN 0.00155f
C884 6ph_rosc_0.PH4 6ph_rosc_0.PH5 2.57055f
C885 VDD VSS 0.18846p
C886 a_13127_310# VSS 0.00384f $ **FLOATING
C887 a_12767_310# VSS 0.00384f $ **FLOATING
C888 a_12407_310# VSS 0.00384f $ **FLOATING
C889 a_11995_310# VSS 0.00838f $ **FLOATING
C890 a_11635_310# VSS 0.00384f $ **FLOATING
C891 a_11223_310# VSS 0.00838f $ **FLOATING
C892 a_10811_310# VSS 0.00838f $ **FLOATING
C893 a_10513_310# VSS 0.00838f $ **FLOATING
C894 a_10153_310# VSS 0.00384f $ **FLOATING
C895 a_9793_310# VSS 0.00384f $ **FLOATING
C896 a_9433_310# VSS 0.00384f $ **FLOATING
C897 a_9021_310# VSS 0.00838f $ **FLOATING
C898 a_8661_310# VSS 0.00384f $ **FLOATING
C899 a_8249_310# VSS 0.00838f $ **FLOATING
C900 a_7837_310# VSS 0.00838f $ **FLOATING
C901 a_7539_310# VSS 0.00838f $ **FLOATING
C902 a_7179_310# VSS 0.00384f $ **FLOATING
C903 a_6819_310# VSS 0.00384f $ **FLOATING
C904 a_6459_310# VSS 0.00384f $ **FLOATING
C905 a_6047_310# VSS 0.00838f $ **FLOATING
C906 a_5687_310# VSS 0.00384f $ **FLOATING
C907 a_5275_310# VSS 0.00838f $ **FLOATING
C908 a_4863_310# VSS 0.00838f $ **FLOATING
C909 6ph_rosc_0.buff_d8$1_1.inv_d8$1_0.VIN VSS 1.97807f
C910 6ph_rosc_0.buff_d8$1_1.inv_d4$1_0.VIN VSS 0.96003f
C911 6ph_rosc_0.buff_d8$1_1.inv_d2$1_0.VIN VSS 0.52799f
C912 6ph_rosc_0.buff_d8$1_3.inv_d8$1_0.VIN VSS 1.81629f
C913 6ph_rosc_0.buff_d8$1_3.inv_d4$1_0.VIN VSS 0.89366f
C914 6ph_rosc_0.buff_d8$1_3.inv_d2$1_0.VIN VSS 0.47661f
C915 6ph_rosc_0.buff_d8$1_4.inv_d8$1_0.VIN VSS 1.81332f
C916 6ph_rosc_0.buff_d8$1_4.inv_d4$1_0.VIN VSS 0.89218f
C917 6ph_rosc_0.buff_d8$1_4.inv_d2$1_0.VIN VSS 0.4933f
C918 a_13189_1011# VSS 0.00838f $ **FLOATING
C919 a_12777_1011# VSS 0.00838f $ **FLOATING
C920 a_12417_1011# VSS 0.00384f $ **FLOATING
C921 a_12005_1011# VSS 0.00838f $ **FLOATING
C922 a_11645_1011# VSS 0.00384f $ **FLOATING
C923 a_11285_1011# VSS 0.00384f $ **FLOATING
C924 a_10925_1011# VSS 0.00384f $ **FLOATING
C925 a_10513_1011# VSS 0.00838f $ **FLOATING
C926 a_10215_1011# VSS 0.00838f $ **FLOATING
C927 a_9803_1011# VSS 0.00838f $ **FLOATING
C928 a_9443_1011# VSS 0.00384f $ **FLOATING
C929 a_9031_1011# VSS 0.00838f $ **FLOATING
C930 a_8671_1011# VSS 0.00384f $ **FLOATING
C931 a_8311_1011# VSS 0.00384f $ **FLOATING
C932 a_7951_1011# VSS 0.00384f $ **FLOATING
C933 a_7539_1011# VSS 0.00838f $ **FLOATING
C934 a_7241_1011# VSS 0.00838f $ **FLOATING
C935 a_6829_1011# VSS 0.00838f $ **FLOATING
C936 a_6469_1011# VSS 0.00384f $ **FLOATING
C937 a_6057_1011# VSS 0.00838f $ **FLOATING
C938 a_5697_1011# VSS 0.00384f $ **FLOATING
C939 a_5337_1011# VSS 0.00384f $ **FLOATING
C940 a_4977_1011# VSS 0.00384f $ **FLOATING
C941 6ph_rosc_0.psdiff_0.buff_d8$1_0.inv_d2$1_0.VIN VSS 0.51435f
C942 6ph_rosc_0.psdiff_0.buff_d8$1_0.inv_d4$1_0.VIN VSS 0.90438f
C943 6ph_rosc_0.psdiff_0.buff_d8$1_0.inv_d8$1_0.VIN VSS 1.72946f
C944 6ph_rosc_0.psdiff_1.buff_d8$1_0.inv_d2$1_0.VIN VSS 0.49734f
C945 6ph_rosc_0.psdiff_1.buff_d8$1_0.inv_d4$1_0.VIN VSS 0.90484f
C946 6ph_rosc_0.psdiff_1.buff_d8$1_0.inv_d8$1_0.VIN VSS 1.7295f
C947 6ph_rosc_0.psdiff_2.buff_d8$1_0.inv_d2$1_0.VIN VSS 0.49744f
C948 6ph_rosc_0.psdiff_2.buff_d8$1_0.inv_d4$1_0.VIN VSS 0.9049f
C949 6ph_rosc_0.psdiff_2.buff_d8$1_0.inv_d8$1_0.VIN VSS 1.77133f
C950 6ph_rosc_0.psdiff_1.VOUTDP VSS 5.37814f
C951 6ph_rosc_0.psdiff_2.VOUTDP VSS 5.74392f
C952 6ph_rosc_0.psdiff_2.CLKN VSS 3.6778f
C953 a_12104_2338# VSS 0.63563f
C954 a_10947_2194# VSS 0.57129f
C955 a_9130_2338# VSS 0.62775f
C956 a_7973_2194# VSS 0.57129f
C957 a_6156_2338# VSS 0.62775f
C958 a_4999_2194# VSS 0.57917f
C959 a_13144_2939# VSS 0.00384f $ **FLOATING
C960 a_12784_2939# VSS 0.00384f $ **FLOATING
C961 a_12424_2939# VSS 0.00384f $ **FLOATING
C962 a_12012_2939# VSS 0.00838f $ **FLOATING
C963 a_11652_2939# VSS 0.00384f $ **FLOATING
C964 a_11240_2939# VSS 0.00838f $ **FLOATING
C965 a_10828_2939# VSS 0.00838f $ **FLOATING
C966 a_10530_2939# VSS 0.00838f $ **FLOATING
C967 a_10170_2939# VSS 0.00384f $ **FLOATING
C968 a_9810_2939# VSS 0.00384f $ **FLOATING
C969 a_9450_2939# VSS 0.00384f $ **FLOATING
C970 a_9038_2939# VSS 0.00838f $ **FLOATING
C971 a_8678_2939# VSS 0.00384f $ **FLOATING
C972 a_8266_2939# VSS 0.00838f $ **FLOATING
C973 a_7854_2939# VSS 0.00838f $ **FLOATING
C974 a_7556_2939# VSS 0.00838f $ **FLOATING
C975 a_7196_2939# VSS 0.00384f $ **FLOATING
C976 a_6836_2939# VSS 0.00384f $ **FLOATING
C977 a_6476_2939# VSS 0.00384f $ **FLOATING
C978 a_6064_2939# VSS 0.00838f $ **FLOATING
C979 a_5704_2939# VSS 0.00384f $ **FLOATING
C980 a_5292_2939# VSS 0.00838f $ **FLOATING
C981 a_4880_2939# VSS 0.00838f $ **FLOATING
C982 6ph_rosc_0.psdiff_0.buff_d8$1_1.inv_d8$1_0.VIN VSS 1.83954f
C983 6ph_rosc_0.psdiff_0.buff_d8$1_1.inv_d4$1_0.VIN VSS 0.88395f
C984 6ph_rosc_0.psdiff_0.buff_d8$1_1.inv_d2$1_0.VIN VSS 0.47558f
C985 6ph_rosc_0.psdiff_1.buff_d8$1_1.inv_d8$1_0.VIN VSS 1.80591f
C986 6ph_rosc_0.psdiff_1.buff_d8$1_1.inv_d4$1_0.VIN VSS 0.88395f
C987 6ph_rosc_0.psdiff_1.buff_d8$1_1.inv_d2$1_0.VIN VSS 0.47558f
C988 6ph_rosc_0.psdiff_2.buff_d8$1_1.inv_d8$1_0.VIN VSS 1.81091f
C989 6ph_rosc_0.psdiff_2.buff_d8$1_1.inv_d4$1_0.VIN VSS 0.89478f
C990 6ph_rosc_0.psdiff_2.buff_d8$1_1.inv_d2$1_0.VIN VSS 0.49469f
C991 a_13206_3640# VSS 0.00838f $ **FLOATING
C992 a_12794_3640# VSS 0.00838f $ **FLOATING
C993 a_12434_3640# VSS 0.00384f $ **FLOATING
C994 a_12022_3640# VSS 0.00838f $ **FLOATING
C995 a_11662_3640# VSS 0.00384f $ **FLOATING
C996 a_11302_3640# VSS 0.00384f $ **FLOATING
C997 a_10942_3640# VSS 0.00384f $ **FLOATING
C998 a_10530_3640# VSS 0.00838f $ **FLOATING
C999 a_10232_3640# VSS 0.00838f $ **FLOATING
C1000 a_9820_3640# VSS 0.00838f $ **FLOATING
C1001 a_9460_3640# VSS 0.00384f $ **FLOATING
C1002 a_9048_3640# VSS 0.00838f $ **FLOATING
C1003 a_8688_3640# VSS 0.00384f $ **FLOATING
C1004 a_8328_3640# VSS 0.00384f $ **FLOATING
C1005 a_7968_3640# VSS 0.00384f $ **FLOATING
C1006 a_7556_3640# VSS 0.00838f $ **FLOATING
C1007 a_7258_3640# VSS 0.00838f $ **FLOATING
C1008 a_6846_3640# VSS 0.00838f $ **FLOATING
C1009 a_6486_3640# VSS 0.00384f $ **FLOATING
C1010 a_6074_3640# VSS 0.00838f $ **FLOATING
C1011 a_5714_3640# VSS 0.00384f $ **FLOATING
C1012 a_5354_3640# VSS 0.00384f $ **FLOATING
C1013 a_4994_3640# VSS 0.00384f $ **FLOATING
C1014 6ph_rosc_0.psdiff_2.CLKP VSS 5.82365f
C1015 6ph_rosc_0.buff_d8$1_0.inv_d2$1_0.VIN VSS 0.51277f
C1016 6ph_rosc_0.buff_d8$1_0.inv_d4$1_0.VIN VSS 0.85434f
C1017 6ph_rosc_0.buff_d8$1_0.inv_d8$1_0.VIN VSS 1.65497f
C1018 6ph_rosc_0.psdiff_1.VOUTDN VSS 2.94651f
C1019 6ph_rosc_0.buff_d8$1_2.inv_d2$1_0.VIN VSS 0.49211f
C1020 6ph_rosc_0.buff_d8$1_2.inv_d4$1_0.VIN VSS 0.84667f
C1021 6ph_rosc_0.buff_d8$1_2.inv_d8$1_0.VIN VSS 1.64991f
C1022 6ph_rosc_0.psdiff_2.VOUTDN VSS 2.94641f
C1023 6ph_rosc_0.buff_d8$1_5.inv_d2$1_0.VIN VSS 0.49211f
C1024 6ph_rosc_0.buff_d8$1_5.inv_d4$1_0.VIN VSS 0.84667f
C1025 6ph_rosc_0.buff_d8$1_5.inv_d8$1_0.VIN VSS 1.69074f
C1026 CTRL VSS 8.44797f
C1027 a_12012_5604# VSS 0.00838f $ **FLOATING
C1028 a_9038_5604# VSS 0.00838f $ **FLOATING
C1029 a_6064_5604# VSS 0.00838f $ **FLOATING
C1030 a_19214_6055# VSS 0.00838f $ **FLOATING
C1031 a_18688_6055# VSS 0.00838f $ **FLOATING
C1032 a_18162_6055# VSS 0.00838f $ **FLOATING
C1033 a_17636_6055# VSS 0.00838f $ **FLOATING
C1034 a_17110_6055# VSS 0.00838f $ **FLOATING
C1035 a_16584_6055# VSS 0.00838f $ **FLOATING
C1036 a_16058_6055# VSS 0.00838f $ **FLOATING
C1037 a_19214_6756# VSS 0.00838f $ **FLOATING
C1038 a_18688_6756# VSS 0.00838f $ **FLOATING
C1039 a_18162_6756# VSS 0.00838f $ **FLOATING
C1040 a_17636_6756# VSS 0.00838f $ **FLOATING
C1041 a_17110_6756# VSS 0.00838f $ **FLOATING
C1042 a_16584_6756# VSS 0.00838f $ **FLOATING
C1043 a_16058_6756# VSS 0.00838f $ **FLOATING
C1044 a_19214_7457# VSS 0.00838f $ **FLOATING
C1045 a_18688_7457# VSS 0.00838f $ **FLOATING
C1046 a_18162_7457# VSS 0.00838f $ **FLOATING
C1047 a_17636_7457# VSS 0.00838f $ **FLOATING
C1048 a_17110_7457# VSS 0.00838f $ **FLOATING
C1049 a_16584_7457# VSS 0.00838f $ **FLOATING
C1050 a_16058_7457# VSS 0.00838f $ **FLOATING
C1051 a_15532_7457# VSS 0.00838f $ **FLOATING
C1052 a_15006_7457# VSS 0.00838f $ **FLOATING
C1053 a_14480_7457# VSS 0.00838f $ **FLOATING
C1054 a_13954_7457# VSS 0.00838f $ **FLOATING
C1055 a_13428_7457# VSS 0.00838f $ **FLOATING
C1056 a_12902_7457# VSS 0.00838f $ **FLOATING
C1057 a_12376_7457# VSS 0.00838f $ **FLOATING
C1058 a_11850_7457# VSS 0.00838f $ **FLOATING
C1059 a_11324_7457# VSS 0.00838f $ **FLOATING
C1060 a_10798_7457# VSS 0.00838f $ **FLOATING
C1061 a_10272_7457# VSS 0.00838f $ **FLOATING
C1062 a_9746_7457# VSS 0.00838f $ **FLOATING
C1063 a_9220_7457# VSS 0.00838f $ **FLOATING
C1064 a_8694_7457# VSS 0.00838f $ **FLOATING
C1065 a_8168_7457# VSS 0.00838f $ **FLOATING
C1066 a_7642_7457# VSS 0.00838f $ **FLOATING
C1067 a_7116_7457# VSS 0.00838f $ **FLOATING
C1068 a_6590_7457# VSS 0.00838f $ **FLOATING
C1069 a_6064_7457# VSS 0.00838f $ **FLOATING
C1070 a_5538_7457# VSS 0.00838f $ **FLOATING
C1071 a_5012_7457# VSS 0.00838f $ **FLOATING
C1072 a_4486_7457# VSS 0.00838f $ **FLOATING
C1073 a_3960_7457# VSS 0.00838f $ **FLOATING
C1074 a_3434_7457# VSS 0.00838f $ **FLOATING
C1075 a_2908_7457# VSS 0.00838f $ **FLOATING
C1076 a_2382_7457# VSS 0.00838f $ **FLOATING
C1077 6to4_0.buff_PI_d32_3.buff_PI_d16$1_0.inv_PI_d4$1_0.VIN VSS 2.44043f
C1078 6to4_0.inv_PI_d2$1_3.VOUT VSS 1.32382f
C1079 6ph_rosc_0.PH3 VSS 10.02178f
C1080 a_19214_8158# VSS 0.00838f $ **FLOATING
C1081 a_18688_8158# VSS 0.00838f $ **FLOATING
C1082 a_18162_8158# VSS 0.00838f $ **FLOATING
C1083 a_17636_8158# VSS 0.00838f $ **FLOATING
C1084 a_17110_8158# VSS 0.00838f $ **FLOATING
C1085 a_16584_8158# VSS 0.00838f $ **FLOATING
C1086 a_16058_8158# VSS 0.00838f $ **FLOATING
C1087 a_15532_8158# VSS 0.00838f $ **FLOATING
C1088 a_15006_8158# VSS 0.00838f $ **FLOATING
C1089 a_14480_8158# VSS 0.00838f $ **FLOATING
C1090 a_13954_8158# VSS 0.00838f $ **FLOATING
C1091 a_13428_8158# VSS 0.00838f $ **FLOATING
C1092 a_12902_8158# VSS 0.00838f $ **FLOATING
C1093 a_12376_8158# VSS 0.00838f $ **FLOATING
C1094 a_11850_8158# VSS 0.00838f $ **FLOATING
C1095 a_11324_8158# VSS 0.00838f $ **FLOATING
C1096 a_10798_8158# VSS 0.00838f $ **FLOATING
C1097 a_10272_8158# VSS 0.00838f $ **FLOATING
C1098 a_9746_8158# VSS 0.00838f $ **FLOATING
C1099 a_9220_8158# VSS 0.00838f $ **FLOATING
C1100 a_8694_8158# VSS 0.00838f $ **FLOATING
C1101 a_8168_8158# VSS 0.00838f $ **FLOATING
C1102 a_7642_8158# VSS 0.00838f $ **FLOATING
C1103 a_7116_8158# VSS 0.00838f $ **FLOATING
C1104 a_6590_8158# VSS 0.00838f $ **FLOATING
C1105 a_6064_8158# VSS 0.00838f $ **FLOATING
C1106 a_5538_8158# VSS 0.00838f $ **FLOATING
C1107 a_5012_8158# VSS 0.00838f $ **FLOATING
C1108 a_4486_8158# VSS 0.00838f $ **FLOATING
C1109 a_3960_8158# VSS 0.00838f $ **FLOATING
C1110 a_3434_8158# VSS 0.00838f $ **FLOATING
C1111 PH180 VSS 9.49731f
C1112 6to4_0.buff_PI_d32_3.inv_PI_d32_0.VIN VSS 20.1466f
C1113 6to4_0.buff_PI_d32_3.inv_PI_d16$1_0.VIN VSS 13.25581f
C1114 6to4_0.buff_PI_d32_3.buff_PI_d16$1_0.inv_PI_d4$1_0.VOUT VSS 5.01451f
C1115 a_19214_8859# VSS 0.00838f $ **FLOATING
C1116 a_18688_8859# VSS 0.00838f $ **FLOATING
C1117 a_18162_8859# VSS 0.00838f $ **FLOATING
C1118 a_17636_8859# VSS 0.00838f $ **FLOATING
C1119 a_17110_8859# VSS 0.00838f $ **FLOATING
C1120 a_16584_8859# VSS 0.00838f $ **FLOATING
C1121 a_16058_8859# VSS 0.00838f $ **FLOATING
C1122 a_19214_9560# VSS 0.00838f $ **FLOATING
C1123 a_18688_9560# VSS 0.00838f $ **FLOATING
C1124 a_18162_9560# VSS 0.00838f $ **FLOATING
C1125 a_17636_9560# VSS 0.00838f $ **FLOATING
C1126 a_17110_9560# VSS 0.00838f $ **FLOATING
C1127 a_16584_9560# VSS 0.00838f $ **FLOATING
C1128 a_16058_9560# VSS 0.00838f $ **FLOATING
C1129 a_4732_9560# VSS 0.00838f $ **FLOATING
C1130 a_4372_9560# VSS 0.00384f $ **FLOATING
C1131 6to4_0.inv_PI_d2$1_2.VOUT VSS 2.72561f
C1132 a_19214_10261# VSS 0.00838f $ **FLOATING
C1133 a_18688_10261# VSS 0.00838f $ **FLOATING
C1134 a_18162_10261# VSS 0.00838f $ **FLOATING
C1135 a_17636_10261# VSS 0.00838f $ **FLOATING
C1136 a_17110_10261# VSS 0.00838f $ **FLOATING
C1137 a_16584_10261# VSS 0.00838f $ **FLOATING
C1138 a_16058_10261# VSS 0.00838f $ **FLOATING
C1139 a_15532_10261# VSS 0.00838f $ **FLOATING
C1140 a_15006_10261# VSS 0.00838f $ **FLOATING
C1141 a_14480_10261# VSS 0.00838f $ **FLOATING
C1142 a_13954_10261# VSS 0.00838f $ **FLOATING
C1143 a_13428_10261# VSS 0.00838f $ **FLOATING
C1144 a_12902_10261# VSS 0.00838f $ **FLOATING
C1145 a_12376_10261# VSS 0.00838f $ **FLOATING
C1146 a_11850_10261# VSS 0.00838f $ **FLOATING
C1147 a_11324_10261# VSS 0.00838f $ **FLOATING
C1148 a_10798_10261# VSS 0.00838f $ **FLOATING
C1149 a_10272_10261# VSS 0.00838f $ **FLOATING
C1150 a_9746_10261# VSS 0.00838f $ **FLOATING
C1151 a_9220_10261# VSS 0.00838f $ **FLOATING
C1152 a_8694_10261# VSS 0.00838f $ **FLOATING
C1153 a_8168_10261# VSS 0.00838f $ **FLOATING
C1154 a_7642_10261# VSS 0.00838f $ **FLOATING
C1155 a_7116_10261# VSS 0.00838f $ **FLOATING
C1156 a_6590_10261# VSS 0.00838f $ **FLOATING
C1157 a_6064_10261# VSS 0.00838f $ **FLOATING
C1158 a_5538_10261# VSS 0.00838f $ **FLOATING
C1159 a_5012_10261# VSS 0.00838f $ **FLOATING
C1160 a_4486_10261# VSS 0.00838f $ **FLOATING
C1161 a_3960_10261# VSS 0.00838f $ **FLOATING
C1162 a_3434_10261# VSS 0.00838f $ **FLOATING
C1163 a_2908_10261# VSS 0.00838f $ **FLOATING
C1164 a_2382_10261# VSS 0.00838f $ **FLOATING
C1165 6to4_0.buff_PI_d32_1.buff_PI_d16$1_0.inv_PI_d4$1_0.VIN VSS 2.45093f
C1166 6to4_0.flywheel_clk_1.PH0 VSS 2.60487f
C1167 6to4_0.inv_PI_d2$1_1.VIN VSS 1.32376f
C1168 6ph_rosc_0.PH0 VSS 9.98661f
C1169 a_19214_10962# VSS 0.00838f $ **FLOATING
C1170 a_18688_10962# VSS 0.00838f $ **FLOATING
C1171 a_18162_10962# VSS 0.00838f $ **FLOATING
C1172 a_17636_10962# VSS 0.00838f $ **FLOATING
C1173 a_17110_10962# VSS 0.00838f $ **FLOATING
C1174 a_16584_10962# VSS 0.00838f $ **FLOATING
C1175 a_16058_10962# VSS 0.00838f $ **FLOATING
C1176 a_15532_10962# VSS 0.00838f $ **FLOATING
C1177 a_15006_10962# VSS 0.00838f $ **FLOATING
C1178 a_14480_10962# VSS 0.00838f $ **FLOATING
C1179 a_13954_10962# VSS 0.00838f $ **FLOATING
C1180 a_13428_10962# VSS 0.00838f $ **FLOATING
C1181 a_12902_10962# VSS 0.00838f $ **FLOATING
C1182 a_12376_10962# VSS 0.00838f $ **FLOATING
C1183 a_11850_10962# VSS 0.00838f $ **FLOATING
C1184 a_11324_10962# VSS 0.00838f $ **FLOATING
C1185 a_10798_10962# VSS 0.00838f $ **FLOATING
C1186 a_10272_10962# VSS 0.00838f $ **FLOATING
C1187 a_9746_10962# VSS 0.00838f $ **FLOATING
C1188 a_9220_10962# VSS 0.00838f $ **FLOATING
C1189 a_8694_10962# VSS 0.00838f $ **FLOATING
C1190 a_8168_10962# VSS 0.00838f $ **FLOATING
C1191 a_7642_10962# VSS 0.00838f $ **FLOATING
C1192 a_7116_10962# VSS 0.00838f $ **FLOATING
C1193 a_6590_10962# VSS 0.00838f $ **FLOATING
C1194 a_6064_10962# VSS 0.00838f $ **FLOATING
C1195 a_5538_10962# VSS 0.00838f $ **FLOATING
C1196 a_5012_10962# VSS 0.00838f $ **FLOATING
C1197 a_4486_10962# VSS 0.00838f $ **FLOATING
C1198 a_3960_10962# VSS 0.00838f $ **FLOATING
C1199 a_3434_10962# VSS 0.00838f $ **FLOATING
C1200 PH0 VSS 9.51442f
C1201 6to4_0.buff_PI_d32_1.inv_PI_d32_0.VIN VSS 19.6317f
C1202 6to4_0.buff_PI_d32_1.inv_PI_d16$1_0.VIN VSS 11.7616f
C1203 6to4_0.buff_PI_d32_1.buff_PI_d16$1_0.inv_PI_d4$1_0.VOUT VSS 4.96698f
C1204 a_19214_11663# VSS 0.00838f $ **FLOATING
C1205 a_18688_11663# VSS 0.00838f $ **FLOATING
C1206 a_18162_11663# VSS 0.00838f $ **FLOATING
C1207 a_17636_11663# VSS 0.00838f $ **FLOATING
C1208 a_17110_11663# VSS 0.00838f $ **FLOATING
C1209 a_16584_11663# VSS 0.00838f $ **FLOATING
C1210 a_16058_11663# VSS 0.00838f $ **FLOATING
C1211 a_3434_11663# VSS 0.00838f $ **FLOATING
C1212 6ph_rosc_0.PH5 VSS 14.4111f
C1213 a_19214_12364# VSS 0.00838f $ **FLOATING
C1214 a_18688_12364# VSS 0.00838f $ **FLOATING
C1215 a_18162_12364# VSS 0.00838f $ **FLOATING
C1216 a_17636_12364# VSS 0.00838f $ **FLOATING
C1217 a_17110_12364# VSS 0.00838f $ **FLOATING
C1218 a_16584_12364# VSS 0.00838f $ **FLOATING
C1219 a_16058_12364# VSS 0.00838f $ **FLOATING
C1220 a_3434_12364# VSS 0.00838f $ **FLOATING
C1221 a_19214_13065# VSS 0.00838f $ **FLOATING
C1222 a_18688_13065# VSS 0.00838f $ **FLOATING
C1223 a_18162_13065# VSS 0.00838f $ **FLOATING
C1224 a_17636_13065# VSS 0.00838f $ **FLOATING
C1225 a_17110_13065# VSS 0.00838f $ **FLOATING
C1226 a_16584_13065# VSS 0.00838f $ **FLOATING
C1227 a_16058_13065# VSS 0.00838f $ **FLOATING
C1228 a_15532_13065# VSS 0.00838f $ **FLOATING
C1229 a_15006_13065# VSS 0.00838f $ **FLOATING
C1230 a_14480_13065# VSS 0.00838f $ **FLOATING
C1231 a_13954_13065# VSS 0.00838f $ **FLOATING
C1232 a_13428_13065# VSS 0.00838f $ **FLOATING
C1233 a_12902_13065# VSS 0.00838f $ **FLOATING
C1234 a_12376_13065# VSS 0.00838f $ **FLOATING
C1235 a_11850_13065# VSS 0.00838f $ **FLOATING
C1236 a_11324_13065# VSS 0.00838f $ **FLOATING
C1237 a_10798_13065# VSS 0.00838f $ **FLOATING
C1238 a_10272_13065# VSS 0.00838f $ **FLOATING
C1239 a_9746_13065# VSS 0.00838f $ **FLOATING
C1240 a_9220_13065# VSS 0.00838f $ **FLOATING
C1241 a_8694_13065# VSS 0.00838f $ **FLOATING
C1242 a_8168_13065# VSS 0.00838f $ **FLOATING
C1243 a_7642_13065# VSS 0.00838f $ **FLOATING
C1244 a_7116_13065# VSS 0.00838f $ **FLOATING
C1245 a_6590_13065# VSS 0.00838f $ **FLOATING
C1246 a_6064_13065# VSS 0.00838f $ **FLOATING
C1247 a_5538_13065# VSS 0.00838f $ **FLOATING
C1248 a_5012_13065# VSS 0.00838f $ **FLOATING
C1249 a_4486_13065# VSS 0.00838f $ **FLOATING
C1250 a_3960_13065# VSS 0.00838f $ **FLOATING
C1251 a_3434_13065# VSS 0.00838f $ **FLOATING
C1252 6to4_0.buff_PI_d32_2.buff_PI_d16$1_0.inv_PI_d4$1_0.VIN VSS 2.45511f
C1253 6to4_0.PI_clk_1.inv_PI_d2$1_0.VOUT VSS 2.09609f
C1254 6ph_rosc_0.PH4 VSS 13.73654f
C1255 a_19214_13766# VSS 0.00838f $ **FLOATING
C1256 a_18688_13766# VSS 0.00838f $ **FLOATING
C1257 a_18162_13766# VSS 0.00838f $ **FLOATING
C1258 a_17636_13766# VSS 0.00838f $ **FLOATING
C1259 a_17110_13766# VSS 0.00838f $ **FLOATING
C1260 a_16584_13766# VSS 0.00838f $ **FLOATING
C1261 a_16058_13766# VSS 0.00838f $ **FLOATING
C1262 a_15532_13766# VSS 0.00838f $ **FLOATING
C1263 a_15006_13766# VSS 0.00838f $ **FLOATING
C1264 a_14480_13766# VSS 0.00838f $ **FLOATING
C1265 a_13954_13766# VSS 0.00838f $ **FLOATING
C1266 a_13428_13766# VSS 0.00838f $ **FLOATING
C1267 a_12902_13766# VSS 0.00838f $ **FLOATING
C1268 a_12376_13766# VSS 0.00838f $ **FLOATING
C1269 a_11850_13766# VSS 0.00838f $ **FLOATING
C1270 a_11324_13766# VSS 0.00838f $ **FLOATING
C1271 a_10798_13766# VSS 0.00838f $ **FLOATING
C1272 a_10272_13766# VSS 0.00838f $ **FLOATING
C1273 a_9746_13766# VSS 0.00838f $ **FLOATING
C1274 a_9220_13766# VSS 0.00838f $ **FLOATING
C1275 a_8694_13766# VSS 0.00838f $ **FLOATING
C1276 a_8168_13766# VSS 0.00838f $ **FLOATING
C1277 a_7642_13766# VSS 0.00838f $ **FLOATING
C1278 a_7116_13766# VSS 0.00838f $ **FLOATING
C1279 a_6590_13766# VSS 0.00838f $ **FLOATING
C1280 a_6064_13766# VSS 0.00838f $ **FLOATING
C1281 a_5538_13766# VSS 0.00838f $ **FLOATING
C1282 a_5012_13766# VSS 0.00838f $ **FLOATING
C1283 a_4486_13766# VSS 0.00838f $ **FLOATING
C1284 a_3960_13766# VSS 0.00838f $ **FLOATING
C1285 a_3434_13766# VSS 0.00838f $ **FLOATING
C1286 PH270 VSS 9.51518f
C1287 6to4_0.buff_PI_d32_2.inv_PI_d32_0.VIN VSS 22.00879f
C1288 6to4_0.buff_PI_d32_2.inv_PI_d16$1_0.VIN VSS 13.25841f
C1289 6to4_0.buff_PI_d32_2.buff_PI_d16$1_0.inv_PI_d4$1_0.VOUT VSS 4.94693f
C1290 a_19214_14467# VSS 0.00838f $ **FLOATING
C1291 a_18688_14467# VSS 0.00838f $ **FLOATING
C1292 a_18162_14467# VSS 0.00838f $ **FLOATING
C1293 a_17636_14467# VSS 0.00838f $ **FLOATING
C1294 a_17110_14467# VSS 0.00838f $ **FLOATING
C1295 a_16584_14467# VSS 0.00838f $ **FLOATING
C1296 a_16058_14467# VSS 0.00838f $ **FLOATING
C1297 a_3434_14467# VSS 0.00838f $ **FLOATING
C1298 6ph_rosc_0.PH2 VSS 16.18742f
C1299 a_19214_15168# VSS 0.00838f $ **FLOATING
C1300 a_18688_15168# VSS 0.00838f $ **FLOATING
C1301 a_18162_15168# VSS 0.00838f $ **FLOATING
C1302 a_17636_15168# VSS 0.00838f $ **FLOATING
C1303 a_17110_15168# VSS 0.00838f $ **FLOATING
C1304 a_16584_15168# VSS 0.00838f $ **FLOATING
C1305 a_16058_15168# VSS 0.00838f $ **FLOATING
C1306 a_4732_15168# VSS 0.00838f $ **FLOATING
C1307 a_4372_15168# VSS 0.00384f $ **FLOATING
C1308 a_3960_15168# VSS 0.00838f $ **FLOATING
C1309 a_3434_15168# VSS 0.00838f $ **FLOATING
C1310 6to4_0.buff_PI_d32_2.VIN VSS 3.22481f
C1311 a_19214_15869# VSS 0.00838f $ **FLOATING
C1312 a_18688_15869# VSS 0.00838f $ **FLOATING
C1313 a_18162_15869# VSS 0.00838f $ **FLOATING
C1314 a_17636_15869# VSS 0.00838f $ **FLOATING
C1315 a_17110_15869# VSS 0.00838f $ **FLOATING
C1316 a_16584_15869# VSS 0.00838f $ **FLOATING
C1317 a_16058_15869# VSS 0.00838f $ **FLOATING
C1318 a_15532_15869# VSS 0.00838f $ **FLOATING
C1319 a_15006_15869# VSS 0.00838f $ **FLOATING
C1320 a_14480_15869# VSS 0.00838f $ **FLOATING
C1321 a_13954_15869# VSS 0.00838f $ **FLOATING
C1322 a_13428_15869# VSS 0.00838f $ **FLOATING
C1323 a_12902_15869# VSS 0.00838f $ **FLOATING
C1324 a_12376_15869# VSS 0.00838f $ **FLOATING
C1325 a_11850_15869# VSS 0.00838f $ **FLOATING
C1326 a_11324_15869# VSS 0.00838f $ **FLOATING
C1327 a_10798_15869# VSS 0.00838f $ **FLOATING
C1328 a_10272_15869# VSS 0.00838f $ **FLOATING
C1329 a_9746_15869# VSS 0.00838f $ **FLOATING
C1330 a_9220_15869# VSS 0.00838f $ **FLOATING
C1331 a_8694_15869# VSS 0.00838f $ **FLOATING
C1332 a_8168_15869# VSS 0.00838f $ **FLOATING
C1333 a_7642_15869# VSS 0.00838f $ **FLOATING
C1334 a_7116_15869# VSS 0.00838f $ **FLOATING
C1335 a_6590_15869# VSS 0.00838f $ **FLOATING
C1336 a_6064_15869# VSS 0.00838f $ **FLOATING
C1337 a_5538_15869# VSS 0.00838f $ **FLOATING
C1338 a_5012_15869# VSS 0.00838f $ **FLOATING
C1339 a_4486_15869# VSS 0.00838f $ **FLOATING
C1340 a_3960_15869# VSS 0.00838f $ **FLOATING
C1341 a_3434_15869# VSS 0.00838f $ **FLOATING
C1342 6to4_0.buff_PI_d32_0.buff_PI_d16$1_0.inv_PI_d4$1_0.VIN VSS 2.45549f
C1343 6to4_0.flywheel_clk_0.PH0 VSS 2.43769f
C1344 6to4_0.PI_clk_0.inv_PI_d2$1_0.VOUT VSS 2.02917f
C1345 6ph_rosc_0.PH1 VSS 16.49791f
C1346 a_19214_16570# VSS 0.00838f $ **FLOATING
C1347 a_18688_16570# VSS 0.00838f $ **FLOATING
C1348 a_18162_16570# VSS 0.00838f $ **FLOATING
C1349 a_17636_16570# VSS 0.00838f $ **FLOATING
C1350 a_17110_16570# VSS 0.00838f $ **FLOATING
C1351 a_16584_16570# VSS 0.00838f $ **FLOATING
C1352 a_16058_16570# VSS 0.00838f $ **FLOATING
C1353 a_15532_16570# VSS 0.00838f $ **FLOATING
C1354 a_15006_16570# VSS 0.00838f $ **FLOATING
C1355 a_14480_16570# VSS 0.00838f $ **FLOATING
C1356 a_13954_16570# VSS 0.00838f $ **FLOATING
C1357 a_13428_16570# VSS 0.00838f $ **FLOATING
C1358 a_12902_16570# VSS 0.00838f $ **FLOATING
C1359 a_12376_16570# VSS 0.00838f $ **FLOATING
C1360 a_11850_16570# VSS 0.00838f $ **FLOATING
C1361 a_11324_16570# VSS 0.00838f $ **FLOATING
C1362 a_10798_16570# VSS 0.00838f $ **FLOATING
C1363 a_10272_16570# VSS 0.00838f $ **FLOATING
C1364 a_9746_16570# VSS 0.00838f $ **FLOATING
C1365 a_9220_16570# VSS 0.00838f $ **FLOATING
C1366 a_8694_16570# VSS 0.00838f $ **FLOATING
C1367 a_8168_16570# VSS 0.00838f $ **FLOATING
C1368 a_7642_16570# VSS 0.00838f $ **FLOATING
C1369 a_7116_16570# VSS 0.00838f $ **FLOATING
C1370 a_6590_16570# VSS 0.00838f $ **FLOATING
C1371 a_6064_16570# VSS 0.00838f $ **FLOATING
C1372 a_5538_16570# VSS 0.00838f $ **FLOATING
C1373 a_5012_16570# VSS 0.00838f $ **FLOATING
C1374 a_4486_16570# VSS 0.00838f $ **FLOATING
C1375 a_3960_16570# VSS 0.00838f $ **FLOATING
C1376 a_3434_16570# VSS 0.00838f $ **FLOATING
C1377 PH90 VSS 9.4384f
C1378 6to4_0.buff_PI_d32_0.inv_PI_d32_0.VIN VSS 19.7384f
C1379 6to4_0.buff_PI_d32_0.inv_PI_d16$1_0.VIN VSS 13.25281f
C1380 6to4_0.buff_PI_d32_0.buff_PI_d16$1_0.inv_PI_d4$1_0.VOUT VSS 5.02843f
C1381 6ph_rosc_0.psdiff_1.buff_d8$1_0.inv$3_0.VIN VSS 0.01372f
C1382 6ph_rosc_0.psdiff_1.buff_d8$1_0.VIN.t32 VSS 0.05604f
C1383 6ph_rosc_0.psdiff_1.buff_d8$1_0.VIN.t13 VSS 0.02504f
C1384 6ph_rosc_0.psdiff_1.buff_d8$1_0.VIN.t6 VSS 0.02476f
C1385 6ph_rosc_0.psdiff_1.buff_d8$1_0.VIN.n0 VSS 0.03167f
C1386 6ph_rosc_0.psdiff_1.buff_d8$1_0.VIN.t12 VSS 0.02476f
C1387 6ph_rosc_0.psdiff_1.buff_d8$1_0.VIN.n1 VSS 0.01463f
C1388 6ph_rosc_0.psdiff_1.buff_d8$1_0.VIN.t10 VSS 0.02504f
C1389 6ph_rosc_0.psdiff_1.buff_d8$1_0.VIN.t2 VSS 0.02476f
C1390 6ph_rosc_0.psdiff_1.buff_d8$1_0.VIN.n2 VSS 0.03167f
C1391 6ph_rosc_0.psdiff_1.buff_d8$1_0.VIN.t8 VSS 0.02476f
C1392 6ph_rosc_0.psdiff_1.buff_d8$1_0.VIN.n3 VSS 0.01463f
C1393 6ph_rosc_0.psdiff_1.buff_d8$1_0.VIN.t30 VSS 0.02255f
C1394 6ph_rosc_0.psdiff_1.buff_d8$1_0.VIN.t5 VSS 0.02504f
C1395 6ph_rosc_0.psdiff_1.buff_d8$1_0.VIN.t7 VSS 0.02476f
C1396 6ph_rosc_0.psdiff_1.buff_d8$1_0.VIN.n4 VSS 0.03167f
C1397 6ph_rosc_0.psdiff_1.buff_d8$1_0.VIN.t3 VSS 0.02476f
C1398 6ph_rosc_0.psdiff_1.buff_d8$1_0.VIN.n5 VSS 0.01463f
C1399 6ph_rosc_0.psdiff_1.buff_d8$1_0.VIN.t19 VSS 0.02504f
C1400 6ph_rosc_0.psdiff_1.buff_d8$1_0.VIN.t23 VSS 0.02476f
C1401 6ph_rosc_0.psdiff_1.buff_d8$1_0.VIN.n6 VSS 0.03804f
C1402 6ph_rosc_0.psdiff_1.buff_d8$1_0.VIN.t27 VSS 0.02476f
C1403 6ph_rosc_0.psdiff_1.buff_d8$1_0.VIN.t17 VSS 0.02504f
C1404 6ph_rosc_0.psdiff_1.buff_d8$1_0.VIN.t16 VSS 0.02476f
C1405 6ph_rosc_0.psdiff_1.buff_d8$1_0.VIN.n7 VSS 0.03872f
C1406 6ph_rosc_0.psdiff_1.buff_d8$1_0.VIN.t29 VSS 0.02476f
C1407 6ph_rosc_0.psdiff_1.buff_d8$1_0.VIN.n8 VSS 0.02168f
C1408 6ph_rosc_0.psdiff_1.buff_d8$1_0.VIN.t20 VSS 0.02504f
C1409 6ph_rosc_0.psdiff_1.buff_d8$1_0.VIN.t24 VSS 0.02476f
C1410 6ph_rosc_0.psdiff_1.buff_d8$1_0.VIN.n9 VSS 0.03872f
C1411 6ph_rosc_0.psdiff_1.buff_d8$1_0.VIN.t28 VSS 0.02476f
C1412 6ph_rosc_0.psdiff_1.buff_d8$1_0.VIN.n10 VSS 0.02168f
C1413 6ph_rosc_0.psdiff_1.buff_d8$1_0.VIN.t22 VSS 0.02504f
C1414 6ph_rosc_0.psdiff_1.buff_d8$1_0.VIN.t15 VSS 0.02476f
C1415 6ph_rosc_0.psdiff_1.buff_d8$1_0.VIN.n11 VSS 0.03872f
C1416 6ph_rosc_0.psdiff_1.buff_d8$1_0.VIN.t26 VSS 0.02476f
C1417 6ph_rosc_0.psdiff_1.buff_d8$1_0.VIN.n12 VSS 0.02168f
C1418 6ph_rosc_0.psdiff_1.buff_d8$1_0.VIN.t21 VSS 0.02504f
C1419 6ph_rosc_0.psdiff_1.buff_d8$1_0.VIN.t18 VSS 0.02476f
C1420 6ph_rosc_0.psdiff_1.buff_d8$1_0.VIN.n13 VSS 0.03872f
C1421 6ph_rosc_0.psdiff_1.buff_d8$1_0.VIN.t25 VSS 0.02476f
C1422 6ph_rosc_0.psdiff_1.buff_d8$1_0.VIN.n14 VSS 0.04427f
C1423 6ph_rosc_0.psdiff_1.buff_d8$1_0.VIN.n15 VSS 0.05236f
C1424 6ph_rosc_0.psdiff_1.buff_d8$1_0.VIN.n16 VSS 0.04622f
C1425 6ph_rosc_0.psdiff_1.buff_d8$1_0.VIN.n17 VSS 0.05155f
C1426 6ph_rosc_0.psdiff_1.buff_d8$1_0.VIN.n18 VSS 0.14936f
C1427 6ph_rosc_0.psdiff_1.buff_d8$1_0.VIN.t31 VSS 0.02242f
C1428 6ph_rosc_0.psdiff_1.buff_d8$1_0.VIN.n19 VSS 0.11155f
C1429 6ph_rosc_0.psdiff_1.buff_d8$1_0.VIN.t11 VSS 0.02504f
C1430 6ph_rosc_0.psdiff_1.buff_d8$1_0.VIN.t1 VSS 0.02476f
C1431 6ph_rosc_0.psdiff_1.buff_d8$1_0.VIN.n20 VSS 0.03167f
C1432 6ph_rosc_0.psdiff_1.buff_d8$1_0.VIN.t9 VSS 0.02476f
C1433 6ph_rosc_0.psdiff_1.buff_d8$1_0.VIN.n21 VSS 0.01463f
C1434 6ph_rosc_0.psdiff_1.buff_d8$1_0.VIN.n22 VSS 0.03402f
C1435 6ph_rosc_0.psdiff_1.buff_d8$1_0.VIN.n23 VSS 0.06198f
C1436 6ph_rosc_0.psdiff_1.buff_d8$1_0.VIN.n24 VSS 0.04622f
C1437 6ph_rosc_0.psdiff_1.buff_d8$1_0.VIN.n25 VSS 0.05236f
C1438 6ph_rosc_0.psdiff_1.buff_d8$1_0.VIN.t0 VSS 0.02476f
C1439 6ph_rosc_0.psdiff_1.buff_d8$1_0.VIN.n26 VSS 0.03722f
C1440 6ph_rosc_0.psdiff_1.buff_d8$1_0.VIN.t14 VSS 0.02476f
C1441 6ph_rosc_0.psdiff_1.buff_d8$1_0.VIN.n27 VSS 0.01766f
C1442 6ph_rosc_0.psdiff_1.buff_d8$1_0.VIN.t4 VSS 0.02476f
C1443 6ph_rosc_0.psdiff_1.buff_d8$1_0.VIN.n28 VSS 0.15048f
C1444 6ph_rosc_0.psdiff_1.buff_d8$1_0.VIN.n29 VSS 0.1415f
C1445 6to4_0.buff_PI_d32_0.buff_PI_d16$1_0.inv_PI_d4$1_0.VOUT.t8 VSS 0.02523f
C1446 6to4_0.buff_PI_d32_0.buff_PI_d16$1_0.inv_PI_d4$1_0.VOUT.t13 VSS 0.1872f
C1447 6to4_0.buff_PI_d32_0.buff_PI_d16$1_0.inv_PI_d4$1_0.VOUT.n0 VSS 0.02105f
C1448 6to4_0.buff_PI_d32_0.buff_PI_d16$1_0.inv_PI_d4$1_0.VOUT.t14 VSS 0.1872f
C1449 6to4_0.buff_PI_d32_0.buff_PI_d16$1_0.inv_PI_d4$1_0.VOUT.n1 VSS 0.01527f
C1450 6to4_0.buff_PI_d32_0.buff_PI_d16$1_0.inv_PI_d4$1_0.VOUT.n2 VSS 0.18487f
C1451 6to4_0.buff_PI_d32_0.buff_PI_d16$1_0.inv_PI_d4$1_0.VOUT.t17 VSS 0.1872f
C1452 6to4_0.buff_PI_d32_0.buff_PI_d16$1_0.inv_PI_d4$1_0.VOUT.n3 VSS 0.01119f
C1453 6to4_0.buff_PI_d32_0.buff_PI_d16$1_0.inv_PI_d4$1_0.VOUT.n4 VSS 0.11896f
C1454 6to4_0.buff_PI_d32_0.buff_PI_d16$1_0.inv_PI_d4$1_0.VOUT.t15 VSS 0.1872f
C1455 6to4_0.buff_PI_d32_0.buff_PI_d16$1_0.inv_PI_d4$1_0.VOUT.n5 VSS 0.01527f
C1456 6to4_0.buff_PI_d32_0.buff_PI_d16$1_0.inv_PI_d4$1_0.VOUT.n6 VSS 0.11896f
C1457 6to4_0.buff_PI_d32_0.buff_PI_d16$1_0.inv_PI_d4$1_0.VOUT.t19 VSS 0.1872f
C1458 6to4_0.buff_PI_d32_0.buff_PI_d16$1_0.inv_PI_d4$1_0.VOUT.n7 VSS 0.01119f
C1459 6to4_0.buff_PI_d32_0.buff_PI_d16$1_0.inv_PI_d4$1_0.VOUT.n8 VSS 0.11896f
C1460 6to4_0.buff_PI_d32_0.buff_PI_d16$1_0.inv_PI_d4$1_0.VOUT.t16 VSS 0.1872f
C1461 6to4_0.buff_PI_d32_0.buff_PI_d16$1_0.inv_PI_d4$1_0.VOUT.n9 VSS 0.01527f
C1462 6to4_0.buff_PI_d32_0.buff_PI_d16$1_0.inv_PI_d4$1_0.VOUT.n10 VSS 0.11896f
C1463 6to4_0.buff_PI_d32_0.buff_PI_d16$1_0.inv_PI_d4$1_0.VOUT.t12 VSS 0.1872f
C1464 6to4_0.buff_PI_d32_0.buff_PI_d16$1_0.inv_PI_d4$1_0.VOUT.n11 VSS 0.01119f
C1465 6to4_0.buff_PI_d32_0.buff_PI_d16$1_0.inv_PI_d4$1_0.VOUT.n12 VSS 0.11896f
C1466 6to4_0.buff_PI_d32_0.buff_PI_d16$1_0.inv_PI_d4$1_0.VOUT.t18 VSS 0.1872f
C1467 6to4_0.buff_PI_d32_0.buff_PI_d16$1_0.inv_PI_d4$1_0.VOUT.n13 VSS 0.01527f
C1468 6to4_0.buff_PI_d32_0.buff_PI_d16$1_0.inv_PI_d4$1_0.VOUT.n14 VSS 0.27467f
C1469 6to4_0.buff_PI_d32_0.buff_PI_d16$1_0.inv_PI_d4$1_0.VOUT.n15 VSS 0.11905f
C1470 6to4_0.buff_PI_d32_0.buff_PI_d16$1_0.inv_PI_d4$1_0.VOUT.t2 VSS 0.02582f
C1471 6to4_0.buff_PI_d32_0.buff_PI_d16$1_0.inv_PI_d4$1_0.VOUT.t7 VSS 0.02286f
C1472 6to4_0.buff_PI_d32_0.buff_PI_d16$1_0.inv_PI_d4$1_0.VOUT.t10 VSS 0.02286f
C1473 6to4_0.buff_PI_d32_0.buff_PI_d16$1_0.inv_PI_d4$1_0.VOUT.t0 VSS 0.02582f
C1474 6to4_0.buff_PI_d32_0.buff_PI_d16$1_0.inv_PI_d4$1_0.VOUT.t5 VSS 0.02523f
C1475 6to4_0.buff_PI_d32_0.buff_PI_d16$1_0.inv_PI_d4$1_0.VOUT.t4 VSS 0.02523f
C1476 6to4_0.buff_PI_d32_0.buff_PI_d16$1_0.inv_PI_d4$1_0.VOUT.t9 VSS 0.02286f
C1477 6to4_0.buff_PI_d32_0.buff_PI_d16$1_0.inv_PI_d4$1_0.VOUT.t11 VSS 0.02286f
C1478 6to4_0.buff_PI_d32_0.buff_PI_d16$1_0.inv_PI_d4$1_0.VOUT.t1 VSS 0.02582f
C1479 6to4_0.buff_PI_d32_0.buff_PI_d16$1_0.inv_PI_d4$1_0.VOUT.t6 VSS 0.02575f
C1480 6to4_0.buff_PI_d32_0.buff_PI_d16$1_0.inv_PI_d4$1_0.VOUT.n16 VSS 0.04795f
C1481 6to4_0.buff_PI_d32_0.buff_PI_d16$1_0.inv_PI_d4$1_0.VOUT.n17 VSS 0.04275f
C1482 6to4_0.buff_PI_d32_0.buff_PI_d16$1_0.inv_PI_d4$1_0.VOUT.n18 VSS 0.03334f
C1483 6to4_0.buff_PI_d32_0.buff_PI_d16$1_0.inv_PI_d4$1_0.VOUT.t3 VSS 0.02582f
C1484 6to4_0.buff_PI_d32_0.buff_PI_d16$1_0.inv_PI_d4$1_0.VOUT.n19 VSS 0.04705f
C1485 6to4_0.buff_PI_d32_0.buff_PI_d16$1_0.inv_PI_d4$1_0.VOUT.n20 VSS 0.06175f
C1486 6to4_0.buff_PI_d32_0.buff_PI_d16$1_0.inv_PI_d4$1_0.VOUT.n21 VSS 0.06175f
C1487 6to4_0.buff_PI_d32_0.buff_PI_d16$1_0.inv_PI_d4$1_0.VOUT.n22 VSS 0.04795f
C1488 6to4_0.buff_PI_d32_0.buff_PI_d16$1_0.inv_PI_d4$1_0.VOUT.n23 VSS 0.04275f
C1489 6to4_0.buff_PI_d32_0.buff_PI_d16$1_0.inv_PI_d4$1_0.VOUT.n24 VSS 0.03334f
C1490 6to4_0.buff_PI_d32_0.buff_PI_d16$1_0.inv_PI_d4$1_0.VOUT.n25 VSS 0.04705f
C1491 6ph_rosc_0.psdiff_2.buff_d8$1_0.inv$3_0.VIN VSS 0.01372f
C1492 6ph_rosc_0.psdiff_2.buff_d8$1_0.VIN.t32 VSS 0.05604f
C1493 6ph_rosc_0.psdiff_2.buff_d8$1_0.VIN.t12 VSS 0.02504f
C1494 6ph_rosc_0.psdiff_2.buff_d8$1_0.VIN.t19 VSS 0.02476f
C1495 6ph_rosc_0.psdiff_2.buff_d8$1_0.VIN.n0 VSS 0.03167f
C1496 6ph_rosc_0.psdiff_2.buff_d8$1_0.VIN.t21 VSS 0.02476f
C1497 6ph_rosc_0.psdiff_2.buff_d8$1_0.VIN.n1 VSS 0.01463f
C1498 6ph_rosc_0.psdiff_2.buff_d8$1_0.VIN.t15 VSS 0.02504f
C1499 6ph_rosc_0.psdiff_2.buff_d8$1_0.VIN.t23 VSS 0.02476f
C1500 6ph_rosc_0.psdiff_2.buff_d8$1_0.VIN.n2 VSS 0.03167f
C1501 6ph_rosc_0.psdiff_2.buff_d8$1_0.VIN.t14 VSS 0.02476f
C1502 6ph_rosc_0.psdiff_2.buff_d8$1_0.VIN.n3 VSS 0.01463f
C1503 6ph_rosc_0.psdiff_2.buff_d8$1_0.VIN.t10 VSS 0.02255f
C1504 6ph_rosc_0.psdiff_2.buff_d8$1_0.VIN.t13 VSS 0.02504f
C1505 6ph_rosc_0.psdiff_2.buff_d8$1_0.VIN.t20 VSS 0.02476f
C1506 6ph_rosc_0.psdiff_2.buff_d8$1_0.VIN.n4 VSS 0.03167f
C1507 6ph_rosc_0.psdiff_2.buff_d8$1_0.VIN.t22 VSS 0.02476f
C1508 6ph_rosc_0.psdiff_2.buff_d8$1_0.VIN.n5 VSS 0.01463f
C1509 6ph_rosc_0.psdiff_2.buff_d8$1_0.VIN.t26 VSS 0.02504f
C1510 6ph_rosc_0.psdiff_2.buff_d8$1_0.VIN.t17 VSS 0.02476f
C1511 6ph_rosc_0.psdiff_2.buff_d8$1_0.VIN.n6 VSS 0.03167f
C1512 6ph_rosc_0.psdiff_2.buff_d8$1_0.VIN.t24 VSS 0.02476f
C1513 6ph_rosc_0.psdiff_2.buff_d8$1_0.VIN.n7 VSS 0.01463f
C1514 6ph_rosc_0.psdiff_2.buff_d8$1_0.VIN.t11 VSS 0.02242f
C1515 6ph_rosc_0.psdiff_2.buff_d8$1_0.VIN.t0 VSS 0.02504f
C1516 6ph_rosc_0.psdiff_2.buff_d8$1_0.VIN.t6 VSS 0.02476f
C1517 6ph_rosc_0.psdiff_2.buff_d8$1_0.VIN.n8 VSS 0.03804f
C1518 6ph_rosc_0.psdiff_2.buff_d8$1_0.VIN.t8 VSS 0.02504f
C1519 6ph_rosc_0.psdiff_2.buff_d8$1_0.VIN.t3 VSS 0.02476f
C1520 6ph_rosc_0.psdiff_2.buff_d8$1_0.VIN.n9 VSS 0.03872f
C1521 6ph_rosc_0.psdiff_2.buff_d8$1_0.VIN.t29 VSS 0.02476f
C1522 6ph_rosc_0.psdiff_2.buff_d8$1_0.VIN.n10 VSS 0.02168f
C1523 6ph_rosc_0.psdiff_2.buff_d8$1_0.VIN.t5 VSS 0.02504f
C1524 6ph_rosc_0.psdiff_2.buff_d8$1_0.VIN.t2 VSS 0.02476f
C1525 6ph_rosc_0.psdiff_2.buff_d8$1_0.VIN.n11 VSS 0.03872f
C1526 6ph_rosc_0.psdiff_2.buff_d8$1_0.VIN.t28 VSS 0.02476f
C1527 6ph_rosc_0.psdiff_2.buff_d8$1_0.VIN.n12 VSS 0.02168f
C1528 6ph_rosc_0.psdiff_2.buff_d8$1_0.VIN.t1 VSS 0.02504f
C1529 6ph_rosc_0.psdiff_2.buff_d8$1_0.VIN.t7 VSS 0.02476f
C1530 6ph_rosc_0.psdiff_2.buff_d8$1_0.VIN.n13 VSS 0.03872f
C1531 6ph_rosc_0.psdiff_2.buff_d8$1_0.VIN.t27 VSS 0.02476f
C1532 6ph_rosc_0.psdiff_2.buff_d8$1_0.VIN.n14 VSS 0.04427f
C1533 6ph_rosc_0.psdiff_2.buff_d8$1_0.VIN.t9 VSS 0.02504f
C1534 6ph_rosc_0.psdiff_2.buff_d8$1_0.VIN.t4 VSS 0.02476f
C1535 6ph_rosc_0.psdiff_2.buff_d8$1_0.VIN.n15 VSS 0.03872f
C1536 6ph_rosc_0.psdiff_2.buff_d8$1_0.VIN.t30 VSS 0.02476f
C1537 6ph_rosc_0.psdiff_2.buff_d8$1_0.VIN.n16 VSS 0.02168f
C1538 6ph_rosc_0.psdiff_2.buff_d8$1_0.VIN.n17 VSS 0.05236f
C1539 6ph_rosc_0.psdiff_2.buff_d8$1_0.VIN.n18 VSS 0.04622f
C1540 6ph_rosc_0.psdiff_2.buff_d8$1_0.VIN.n19 VSS 0.05155f
C1541 6ph_rosc_0.psdiff_2.buff_d8$1_0.VIN.t31 VSS 0.02476f
C1542 6ph_rosc_0.psdiff_2.buff_d8$1_0.VIN.n20 VSS 0.14936f
C1543 6ph_rosc_0.psdiff_2.buff_d8$1_0.VIN.n21 VSS 0.11155f
C1544 6ph_rosc_0.psdiff_2.buff_d8$1_0.VIN.n22 VSS 0.03402f
C1545 6ph_rosc_0.psdiff_2.buff_d8$1_0.VIN.n23 VSS 0.06198f
C1546 6ph_rosc_0.psdiff_2.buff_d8$1_0.VIN.n24 VSS 0.04622f
C1547 6ph_rosc_0.psdiff_2.buff_d8$1_0.VIN.n25 VSS 0.05236f
C1548 6ph_rosc_0.psdiff_2.buff_d8$1_0.VIN.t16 VSS 0.02476f
C1549 6ph_rosc_0.psdiff_2.buff_d8$1_0.VIN.n26 VSS 0.03722f
C1550 6ph_rosc_0.psdiff_2.buff_d8$1_0.VIN.t25 VSS 0.02476f
C1551 6ph_rosc_0.psdiff_2.buff_d8$1_0.VIN.n27 VSS 0.01766f
C1552 6ph_rosc_0.psdiff_2.buff_d8$1_0.VIN.t18 VSS 0.02476f
C1553 6ph_rosc_0.psdiff_2.buff_d8$1_0.VIN.n28 VSS 0.15048f
C1554 6ph_rosc_0.psdiff_2.buff_d8$1_0.VIN.n29 VSS 0.1415f
C1555 6to4_0.buff_PI_d32_1.buff_PI_d16$1_0.inv_PI_d4$1_0.VOUT.t7 VSS 0.02523f
C1556 6to4_0.buff_PI_d32_1.buff_PI_d16$1_0.inv_PI_d4$1_0.VOUT.t15 VSS 0.1872f
C1557 6to4_0.buff_PI_d32_1.buff_PI_d16$1_0.inv_PI_d4$1_0.VOUT.n0 VSS 0.02105f
C1558 6to4_0.buff_PI_d32_1.buff_PI_d16$1_0.inv_PI_d4$1_0.VOUT.t16 VSS 0.1872f
C1559 6to4_0.buff_PI_d32_1.buff_PI_d16$1_0.inv_PI_d4$1_0.VOUT.n1 VSS 0.01527f
C1560 6to4_0.buff_PI_d32_1.buff_PI_d16$1_0.inv_PI_d4$1_0.VOUT.n2 VSS 0.18487f
C1561 6to4_0.buff_PI_d32_1.buff_PI_d16$1_0.inv_PI_d4$1_0.VOUT.t14 VSS 0.1872f
C1562 6to4_0.buff_PI_d32_1.buff_PI_d16$1_0.inv_PI_d4$1_0.VOUT.n3 VSS 0.01119f
C1563 6to4_0.buff_PI_d32_1.buff_PI_d16$1_0.inv_PI_d4$1_0.VOUT.n4 VSS 0.11896f
C1564 6to4_0.buff_PI_d32_1.buff_PI_d16$1_0.inv_PI_d4$1_0.VOUT.t18 VSS 0.1872f
C1565 6to4_0.buff_PI_d32_1.buff_PI_d16$1_0.inv_PI_d4$1_0.VOUT.n5 VSS 0.01527f
C1566 6to4_0.buff_PI_d32_1.buff_PI_d16$1_0.inv_PI_d4$1_0.VOUT.n6 VSS 0.11896f
C1567 6to4_0.buff_PI_d32_1.buff_PI_d16$1_0.inv_PI_d4$1_0.VOUT.t17 VSS 0.1872f
C1568 6to4_0.buff_PI_d32_1.buff_PI_d16$1_0.inv_PI_d4$1_0.VOUT.n7 VSS 0.01119f
C1569 6to4_0.buff_PI_d32_1.buff_PI_d16$1_0.inv_PI_d4$1_0.VOUT.n8 VSS 0.11896f
C1570 6to4_0.buff_PI_d32_1.buff_PI_d16$1_0.inv_PI_d4$1_0.VOUT.t19 VSS 0.1872f
C1571 6to4_0.buff_PI_d32_1.buff_PI_d16$1_0.inv_PI_d4$1_0.VOUT.n9 VSS 0.01527f
C1572 6to4_0.buff_PI_d32_1.buff_PI_d16$1_0.inv_PI_d4$1_0.VOUT.n10 VSS 0.11896f
C1573 6to4_0.buff_PI_d32_1.buff_PI_d16$1_0.inv_PI_d4$1_0.VOUT.t12 VSS 0.1872f
C1574 6to4_0.buff_PI_d32_1.buff_PI_d16$1_0.inv_PI_d4$1_0.VOUT.n11 VSS 0.01119f
C1575 6to4_0.buff_PI_d32_1.buff_PI_d16$1_0.inv_PI_d4$1_0.VOUT.n12 VSS 0.11896f
C1576 6to4_0.buff_PI_d32_1.buff_PI_d16$1_0.inv_PI_d4$1_0.VOUT.t13 VSS 0.1872f
C1577 6to4_0.buff_PI_d32_1.buff_PI_d16$1_0.inv_PI_d4$1_0.VOUT.n13 VSS 0.01527f
C1578 6to4_0.buff_PI_d32_1.buff_PI_d16$1_0.inv_PI_d4$1_0.VOUT.n14 VSS 0.27467f
C1579 6to4_0.buff_PI_d32_1.buff_PI_d16$1_0.inv_PI_d4$1_0.VOUT.n15 VSS 0.11905f
C1580 6to4_0.buff_PI_d32_1.buff_PI_d16$1_0.inv_PI_d4$1_0.VOUT.t2 VSS 0.02582f
C1581 6to4_0.buff_PI_d32_1.buff_PI_d16$1_0.inv_PI_d4$1_0.VOUT.t5 VSS 0.02286f
C1582 6to4_0.buff_PI_d32_1.buff_PI_d16$1_0.inv_PI_d4$1_0.VOUT.t9 VSS 0.02286f
C1583 6to4_0.buff_PI_d32_1.buff_PI_d16$1_0.inv_PI_d4$1_0.VOUT.t0 VSS 0.02582f
C1584 6to4_0.buff_PI_d32_1.buff_PI_d16$1_0.inv_PI_d4$1_0.VOUT.t6 VSS 0.02523f
C1585 6to4_0.buff_PI_d32_1.buff_PI_d16$1_0.inv_PI_d4$1_0.VOUT.t10 VSS 0.02523f
C1586 6to4_0.buff_PI_d32_1.buff_PI_d16$1_0.inv_PI_d4$1_0.VOUT.t8 VSS 0.02286f
C1587 6to4_0.buff_PI_d32_1.buff_PI_d16$1_0.inv_PI_d4$1_0.VOUT.t11 VSS 0.02286f
C1588 6to4_0.buff_PI_d32_1.buff_PI_d16$1_0.inv_PI_d4$1_0.VOUT.t1 VSS 0.02582f
C1589 6to4_0.buff_PI_d32_1.buff_PI_d16$1_0.inv_PI_d4$1_0.VOUT.t4 VSS 0.02575f
C1590 6to4_0.buff_PI_d32_1.buff_PI_d16$1_0.inv_PI_d4$1_0.VOUT.n16 VSS 0.04795f
C1591 6to4_0.buff_PI_d32_1.buff_PI_d16$1_0.inv_PI_d4$1_0.VOUT.n17 VSS 0.04275f
C1592 6to4_0.buff_PI_d32_1.buff_PI_d16$1_0.inv_PI_d4$1_0.VOUT.n18 VSS 0.03334f
C1593 6to4_0.buff_PI_d32_1.buff_PI_d16$1_0.inv_PI_d4$1_0.VOUT.t3 VSS 0.02582f
C1594 6to4_0.buff_PI_d32_1.buff_PI_d16$1_0.inv_PI_d4$1_0.VOUT.n19 VSS 0.04705f
C1595 6to4_0.buff_PI_d32_1.buff_PI_d16$1_0.inv_PI_d4$1_0.VOUT.n20 VSS 0.06175f
C1596 6to4_0.buff_PI_d32_1.buff_PI_d16$1_0.inv_PI_d4$1_0.VOUT.n21 VSS 0.06175f
C1597 6to4_0.buff_PI_d32_1.buff_PI_d16$1_0.inv_PI_d4$1_0.VOUT.n22 VSS 0.04795f
C1598 6to4_0.buff_PI_d32_1.buff_PI_d16$1_0.inv_PI_d4$1_0.VOUT.n23 VSS 0.04275f
C1599 6to4_0.buff_PI_d32_1.buff_PI_d16$1_0.inv_PI_d4$1_0.VOUT.n24 VSS 0.03334f
C1600 6to4_0.buff_PI_d32_1.buff_PI_d16$1_0.inv_PI_d4$1_0.VOUT.n25 VSS 0.04705f
C1601 6to4_0.buff_PI_d32_0.buff_PI_d16$1_0.inv_PI_d8$1_0.VOUT.t20 VSS 0.0351f
C1602 6to4_0.buff_PI_d32_0.buff_PI_d16$1_0.inv_PI_d8$1_0.VOUT.t36 VSS 0.2604f
C1603 6to4_0.buff_PI_d32_0.buff_PI_d16$1_0.inv_PI_d16$1_0.inv_PI_d8$1_1.inv_PI_d4$1_1.inv_PI_d2$1_0.inv_PI$1_1.VIN VSS 0.00566f
C1604 6to4_0.buff_PI_d32_0.buff_PI_d16$1_0.inv_PI_d16$1_0.inv_PI_d8$1_1.inv_PI_d4$1_1.inv_PI_d2$1_0.VIN VSS 0.00708f
C1605 6to4_0.buff_PI_d32_0.buff_PI_d16$1_0.inv_PI_d8$1_0.VOUT.n0 VSS 0.01557f
C1606 6to4_0.buff_PI_d32_0.buff_PI_d16$1_0.inv_PI_d8$1_0.VOUT.n1 VSS 0.12379f
C1607 6to4_0.buff_PI_d32_0.buff_PI_d16$1_0.inv_PI_d8$1_0.VOUT.t39 VSS 0.2604f
C1608 6to4_0.buff_PI_d32_0.buff_PI_d16$1_0.inv_PI_d16$1_0.inv_PI_d8$1_0.inv_PI_d4$1_1.inv_PI_d2$1_1.inv_PI$1_1.VIN VSS 0.00472f
C1609 6to4_0.buff_PI_d32_0.buff_PI_d16$1_0.inv_PI_d16$1_0.inv_PI_d8$1_0.inv_PI_d4$1_1.VIN VSS 0.00566f
C1610 6to4_0.buff_PI_d32_0.buff_PI_d16$1_0.inv_PI_d16$1_0.inv_PI_d8$1_0.inv_PI_d4$1_1.inv_PI_d2$1_1.VIN VSS 0.00236f
C1611 6to4_0.buff_PI_d32_0.buff_PI_d16$1_0.inv_PI_d8$1_0.VOUT.n2 VSS 0.02929f
C1612 6to4_0.buff_PI_d32_0.buff_PI_d16$1_0.inv_PI_d8$1_0.VOUT.t32 VSS 0.2604f
C1613 6to4_0.buff_PI_d32_0.buff_PI_d16$1_0.inv_PI_d16$1_0.inv_PI_d8$1_0.inv_PI_d4$1_1.inv_PI_d2$1_1.inv_PI$1_0.VIN VSS 0.00708f
C1614 6to4_0.buff_PI_d32_0.buff_PI_d16$1_0.inv_PI_d8$1_0.VOUT.n3 VSS 0.02123f
C1615 6to4_0.buff_PI_d32_0.buff_PI_d16$1_0.inv_PI_d8$1_0.VOUT.n4 VSS 0.2153f
C1616 6to4_0.buff_PI_d32_0.buff_PI_d16$1_0.inv_PI_d8$1_0.VOUT.t35 VSS 0.2604f
C1617 6to4_0.buff_PI_d32_0.buff_PI_d16$1_0.inv_PI_d16$1_0.inv_PI_d8$1_0.inv_PI_d4$1_0.inv_PI_d2$1_1.inv_PI$1_1.VIN VSS 0.00472f
C1618 6to4_0.buff_PI_d32_0.buff_PI_d16$1_0.inv_PI_d16$1_0.inv_PI_d8$1_0.inv_PI_d4$1_0.VIN VSS 0.00566f
C1619 6to4_0.buff_PI_d32_0.buff_PI_d16$1_0.inv_PI_d16$1_0.inv_PI_d8$1_0.inv_PI_d4$1_0.inv_PI_d2$1_1.VIN VSS 0.00236f
C1620 6to4_0.buff_PI_d32_0.buff_PI_d16$1_0.inv_PI_d8$1_0.VOUT.n5 VSS 0.01557f
C1621 6to4_0.buff_PI_d32_0.buff_PI_d16$1_0.inv_PI_d8$1_0.VOUT.n6 VSS 0.12379f
C1622 6to4_0.buff_PI_d32_0.buff_PI_d16$1_0.inv_PI_d8$1_0.VOUT.t29 VSS 0.2604f
C1623 6to4_0.buff_PI_d32_0.buff_PI_d16$1_0.inv_PI_d16$1_0.inv_PI_d8$1_1.inv_PI_d4$1_1.inv_PI_d2$1_0.inv_PI$1_0.VIN VSS 0.00708f
C1624 6to4_0.buff_PI_d32_0.buff_PI_d16$1_0.inv_PI_d8$1_0.VOUT.n7 VSS 0.02123f
C1625 6to4_0.buff_PI_d32_0.buff_PI_d16$1_0.inv_PI_d8$1_0.VOUT.n8 VSS 0.12363f
C1626 6to4_0.buff_PI_d32_0.buff_PI_d16$1_0.inv_PI_d8$1_0.VOUT.t27 VSS 0.2604f
C1627 6to4_0.buff_PI_d32_0.buff_PI_d16$1_0.inv_PI_d16$1_0.inv_PI_d8$1_1.inv_PI_d4$1_0.inv_PI_d2$1_0.inv_PI$1_0.VIN VSS 0.00708f
C1628 6to4_0.buff_PI_d32_0.buff_PI_d16$1_0.inv_PI_d8$1_0.VOUT.n9 VSS 0.03495f
C1629 6to4_0.buff_PI_d32_0.buff_PI_d16$1_0.inv_PI_d8$1_0.VOUT.t31 VSS 0.2604f
C1630 6to4_0.buff_PI_d32_0.buff_PI_d16$1_0.inv_PI_d16$1_0.inv_PI_d8$1_1.inv_PI_d4$1_0.inv_PI_d2$1_0.inv_PI$1_1.VIN VSS 0.00566f
C1631 6to4_0.buff_PI_d32_0.buff_PI_d16$1_0.inv_PI_d16$1_0.inv_PI_d8$1_1.inv_PI_d4$1_0.inv_PI_d2$1_0.VIN VSS 0.00708f
C1632 6to4_0.buff_PI_d32_0.buff_PI_d16$1_0.inv_PI_d8$1_0.VOUT.n10 VSS 0.01557f
C1633 6to4_0.buff_PI_d32_0.buff_PI_d16$1_0.inv_PI_d8$1_0.VOUT.n11 VSS 0.21546f
C1634 6to4_0.buff_PI_d32_0.buff_PI_d16$1_0.inv_PI_d8$1_0.VOUT.t28 VSS 0.2604f
C1635 6to4_0.buff_PI_d32_0.buff_PI_d16$1_0.inv_PI_d16$1_0.inv_PI_d8$1_0.inv_PI_d4$1_0.inv_PI_d2$1_1.inv_PI$1_0.VIN VSS 0.00708f
C1636 6to4_0.buff_PI_d32_0.buff_PI_d16$1_0.inv_PI_d8$1_0.VOUT.n12 VSS 0.02123f
C1637 6to4_0.buff_PI_d32_0.buff_PI_d16$1_0.inv_PI_d8$1_0.VOUT.n13 VSS 0.12363f
C1638 6to4_0.buff_PI_d32_0.buff_PI_d16$1_0.inv_PI_d8$1_0.VOUT.t37 VSS 0.2604f
C1639 6to4_0.buff_PI_d32_0.buff_PI_d16$1_0.inv_PI_d16$1_0.inv_PI_d8$1_0.inv_PI_d4$1_0.inv_PI_d2$1_0.inv_PI$1_0.VIN VSS 0.00708f
C1640 6to4_0.buff_PI_d32_0.buff_PI_d16$1_0.inv_PI_d8$1_0.VOUT.n14 VSS 0.03495f
C1641 6to4_0.buff_PI_d32_0.buff_PI_d16$1_0.inv_PI_d8$1_0.VOUT.t30 VSS 0.2604f
C1642 6to4_0.buff_PI_d32_0.buff_PI_d16$1_0.inv_PI_d16$1_0.inv_PI_d8$1_0.inv_PI_d4$1_0.inv_PI_d2$1_0.inv_PI$1_1.VIN VSS 0.00566f
C1643 6to4_0.buff_PI_d32_0.buff_PI_d16$1_0.inv_PI_d16$1_0.inv_PI_d8$1_0.inv_PI_d4$1_0.inv_PI_d2$1_0.VIN VSS 0.00708f
C1644 6to4_0.buff_PI_d32_0.buff_PI_d16$1_0.inv_PI_d8$1_0.VOUT.n15 VSS 0.01557f
C1645 6to4_0.buff_PI_d32_0.buff_PI_d16$1_0.inv_PI_d8$1_0.VOUT.n16 VSS 0.21546f
C1646 6to4_0.buff_PI_d32_0.buff_PI_d16$1_0.inv_PI_d8$1_0.VOUT.n17 VSS 0.32005f
C1647 6to4_0.buff_PI_d32_0.buff_PI_d16$1_0.inv_PI_d8$1_0.VOUT.n18 VSS 0.32005f
C1648 6to4_0.buff_PI_d32_0.buff_PI_d16$1_0.inv_PI_d8$1_0.VOUT.t38 VSS 0.2604f
C1649 6to4_0.buff_PI_d32_0.buff_PI_d16$1_0.inv_PI_d16$1_0.inv_PI_d8$1_1.inv_PI_d4$1_0.inv_PI_d2$1_1.inv_PI$1_0.VIN VSS 0.00708f
C1650 6to4_0.buff_PI_d32_0.buff_PI_d16$1_0.inv_PI_d8$1_0.VOUT.n19 VSS 0.02123f
C1651 6to4_0.buff_PI_d32_0.buff_PI_d16$1_0.inv_PI_d8$1_0.VOUT.n20 VSS 0.12363f
C1652 6to4_0.buff_PI_d32_0.buff_PI_d16$1_0.inv_PI_d8$1_0.VOUT.t26 VSS 0.2604f
C1653 6to4_0.buff_PI_d32_0.buff_PI_d16$1_0.inv_PI_d16$1_0.inv_PI_d8$1_1.inv_PI_d4$1_0.inv_PI_d2$1_1.inv_PI$1_1.VIN VSS 0.00472f
C1654 6to4_0.buff_PI_d32_0.buff_PI_d16$1_0.inv_PI_d16$1_0.inv_PI_d8$1_1.inv_PI_d4$1_0.VIN VSS 0.00566f
C1655 6to4_0.buff_PI_d32_0.buff_PI_d16$1_0.inv_PI_d16$1_0.inv_PI_d8$1_1.inv_PI_d4$1_0.inv_PI_d2$1_1.VIN VSS 0.00236f
C1656 6to4_0.buff_PI_d32_0.buff_PI_d16$1_0.inv_PI_d8$1_0.VOUT.n21 VSS 0.01557f
C1657 6to4_0.buff_PI_d32_0.buff_PI_d16$1_0.inv_PI_d8$1_0.VOUT.n22 VSS 0.12379f
C1658 6to4_0.buff_PI_d32_0.buff_PI_d16$1_0.inv_PI_d8$1_0.VOUT.n23 VSS 0.32005f
C1659 6to4_0.buff_PI_d32_0.buff_PI_d16$1_0.inv_PI_d8$1_0.VOUT.n24 VSS 0.32005f
C1660 6to4_0.buff_PI_d32_0.buff_PI_d16$1_0.inv_PI_d8$1_0.VOUT.t33 VSS 0.2604f
C1661 6to4_0.buff_PI_d32_0.buff_PI_d16$1_0.inv_PI_d16$1_0.inv_PI_d8$1_0.inv_PI_d4$1_1.inv_PI_d2$1_0.inv_PI$1_0.VIN VSS 0.00708f
C1662 6to4_0.buff_PI_d32_0.buff_PI_d16$1_0.inv_PI_d8$1_0.VOUT.n25 VSS 0.02123f
C1663 6to4_0.buff_PI_d32_0.buff_PI_d16$1_0.inv_PI_d8$1_0.VOUT.n26 VSS 0.12363f
C1664 6to4_0.buff_PI_d32_0.buff_PI_d16$1_0.inv_PI_d8$1_0.VOUT.t24 VSS 0.2604f
C1665 6to4_0.buff_PI_d32_0.buff_PI_d16$1_0.inv_PI_d16$1_0.inv_PI_d8$1_0.inv_PI_d4$1_1.inv_PI_d2$1_0.inv_PI$1_1.VIN VSS 0.00566f
C1666 6to4_0.buff_PI_d32_0.buff_PI_d16$1_0.inv_PI_d16$1_0.inv_PI_d8$1_0.inv_PI_d4$1_1.inv_PI_d2$1_0.VIN VSS 0.00708f
C1667 6to4_0.buff_PI_d32_0.buff_PI_d16$1_0.inv_PI_d8$1_0.VOUT.n27 VSS 0.01557f
C1668 6to4_0.buff_PI_d32_0.buff_PI_d16$1_0.inv_PI_d8$1_0.VOUT.n28 VSS 0.12379f
C1669 6to4_0.buff_PI_d32_0.buff_PI_d16$1_0.inv_PI_d8$1_0.VOUT.n29 VSS 0.09354f
C1670 6to4_0.buff_PI_d32_0.buff_PI_d16$1_0.inv_PI_d16$1_0.VIN VSS 0.45552f
C1671 6to4_0.buff_PI_d32_0.buff_PI_d16$1_0.inv_PI_d8$1_0.VOUT.n30 VSS 0.09103f
C1672 6to4_0.buff_PI_d32_0.buff_PI_d16$1_0.inv_PI_d8$1_0.VOUT.t34 VSS 0.2604f
C1673 6to4_0.buff_PI_d32_0.buff_PI_d16$1_0.inv_PI_d16$1_0.inv_PI_d8$1_1.inv_PI_d4$1_1.inv_PI_d2$1_1.inv_PI$1_0.VIN VSS 0.00708f
C1674 6to4_0.buff_PI_d32_0.buff_PI_d16$1_0.inv_PI_d8$1_0.VOUT.n31 VSS 0.02123f
C1675 6to4_0.buff_PI_d32_0.buff_PI_d16$1_0.inv_PI_d8$1_0.VOUT.n32 VSS 0.2153f
C1676 6to4_0.buff_PI_d32_0.buff_PI_d16$1_0.inv_PI_d8$1_0.VOUT.t25 VSS 0.2604f
C1677 6to4_0.buff_PI_d32_0.buff_PI_d16$1_0.inv_PI_d8$1_0.VOUT.n33 VSS 0.02929f
C1678 6to4_0.buff_PI_d32_0.buff_PI_d16$1_0.inv_PI_d16$1_0.inv_PI_d8$1_1.inv_PI_d4$1_1.inv_PI_d2$1_1.VIN VSS 0.00236f
C1679 6to4_0.buff_PI_d32_0.buff_PI_d16$1_0.inv_PI_d16$1_0.inv_PI_d8$1_1.inv_PI_d4$1_1.VIN VSS 0.00566f
C1680 6to4_0.buff_PI_d32_0.buff_PI_d16$1_0.inv_PI_d16$1_0.inv_PI_d8$1_1.inv_PI_d4$1_1.inv_PI_d2$1_1.inv_PI$1_1.VIN VSS 0.06501f
C1681 6to4_0.buff_PI_d32_0.buff_PI_d16$1_0.inv_PI_d8$1_0.VOUT.n34 VSS 0.08613f
C1682 6to4_0.buff_PI_d32_0.buff_PI_d16$1_0.inv_PI_d8$1_0.VOUT.t18 VSS 0.03591f
C1683 6to4_0.buff_PI_d32_0.buff_PI_d16$1_0.inv_PI_d8$1_0.VOUT.t19 VSS 0.03179f
C1684 6to4_0.buff_PI_d32_0.buff_PI_d16$1_0.inv_PI_d8$1_0.VOUT.t2 VSS 0.03179f
C1685 6to4_0.buff_PI_d32_0.buff_PI_d16$1_0.inv_PI_d8$1_0.VOUT.t1 VSS 0.0351f
C1686 6to4_0.buff_PI_d32_0.buff_PI_d16$1_0.inv_PI_d8$1_0.VOUT.t14 VSS 0.0351f
C1687 6to4_0.buff_PI_d32_0.buff_PI_d16$1_0.inv_PI_d8$1_0.VOUT.t12 VSS 0.03591f
C1688 6to4_0.buff_PI_d32_0.buff_PI_d16$1_0.inv_PI_d8$1_0.VOUT.t13 VSS 0.03179f
C1689 6to4_0.buff_PI_d32_0.buff_PI_d16$1_0.inv_PI_d8$1_0.VOUT.t23 VSS 0.03179f
C1690 6to4_0.buff_PI_d32_0.buff_PI_d16$1_0.inv_PI_d8$1_0.VOUT.t21 VSS 0.03591f
C1691 6to4_0.buff_PI_d32_0.buff_PI_d16$1_0.inv_PI_d8$1_0.VOUT.t22 VSS 0.0351f
C1692 6to4_0.buff_PI_d32_0.buff_PI_d16$1_0.inv_PI_d8$1_0.VOUT.t10 VSS 0.0351f
C1693 6to4_0.buff_PI_d32_0.buff_PI_d16$1_0.inv_PI_d8$1_0.VOUT.t9 VSS 0.03591f
C1694 6to4_0.buff_PI_d32_0.buff_PI_d16$1_0.inv_PI_d8$1_0.VOUT.t11 VSS 0.03179f
C1695 6to4_0.buff_PI_d32_0.buff_PI_d16$1_0.inv_PI_d8$1_0.VOUT.t16 VSS 0.03179f
C1696 6to4_0.buff_PI_d32_0.buff_PI_d16$1_0.inv_PI_d8$1_0.VOUT.t15 VSS 0.03591f
C1697 6to4_0.buff_PI_d32_0.buff_PI_d16$1_0.inv_PI_d8$1_0.VOUT.t17 VSS 0.0351f
C1698 6to4_0.buff_PI_d32_0.buff_PI_d16$1_0.inv_PI_d8$1_0.VOUT.t7 VSS 0.0351f
C1699 6to4_0.buff_PI_d32_0.buff_PI_d16$1_0.inv_PI_d8$1_0.VOUT.t6 VSS 0.03591f
C1700 6to4_0.buff_PI_d32_0.buff_PI_d16$1_0.inv_PI_d8$1_0.VOUT.t8 VSS 0.03179f
C1701 6to4_0.buff_PI_d32_0.buff_PI_d16$1_0.inv_PI_d8$1_0.VOUT.t4 VSS 0.03179f
C1702 6to4_0.buff_PI_d32_0.buff_PI_d16$1_0.inv_PI_d8$1_0.VOUT.t3 VSS 0.03591f
C1703 6to4_0.buff_PI_d32_0.buff_PI_d16$1_0.inv_PI_d8$1_0.VOUT.t5 VSS 0.03581f
C1704 6to4_0.buff_PI_d32_0.buff_PI_d16$1_0.inv_PI_d8$1_0.inv_PI_d4$1_1.inv_PI_d2$1_1.inv_PI$1_1.VOUT VSS 0.0517f
C1705 6to4_0.buff_PI_d32_0.buff_PI_d16$1_0.inv_PI_d8$1_0.VOUT.n35 VSS 0.0667f
C1706 6to4_0.buff_PI_d32_0.buff_PI_d16$1_0.inv_PI_d8$1_0.VOUT.n36 VSS 0.05947f
C1707 6to4_0.buff_PI_d32_0.buff_PI_d16$1_0.inv_PI_d8$1_0.VOUT.n37 VSS 0.04638f
C1708 6to4_0.buff_PI_d32_0.buff_PI_d16$1_0.inv_PI_d8$1_0.inv_PI_d4$1_1.inv_PI_d2$1_1.VOUT VSS 0.01435f
C1709 6to4_0.buff_PI_d32_0.buff_PI_d16$1_0.inv_PI_d8$1_0.VOUT.n38 VSS 0.06544f
C1710 6to4_0.buff_PI_d32_0.buff_PI_d16$1_0.inv_PI_d8$1_0.inv_PI_d4$1_1.inv_PI_d2$1_1.inv_PI$1_0.VOUT VSS 0.01435f
C1711 6to4_0.buff_PI_d32_0.buff_PI_d16$1_0.inv_PI_d8$1_0.VOUT.n39 VSS 0.08589f
C1712 6to4_0.buff_PI_d32_0.buff_PI_d16$1_0.inv_PI_d8$1_0.VOUT.n40 VSS 0.08589f
C1713 6to4_0.buff_PI_d32_0.buff_PI_d16$1_0.inv_PI_d8$1_0.inv_PI_d4$1_1.inv_PI_d2$1_0.inv_PI$1_1.VOUT VSS 0.01435f
C1714 6to4_0.buff_PI_d32_0.buff_PI_d16$1_0.inv_PI_d8$1_0.VOUT.n41 VSS 0.0667f
C1715 6to4_0.buff_PI_d32_0.buff_PI_d16$1_0.inv_PI_d8$1_0.VOUT.n42 VSS 0.05947f
C1716 6to4_0.buff_PI_d32_0.buff_PI_d16$1_0.inv_PI_d8$1_0.VOUT.n43 VSS 0.04638f
C1717 6to4_0.buff_PI_d32_0.buff_PI_d16$1_0.inv_PI_d8$1_0.inv_PI_d4$1_1.inv_PI_d2$1_0.VOUT VSS 0.01435f
C1718 6to4_0.buff_PI_d32_0.buff_PI_d16$1_0.inv_PI_d8$1_0.VOUT.n44 VSS 0.06544f
C1719 6to4_0.buff_PI_d32_0.buff_PI_d16$1_0.inv_PI_d8$1_0.inv_PI_d4$1_1.inv_PI_d2$1_0.inv_PI$1_0.VOUT VSS 0.01019f
C1720 6to4_0.buff_PI_d32_0.buff_PI_d16$1_0.inv_PI_d8$1_0.inv_PI_d4$1_1.VOUT VSS 0.01208f
C1721 6to4_0.buff_PI_d32_0.buff_PI_d16$1_0.inv_PI_d8$1_0.VOUT.n45 VSS 0.07796f
C1722 6to4_0.buff_PI_d32_0.buff_PI_d16$1_0.inv_PI_d8$1_0.VOUT.n46 VSS 0.08589f
C1723 6to4_0.buff_PI_d32_0.buff_PI_d16$1_0.inv_PI_d8$1_0.inv_PI_d4$1_0.inv_PI_d2$1_1.inv_PI$1_1.VOUT VSS 0.01435f
C1724 6to4_0.buff_PI_d32_0.buff_PI_d16$1_0.inv_PI_d8$1_0.VOUT.n47 VSS 0.0667f
C1725 6to4_0.buff_PI_d32_0.buff_PI_d16$1_0.inv_PI_d8$1_0.VOUT.n48 VSS 0.05947f
C1726 6to4_0.buff_PI_d32_0.buff_PI_d16$1_0.inv_PI_d8$1_0.VOUT.n49 VSS 0.04638f
C1727 6to4_0.buff_PI_d32_0.buff_PI_d16$1_0.inv_PI_d8$1_0.inv_PI_d4$1_0.inv_PI_d2$1_1.VOUT VSS 0.01435f
C1728 6to4_0.buff_PI_d32_0.buff_PI_d16$1_0.inv_PI_d8$1_0.VOUT.n50 VSS 0.06544f
C1729 6to4_0.buff_PI_d32_0.buff_PI_d16$1_0.inv_PI_d8$1_0.inv_PI_d4$1_0.inv_PI_d2$1_1.inv_PI$1_0.VOUT VSS 0.01435f
C1730 6to4_0.buff_PI_d32_0.buff_PI_d16$1_0.inv_PI_d8$1_0.VOUT.n51 VSS 0.08589f
C1731 6to4_0.buff_PI_d32_0.buff_PI_d16$1_0.inv_PI_d8$1_0.VOUT.n52 VSS 0.08589f
C1732 6to4_0.buff_PI_d32_0.buff_PI_d16$1_0.inv_PI_d8$1_0.inv_PI_d4$1_0.inv_PI_d2$1_0.inv_PI$1_1.VOUT VSS 0.01435f
C1733 6to4_0.buff_PI_d32_0.buff_PI_d16$1_0.inv_PI_d8$1_0.VOUT.t0 VSS 0.03591f
C1734 6to4_0.buff_PI_d32_0.buff_PI_d16$1_0.inv_PI_d8$1_0.VOUT.n53 VSS 0.0667f
C1735 6to4_0.buff_PI_d32_0.buff_PI_d16$1_0.inv_PI_d8$1_0.VOUT.n54 VSS 0.05947f
C1736 6to4_0.buff_PI_d32_0.buff_PI_d16$1_0.inv_PI_d8$1_0.VOUT.n55 VSS 0.04638f
C1737 6to4_0.buff_PI_d32_0.buff_PI_d16$1_0.inv_PI_d8$1_0.inv_PI_d4$1_0.inv_PI_d2$1_0.VOUT VSS 0.01435f
C1738 6to4_0.buff_PI_d32_0.buff_PI_d16$1_0.inv_PI_d8$1_0.VOUT.n56 VSS 0.06544f
C1739 6to4_0.buff_PI_d32_0.buff_PI_d16$1_0.inv_PI_d8$1_0.inv_PI_d4$1_0.inv_PI_d2$1_0.inv_PI$1_0.VOUT VSS 0.01019f
C1740 6to4_0.buff_PI_d32_0.buff_PI_d16$1_0.inv_PI_d8$1_0.inv_PI_d4$1_0.VOUT VSS 0.01208f
C1741 6ph_rosc_0.PH5.t7 VSS 0.01555f
C1742 6ph_rosc_0.PH5.t1 VSS 0.01555f
C1743 6ph_rosc_0.PH5.n0 VSS 0.00605f
C1744 6ph_rosc_0.PH5.n1 VSS 0.03686f
C1745 6ph_rosc_0.PH5.n2 VSS 0.02526f
C1746 6ph_rosc_0.PH5.t9 VSS 0.01555f
C1747 6ph_rosc_0.PH5.t8 VSS 0.01555f
C1748 6ph_rosc_0.PH5.n3 VSS 0.00605f
C1749 6ph_rosc_0.PH5.n4 VSS 0.03686f
C1750 6ph_rosc_0.PH5.n5 VSS 0.02825f
C1751 6ph_rosc_0.PH5.t14 VSS 0.03519f
C1752 6ph_rosc_0.PH5.n6 VSS 0.00714f
C1753 6ph_rosc_0.PH5.n7 VSS 0.08008f
C1754 6ph_rosc_0.PH5.t13 VSS 0.03519f
C1755 6ph_rosc_0.PH5.n8 VSS 0.05267f
C1756 6ph_rosc_0.PH5.t10 VSS 0.11596f
C1757 6ph_rosc_0.PH5.n9 VSS 0.01556f
C1758 6ph_rosc_0.PH5.t11 VSS 0.11596f
C1759 6ph_rosc_0.PH5.n10 VSS 0.00693f
C1760 6ph_rosc_0.PH5.n11 VSS 0.08572f
C1761 6ph_rosc_0.PH5.n12 VSS 5.02072f
C1762 6ph_rosc_0.PH5.t12 VSS 0.81591f
C1763 6ph_rosc_0.PH5.n13 VSS 0.00725f
C1764 6ph_rosc_0.PH5.n14 VSS 0.55513f
C1765 6ph_rosc_0.PH5.n15 VSS 0.52007f
C1766 6ph_rosc_0.PH5.t4 VSS 0.01555f
C1767 6ph_rosc_0.PH5.t2 VSS 0.01555f
C1768 6ph_rosc_0.PH5.n16 VSS 0.00605f
C1769 6ph_rosc_0.PH5.n17 VSS 0.03686f
C1770 6ph_rosc_0.PH5.n18 VSS 0.02526f
C1771 6ph_rosc_0.PH5.t6 VSS 0.01555f
C1772 6ph_rosc_0.PH5.t0 VSS 0.01555f
C1773 6ph_rosc_0.PH5.n19 VSS 0.00605f
C1774 6ph_rosc_0.PH5.n20 VSS 0.03686f
C1775 6ph_rosc_0.PH5.n21 VSS 0.0286f
C1776 6ph_rosc_0.PH5.n22 VSS 0.08927f
C1777 6ph_rosc_0.PH5.n23 VSS 0.0521f
C1778 6ph_rosc_0.PH5.t5 VSS 0.01555f
C1779 6ph_rosc_0.PH5.n24 VSS 0.02526f
C1780 6ph_rosc_0.PH5.n25 VSS 0.03686f
C1781 6ph_rosc_0.PH5.t3 VSS 0.01555f
C1782 6ph_rosc_0.PH5.n26 VSS 0.00605f
C1783 6ph_rosc_0.PH2.t9 VSS 0.02324f
C1784 6ph_rosc_0.PH2.n0 VSS 0.01209f
C1785 6ph_rosc_0.PH2.t8 VSS 0.02297f
C1786 6ph_rosc_0.PH2.n1 VSS 0.00452f
C1787 6ph_rosc_0.PH2.n2 VSS 0.01096f
C1788 6ph_rosc_0.PH2.t13 VSS 0.05198f
C1789 6ph_rosc_0.PH2.n3 VSS 0.00559f
C1790 6ph_rosc_0.PH2.n4 VSS 0.11867f
C1791 6ph_rosc_0.PH2.t14 VSS 0.05198f
C1792 6ph_rosc_0.PH2.n5 VSS 0.07781f
C1793 6ph_rosc_0.PH2.t12 VSS 0.17129f
C1794 6ph_rosc_0.PH2.n6 VSS 0.02299f
C1795 6ph_rosc_0.PH2.t11 VSS 0.17129f
C1796 6ph_rosc_0.PH2.n7 VSS 0.01024f
C1797 6ph_rosc_0.PH2.n8 VSS 0.12662f
C1798 6ph_rosc_0.PH2.n9 VSS 8.19737f
C1799 6ph_rosc_0.PH2.t10 VSS 1.20524f
C1800 6ph_rosc_0.PH2.n10 VSS 0.24266f
C1801 6ph_rosc_0.PH2.t6 VSS 0.02297f
C1802 6ph_rosc_0.PH2.t0 VSS 0.02297f
C1803 6ph_rosc_0.PH2.n11 VSS 0.00894f
C1804 6ph_rosc_0.PH2.n12 VSS 0.05444f
C1805 6ph_rosc_0.PH2.n13 VSS 0.03731f
C1806 6ph_rosc_0.PH2.t4 VSS 0.02297f
C1807 6ph_rosc_0.PH2.t2 VSS 0.02297f
C1808 6ph_rosc_0.PH2.n14 VSS 0.00894f
C1809 6ph_rosc_0.PH2.n15 VSS 0.05444f
C1810 6ph_rosc_0.PH2.n16 VSS 0.03731f
C1811 6ph_rosc_0.PH2.t7 VSS 0.02297f
C1812 6ph_rosc_0.PH2.t1 VSS 0.02297f
C1813 6ph_rosc_0.PH2.n17 VSS 0.00894f
C1814 6ph_rosc_0.PH2.n18 VSS 0.05444f
C1815 6ph_rosc_0.PH2.n19 VSS 0.04225f
C1816 6ph_rosc_0.PH2.n20 VSS 0.13186f
C1817 6ph_rosc_0.PH2.n21 VSS 0.07782f
C1818 6ph_rosc_0.PH2.n22 VSS 0.21536f
C1819 6ph_rosc_0.PH2.t5 VSS 0.02297f
C1820 6ph_rosc_0.PH2.n23 VSS 0.03731f
C1821 6ph_rosc_0.PH2.n24 VSS 0.05444f
C1822 6ph_rosc_0.PH2.t3 VSS 0.02297f
C1823 6ph_rosc_0.PH2.n25 VSS 0.00894f
C1824 6to4_0.buff_PI_d32_3.buff_PI_d16$1_0.inv_PI_d8$1_0.VOUT.t13 VSS 0.0351f
C1825 6to4_0.buff_PI_d32_3.buff_PI_d16$1_0.inv_PI_d8$1_0.VOUT.t35 VSS 0.2604f
C1826 6to4_0.buff_PI_d32_3.buff_PI_d16$1_0.inv_PI_d16$1_0.inv_PI_d8$1_1.inv_PI_d4$1_1.inv_PI_d2$1_0.inv_PI$1_1.VIN VSS 0.00566f
C1827 6to4_0.buff_PI_d32_3.buff_PI_d16$1_0.inv_PI_d16$1_0.inv_PI_d8$1_1.inv_PI_d4$1_1.inv_PI_d2$1_0.VIN VSS 0.00708f
C1828 6to4_0.buff_PI_d32_3.buff_PI_d16$1_0.inv_PI_d8$1_0.VOUT.n0 VSS 0.01557f
C1829 6to4_0.buff_PI_d32_3.buff_PI_d16$1_0.inv_PI_d8$1_0.VOUT.n1 VSS 0.12379f
C1830 6to4_0.buff_PI_d32_3.buff_PI_d16$1_0.inv_PI_d8$1_0.VOUT.t26 VSS 0.2604f
C1831 6to4_0.buff_PI_d32_3.buff_PI_d16$1_0.inv_PI_d16$1_0.inv_PI_d8$1_0.inv_PI_d4$1_1.inv_PI_d2$1_1.inv_PI$1_1.VIN VSS 0.00472f
C1832 6to4_0.buff_PI_d32_3.buff_PI_d16$1_0.inv_PI_d16$1_0.inv_PI_d8$1_0.inv_PI_d4$1_1.VIN VSS 0.00566f
C1833 6to4_0.buff_PI_d32_3.buff_PI_d16$1_0.inv_PI_d16$1_0.inv_PI_d8$1_0.inv_PI_d4$1_1.inv_PI_d2$1_1.VIN VSS 0.00236f
C1834 6to4_0.buff_PI_d32_3.buff_PI_d16$1_0.inv_PI_d8$1_0.VOUT.n2 VSS 0.02929f
C1835 6to4_0.buff_PI_d32_3.buff_PI_d16$1_0.inv_PI_d8$1_0.VOUT.t31 VSS 0.2604f
C1836 6to4_0.buff_PI_d32_3.buff_PI_d16$1_0.inv_PI_d16$1_0.inv_PI_d8$1_0.inv_PI_d4$1_1.inv_PI_d2$1_1.inv_PI$1_0.VIN VSS 0.00708f
C1837 6to4_0.buff_PI_d32_3.buff_PI_d16$1_0.inv_PI_d8$1_0.VOUT.n3 VSS 0.02123f
C1838 6to4_0.buff_PI_d32_3.buff_PI_d16$1_0.inv_PI_d8$1_0.VOUT.n4 VSS 0.2153f
C1839 6to4_0.buff_PI_d32_3.buff_PI_d16$1_0.inv_PI_d8$1_0.VOUT.t33 VSS 0.2604f
C1840 6to4_0.buff_PI_d32_3.buff_PI_d16$1_0.inv_PI_d16$1_0.inv_PI_d8$1_0.inv_PI_d4$1_0.inv_PI_d2$1_1.inv_PI$1_1.VIN VSS 0.00472f
C1841 6to4_0.buff_PI_d32_3.buff_PI_d16$1_0.inv_PI_d16$1_0.inv_PI_d8$1_0.inv_PI_d4$1_0.VIN VSS 0.00566f
C1842 6to4_0.buff_PI_d32_3.buff_PI_d16$1_0.inv_PI_d16$1_0.inv_PI_d8$1_0.inv_PI_d4$1_0.inv_PI_d2$1_1.VIN VSS 0.00236f
C1843 6to4_0.buff_PI_d32_3.buff_PI_d16$1_0.inv_PI_d8$1_0.VOUT.n5 VSS 0.01557f
C1844 6to4_0.buff_PI_d32_3.buff_PI_d16$1_0.inv_PI_d8$1_0.VOUT.n6 VSS 0.12379f
C1845 6to4_0.buff_PI_d32_3.buff_PI_d16$1_0.inv_PI_d8$1_0.VOUT.t28 VSS 0.2604f
C1846 6to4_0.buff_PI_d32_3.buff_PI_d16$1_0.inv_PI_d16$1_0.inv_PI_d8$1_1.inv_PI_d4$1_1.inv_PI_d2$1_0.inv_PI$1_0.VIN VSS 0.00708f
C1847 6to4_0.buff_PI_d32_3.buff_PI_d16$1_0.inv_PI_d8$1_0.VOUT.n7 VSS 0.02123f
C1848 6to4_0.buff_PI_d32_3.buff_PI_d16$1_0.inv_PI_d8$1_0.VOUT.n8 VSS 0.12363f
C1849 6to4_0.buff_PI_d32_3.buff_PI_d16$1_0.inv_PI_d8$1_0.VOUT.t37 VSS 0.2604f
C1850 6to4_0.buff_PI_d32_3.buff_PI_d16$1_0.inv_PI_d16$1_0.inv_PI_d8$1_1.inv_PI_d4$1_0.inv_PI_d2$1_0.inv_PI$1_0.VIN VSS 0.00708f
C1851 6to4_0.buff_PI_d32_3.buff_PI_d16$1_0.inv_PI_d8$1_0.VOUT.n9 VSS 0.03495f
C1852 6to4_0.buff_PI_d32_3.buff_PI_d16$1_0.inv_PI_d8$1_0.VOUT.t38 VSS 0.2604f
C1853 6to4_0.buff_PI_d32_3.buff_PI_d16$1_0.inv_PI_d16$1_0.inv_PI_d8$1_1.inv_PI_d4$1_0.inv_PI_d2$1_0.inv_PI$1_1.VIN VSS 0.00566f
C1854 6to4_0.buff_PI_d32_3.buff_PI_d16$1_0.inv_PI_d16$1_0.inv_PI_d8$1_1.inv_PI_d4$1_0.inv_PI_d2$1_0.VIN VSS 0.00708f
C1855 6to4_0.buff_PI_d32_3.buff_PI_d16$1_0.inv_PI_d8$1_0.VOUT.n10 VSS 0.01557f
C1856 6to4_0.buff_PI_d32_3.buff_PI_d16$1_0.inv_PI_d8$1_0.VOUT.n11 VSS 0.21546f
C1857 6to4_0.buff_PI_d32_3.buff_PI_d16$1_0.inv_PI_d8$1_0.VOUT.t36 VSS 0.2604f
C1858 6to4_0.buff_PI_d32_3.buff_PI_d16$1_0.inv_PI_d16$1_0.inv_PI_d8$1_0.inv_PI_d4$1_0.inv_PI_d2$1_1.inv_PI$1_0.VIN VSS 0.00708f
C1859 6to4_0.buff_PI_d32_3.buff_PI_d16$1_0.inv_PI_d8$1_0.VOUT.n12 VSS 0.02123f
C1860 6to4_0.buff_PI_d32_3.buff_PI_d16$1_0.inv_PI_d8$1_0.VOUT.n13 VSS 0.12363f
C1861 6to4_0.buff_PI_d32_3.buff_PI_d16$1_0.inv_PI_d8$1_0.VOUT.t32 VSS 0.2604f
C1862 6to4_0.buff_PI_d32_3.buff_PI_d16$1_0.inv_PI_d16$1_0.inv_PI_d8$1_0.inv_PI_d4$1_0.inv_PI_d2$1_0.inv_PI$1_0.VIN VSS 0.00708f
C1863 6to4_0.buff_PI_d32_3.buff_PI_d16$1_0.inv_PI_d8$1_0.VOUT.n14 VSS 0.03495f
C1864 6to4_0.buff_PI_d32_3.buff_PI_d16$1_0.inv_PI_d8$1_0.VOUT.t25 VSS 0.2604f
C1865 6to4_0.buff_PI_d32_3.buff_PI_d16$1_0.inv_PI_d16$1_0.inv_PI_d8$1_0.inv_PI_d4$1_0.inv_PI_d2$1_0.inv_PI$1_1.VIN VSS 0.00566f
C1866 6to4_0.buff_PI_d32_3.buff_PI_d16$1_0.inv_PI_d16$1_0.inv_PI_d8$1_0.inv_PI_d4$1_0.inv_PI_d2$1_0.VIN VSS 0.00708f
C1867 6to4_0.buff_PI_d32_3.buff_PI_d16$1_0.inv_PI_d8$1_0.VOUT.n15 VSS 0.01557f
C1868 6to4_0.buff_PI_d32_3.buff_PI_d16$1_0.inv_PI_d8$1_0.VOUT.n16 VSS 0.21546f
C1869 6to4_0.buff_PI_d32_3.buff_PI_d16$1_0.inv_PI_d8$1_0.VOUT.n17 VSS 0.32005f
C1870 6to4_0.buff_PI_d32_3.buff_PI_d16$1_0.inv_PI_d8$1_0.VOUT.n18 VSS 0.32005f
C1871 6to4_0.buff_PI_d32_3.buff_PI_d16$1_0.inv_PI_d8$1_0.VOUT.t39 VSS 0.2604f
C1872 6to4_0.buff_PI_d32_3.buff_PI_d16$1_0.inv_PI_d16$1_0.inv_PI_d8$1_1.inv_PI_d4$1_0.inv_PI_d2$1_1.inv_PI$1_0.VIN VSS 0.00708f
C1873 6to4_0.buff_PI_d32_3.buff_PI_d16$1_0.inv_PI_d8$1_0.VOUT.n19 VSS 0.02123f
C1874 6to4_0.buff_PI_d32_3.buff_PI_d16$1_0.inv_PI_d8$1_0.VOUT.n20 VSS 0.12363f
C1875 6to4_0.buff_PI_d32_3.buff_PI_d16$1_0.inv_PI_d8$1_0.VOUT.t29 VSS 0.2604f
C1876 6to4_0.buff_PI_d32_3.buff_PI_d16$1_0.inv_PI_d16$1_0.inv_PI_d8$1_1.inv_PI_d4$1_0.inv_PI_d2$1_1.inv_PI$1_1.VIN VSS 0.00472f
C1877 6to4_0.buff_PI_d32_3.buff_PI_d16$1_0.inv_PI_d16$1_0.inv_PI_d8$1_1.inv_PI_d4$1_0.VIN VSS 0.00566f
C1878 6to4_0.buff_PI_d32_3.buff_PI_d16$1_0.inv_PI_d16$1_0.inv_PI_d8$1_1.inv_PI_d4$1_0.inv_PI_d2$1_1.VIN VSS 0.00236f
C1879 6to4_0.buff_PI_d32_3.buff_PI_d16$1_0.inv_PI_d8$1_0.VOUT.n21 VSS 0.01557f
C1880 6to4_0.buff_PI_d32_3.buff_PI_d16$1_0.inv_PI_d8$1_0.VOUT.n22 VSS 0.12379f
C1881 6to4_0.buff_PI_d32_3.buff_PI_d16$1_0.inv_PI_d8$1_0.VOUT.n23 VSS 0.32005f
C1882 6to4_0.buff_PI_d32_3.buff_PI_d16$1_0.inv_PI_d8$1_0.VOUT.n24 VSS 0.32005f
C1883 6to4_0.buff_PI_d32_3.buff_PI_d16$1_0.inv_PI_d8$1_0.VOUT.t24 VSS 0.2604f
C1884 6to4_0.buff_PI_d32_3.buff_PI_d16$1_0.inv_PI_d16$1_0.inv_PI_d8$1_0.inv_PI_d4$1_1.inv_PI_d2$1_0.inv_PI$1_0.VIN VSS 0.00708f
C1885 6to4_0.buff_PI_d32_3.buff_PI_d16$1_0.inv_PI_d8$1_0.VOUT.n25 VSS 0.02123f
C1886 6to4_0.buff_PI_d32_3.buff_PI_d16$1_0.inv_PI_d8$1_0.VOUT.n26 VSS 0.12363f
C1887 6to4_0.buff_PI_d32_3.buff_PI_d16$1_0.inv_PI_d8$1_0.VOUT.t30 VSS 0.2604f
C1888 6to4_0.buff_PI_d32_3.buff_PI_d16$1_0.inv_PI_d16$1_0.inv_PI_d8$1_0.inv_PI_d4$1_1.inv_PI_d2$1_0.inv_PI$1_1.VIN VSS 0.00566f
C1889 6to4_0.buff_PI_d32_3.buff_PI_d16$1_0.inv_PI_d16$1_0.inv_PI_d8$1_0.inv_PI_d4$1_1.inv_PI_d2$1_0.VIN VSS 0.00708f
C1890 6to4_0.buff_PI_d32_3.buff_PI_d16$1_0.inv_PI_d8$1_0.VOUT.n27 VSS 0.01557f
C1891 6to4_0.buff_PI_d32_3.buff_PI_d16$1_0.inv_PI_d8$1_0.VOUT.n28 VSS 0.12379f
C1892 6to4_0.buff_PI_d32_3.buff_PI_d16$1_0.inv_PI_d8$1_0.VOUT.n29 VSS 0.09354f
C1893 6to4_0.buff_PI_d32_3.buff_PI_d16$1_0.inv_PI_d16$1_0.VIN VSS 0.45552f
C1894 6to4_0.buff_PI_d32_3.buff_PI_d16$1_0.inv_PI_d8$1_0.VOUT.n30 VSS 0.09103f
C1895 6to4_0.buff_PI_d32_3.buff_PI_d16$1_0.inv_PI_d8$1_0.VOUT.t27 VSS 0.2604f
C1896 6to4_0.buff_PI_d32_3.buff_PI_d16$1_0.inv_PI_d16$1_0.inv_PI_d8$1_1.inv_PI_d4$1_1.inv_PI_d2$1_1.inv_PI$1_0.VIN VSS 0.00708f
C1897 6to4_0.buff_PI_d32_3.buff_PI_d16$1_0.inv_PI_d8$1_0.VOUT.n31 VSS 0.02123f
C1898 6to4_0.buff_PI_d32_3.buff_PI_d16$1_0.inv_PI_d8$1_0.VOUT.n32 VSS 0.2153f
C1899 6to4_0.buff_PI_d32_3.buff_PI_d16$1_0.inv_PI_d8$1_0.VOUT.t34 VSS 0.2604f
C1900 6to4_0.buff_PI_d32_3.buff_PI_d16$1_0.inv_PI_d8$1_0.VOUT.n33 VSS 0.02929f
C1901 6to4_0.buff_PI_d32_3.buff_PI_d16$1_0.inv_PI_d16$1_0.inv_PI_d8$1_1.inv_PI_d4$1_1.inv_PI_d2$1_1.VIN VSS 0.00236f
C1902 6to4_0.buff_PI_d32_3.buff_PI_d16$1_0.inv_PI_d16$1_0.inv_PI_d8$1_1.inv_PI_d4$1_1.VIN VSS 0.00566f
C1903 6to4_0.buff_PI_d32_3.buff_PI_d16$1_0.inv_PI_d16$1_0.inv_PI_d8$1_1.inv_PI_d4$1_1.inv_PI_d2$1_1.inv_PI$1_1.VIN VSS 0.06501f
C1904 6to4_0.buff_PI_d32_3.buff_PI_d16$1_0.inv_PI_d8$1_0.VOUT.n34 VSS 0.08613f
C1905 6to4_0.buff_PI_d32_3.buff_PI_d16$1_0.inv_PI_d8$1_0.VOUT.t2 VSS 0.03591f
C1906 6to4_0.buff_PI_d32_3.buff_PI_d16$1_0.inv_PI_d8$1_0.VOUT.t22 VSS 0.03179f
C1907 6to4_0.buff_PI_d32_3.buff_PI_d16$1_0.inv_PI_d8$1_0.VOUT.t18 VSS 0.03179f
C1908 6to4_0.buff_PI_d32_3.buff_PI_d16$1_0.inv_PI_d8$1_0.VOUT.t5 VSS 0.03591f
C1909 6to4_0.buff_PI_d32_3.buff_PI_d16$1_0.inv_PI_d8$1_0.VOUT.t20 VSS 0.0351f
C1910 6to4_0.buff_PI_d32_3.buff_PI_d16$1_0.inv_PI_d8$1_0.VOUT.t10 VSS 0.0351f
C1911 6to4_0.buff_PI_d32_3.buff_PI_d16$1_0.inv_PI_d8$1_0.VOUT.t0 VSS 0.03591f
C1912 6to4_0.buff_PI_d32_3.buff_PI_d16$1_0.inv_PI_d8$1_0.VOUT.t19 VSS 0.03179f
C1913 6to4_0.buff_PI_d32_3.buff_PI_d16$1_0.inv_PI_d8$1_0.VOUT.t16 VSS 0.03179f
C1914 6to4_0.buff_PI_d32_3.buff_PI_d16$1_0.inv_PI_d8$1_0.VOUT.t3 VSS 0.03591f
C1915 6to4_0.buff_PI_d32_3.buff_PI_d16$1_0.inv_PI_d8$1_0.VOUT.t12 VSS 0.0351f
C1916 6to4_0.buff_PI_d32_3.buff_PI_d16$1_0.inv_PI_d8$1_0.VOUT.t15 VSS 0.0351f
C1917 6to4_0.buff_PI_d32_3.buff_PI_d16$1_0.inv_PI_d8$1_0.VOUT.t1 VSS 0.03591f
C1918 6to4_0.buff_PI_d32_3.buff_PI_d16$1_0.inv_PI_d8$1_0.VOUT.t11 VSS 0.03179f
C1919 6to4_0.buff_PI_d32_3.buff_PI_d16$1_0.inv_PI_d8$1_0.VOUT.t8 VSS 0.03179f
C1920 6to4_0.buff_PI_d32_3.buff_PI_d16$1_0.inv_PI_d8$1_0.VOUT.t9 VSS 0.0351f
C1921 6to4_0.buff_PI_d32_3.buff_PI_d16$1_0.inv_PI_d8$1_0.VOUT.t14 VSS 0.0351f
C1922 6to4_0.buff_PI_d32_3.buff_PI_d16$1_0.inv_PI_d8$1_0.VOUT.t4 VSS 0.03591f
C1923 6to4_0.buff_PI_d32_3.buff_PI_d16$1_0.inv_PI_d8$1_0.VOUT.t17 VSS 0.03179f
C1924 6to4_0.buff_PI_d32_3.buff_PI_d16$1_0.inv_PI_d8$1_0.VOUT.t23 VSS 0.03179f
C1925 6to4_0.buff_PI_d32_3.buff_PI_d16$1_0.inv_PI_d8$1_0.VOUT.t6 VSS 0.03591f
C1926 6to4_0.buff_PI_d32_3.buff_PI_d16$1_0.inv_PI_d8$1_0.VOUT.t21 VSS 0.03581f
C1927 6to4_0.buff_PI_d32_3.buff_PI_d16$1_0.inv_PI_d8$1_0.inv_PI_d4$1_1.inv_PI_d2$1_1.inv_PI$1_1.VOUT VSS 0.0517f
C1928 6to4_0.buff_PI_d32_3.buff_PI_d16$1_0.inv_PI_d8$1_0.VOUT.n35 VSS 0.0667f
C1929 6to4_0.buff_PI_d32_3.buff_PI_d16$1_0.inv_PI_d8$1_0.VOUT.n36 VSS 0.05947f
C1930 6to4_0.buff_PI_d32_3.buff_PI_d16$1_0.inv_PI_d8$1_0.VOUT.n37 VSS 0.04638f
C1931 6to4_0.buff_PI_d32_3.buff_PI_d16$1_0.inv_PI_d8$1_0.inv_PI_d4$1_1.inv_PI_d2$1_1.VOUT VSS 0.01435f
C1932 6to4_0.buff_PI_d32_3.buff_PI_d16$1_0.inv_PI_d8$1_0.VOUT.n38 VSS 0.06544f
C1933 6to4_0.buff_PI_d32_3.buff_PI_d16$1_0.inv_PI_d8$1_0.inv_PI_d4$1_1.inv_PI_d2$1_1.inv_PI$1_0.VOUT VSS 0.01435f
C1934 6to4_0.buff_PI_d32_3.buff_PI_d16$1_0.inv_PI_d8$1_0.VOUT.n39 VSS 0.08589f
C1935 6to4_0.buff_PI_d32_3.buff_PI_d16$1_0.inv_PI_d8$1_0.VOUT.n40 VSS 0.08589f
C1936 6to4_0.buff_PI_d32_3.buff_PI_d16$1_0.inv_PI_d8$1_0.inv_PI_d4$1_1.inv_PI_d2$1_0.inv_PI$1_1.VOUT VSS 0.01435f
C1937 6to4_0.buff_PI_d32_3.buff_PI_d16$1_0.inv_PI_d8$1_0.VOUT.t7 VSS 0.03591f
C1938 6to4_0.buff_PI_d32_3.buff_PI_d16$1_0.inv_PI_d8$1_0.VOUT.n41 VSS 0.0667f
C1939 6to4_0.buff_PI_d32_3.buff_PI_d16$1_0.inv_PI_d8$1_0.VOUT.n42 VSS 0.05947f
C1940 6to4_0.buff_PI_d32_3.buff_PI_d16$1_0.inv_PI_d8$1_0.VOUT.n43 VSS 0.04638f
C1941 6to4_0.buff_PI_d32_3.buff_PI_d16$1_0.inv_PI_d8$1_0.inv_PI_d4$1_1.inv_PI_d2$1_0.VOUT VSS 0.01435f
C1942 6to4_0.buff_PI_d32_3.buff_PI_d16$1_0.inv_PI_d8$1_0.VOUT.n44 VSS 0.06544f
C1943 6to4_0.buff_PI_d32_3.buff_PI_d16$1_0.inv_PI_d8$1_0.inv_PI_d4$1_1.inv_PI_d2$1_0.inv_PI$1_0.VOUT VSS 0.01019f
C1944 6to4_0.buff_PI_d32_3.buff_PI_d16$1_0.inv_PI_d8$1_0.inv_PI_d4$1_1.VOUT VSS 0.01208f
C1945 6to4_0.buff_PI_d32_3.buff_PI_d16$1_0.inv_PI_d8$1_0.VOUT.n45 VSS 0.07796f
C1946 6to4_0.buff_PI_d32_3.buff_PI_d16$1_0.inv_PI_d8$1_0.VOUT.n46 VSS 0.08589f
C1947 6to4_0.buff_PI_d32_3.buff_PI_d16$1_0.inv_PI_d8$1_0.inv_PI_d4$1_0.inv_PI_d2$1_1.inv_PI$1_1.VOUT VSS 0.01435f
C1948 6to4_0.buff_PI_d32_3.buff_PI_d16$1_0.inv_PI_d8$1_0.VOUT.n47 VSS 0.0667f
C1949 6to4_0.buff_PI_d32_3.buff_PI_d16$1_0.inv_PI_d8$1_0.VOUT.n48 VSS 0.05947f
C1950 6to4_0.buff_PI_d32_3.buff_PI_d16$1_0.inv_PI_d8$1_0.VOUT.n49 VSS 0.04638f
C1951 6to4_0.buff_PI_d32_3.buff_PI_d16$1_0.inv_PI_d8$1_0.inv_PI_d4$1_0.inv_PI_d2$1_1.VOUT VSS 0.01435f
C1952 6to4_0.buff_PI_d32_3.buff_PI_d16$1_0.inv_PI_d8$1_0.VOUT.n50 VSS 0.06544f
C1953 6to4_0.buff_PI_d32_3.buff_PI_d16$1_0.inv_PI_d8$1_0.inv_PI_d4$1_0.inv_PI_d2$1_1.inv_PI$1_0.VOUT VSS 0.01435f
C1954 6to4_0.buff_PI_d32_3.buff_PI_d16$1_0.inv_PI_d8$1_0.VOUT.n51 VSS 0.08589f
C1955 6to4_0.buff_PI_d32_3.buff_PI_d16$1_0.inv_PI_d8$1_0.VOUT.n52 VSS 0.08589f
C1956 6to4_0.buff_PI_d32_3.buff_PI_d16$1_0.inv_PI_d8$1_0.inv_PI_d4$1_0.inv_PI_d2$1_0.inv_PI$1_1.VOUT VSS 0.01435f
C1957 6to4_0.buff_PI_d32_3.buff_PI_d16$1_0.inv_PI_d8$1_0.VOUT.n53 VSS 0.0667f
C1958 6to4_0.buff_PI_d32_3.buff_PI_d16$1_0.inv_PI_d8$1_0.VOUT.n54 VSS 0.05947f
C1959 6to4_0.buff_PI_d32_3.buff_PI_d16$1_0.inv_PI_d8$1_0.VOUT.n55 VSS 0.04638f
C1960 6to4_0.buff_PI_d32_3.buff_PI_d16$1_0.inv_PI_d8$1_0.inv_PI_d4$1_0.inv_PI_d2$1_0.VOUT VSS 0.01435f
C1961 6to4_0.buff_PI_d32_3.buff_PI_d16$1_0.inv_PI_d8$1_0.VOUT.n56 VSS 0.06544f
C1962 6to4_0.buff_PI_d32_3.buff_PI_d16$1_0.inv_PI_d8$1_0.inv_PI_d4$1_0.inv_PI_d2$1_0.inv_PI$1_0.VOUT VSS 0.01019f
C1963 6to4_0.buff_PI_d32_3.buff_PI_d16$1_0.inv_PI_d8$1_0.inv_PI_d4$1_0.VOUT VSS 0.01208f
C1964 6ph_rosc_0.PH3.t6 VSS 0.02427f
C1965 6ph_rosc_0.PH3.t4 VSS 0.02427f
C1966 6ph_rosc_0.PH3.n0 VSS 0.00945f
C1967 6ph_rosc_0.PH3.n1 VSS 0.05753f
C1968 6ph_rosc_0.PH3.n2 VSS 0.03942f
C1969 6ph_rosc_0.PH3.t9 VSS 0.02427f
C1970 6ph_rosc_0.PH3.t2 VSS 0.02427f
C1971 6ph_rosc_0.PH3.n3 VSS 0.00945f
C1972 6ph_rosc_0.PH3.n4 VSS 0.05753f
C1973 6ph_rosc_0.PH3.n5 VSS 0.03942f
C1974 6ph_rosc_0.PH3.t8 VSS 0.02427f
C1975 6ph_rosc_0.PH3.t5 VSS 0.02427f
C1976 6ph_rosc_0.PH3.n6 VSS 0.00945f
C1977 6ph_rosc_0.PH3.n7 VSS 0.05753f
C1978 6ph_rosc_0.PH3.n8 VSS 0.03942f
C1979 6ph_rosc_0.PH3.t7 VSS 0.02427f
C1980 6ph_rosc_0.PH3.t3 VSS 0.02427f
C1981 6ph_rosc_0.PH3.n9 VSS 0.00945f
C1982 6ph_rosc_0.PH3.n10 VSS 0.05753f
C1983 6ph_rosc_0.PH3.n11 VSS 0.04464f
C1984 6ph_rosc_0.PH3.n12 VSS 0.13932f
C1985 6ph_rosc_0.PH3.n13 VSS 0.08222f
C1986 6ph_rosc_0.PH3.n14 VSS 0.81262f
C1987 6ph_rosc_0.PH3.t11 VSS 1.27345f
C1988 6ph_rosc_0.PH3.n15 VSS 0.01082f
C1989 6ph_rosc_0.PH3.n16 VSS 0.86955f
C1990 6ph_rosc_0.PH3.t12 VSS 0.18098f
C1991 6ph_rosc_0.PH3.n17 VSS 0.02429f
C1992 6ph_rosc_0.PH3.t10 VSS 0.18098f
C1993 6ph_rosc_0.PH3.n18 VSS 0.01082f
C1994 6ph_rosc_0.PH3.n19 VSS 0.13379f
C1995 6ph_rosc_0.PH3.n20 VSS 2.78244f
C1996 6ph_rosc_0.PH3.t13 VSS 0.05492f
C1997 6ph_rosc_0.PH3.n21 VSS 0.08221f
C1998 6ph_rosc_0.PH3.t14 VSS 0.05492f
C1999 6ph_rosc_0.PH3.n22 VSS 0.01115f
C2000 6ph_rosc_0.PH3.n23 VSS 0.12499f
C2001 6ph_rosc_0.PH3.t1 VSS 0.02427f
C2002 6ph_rosc_0.PH3.n24 VSS 0.0441f
C2003 6ph_rosc_0.PH3.n25 VSS 0.05753f
C2004 6ph_rosc_0.PH3.t0 VSS 0.02427f
C2005 6ph_rosc_0.PH3.n26 VSS 0.00945f
C2006 6ph_rosc_0.PH4.t1 VSS 0.02615f
C2007 6ph_rosc_0.PH4.n0 VSS 0.0136f
C2008 6ph_rosc_0.PH4.t12 VSS 0.05847f
C2009 6ph_rosc_0.PH4.n1 VSS 0.00628f
C2010 6ph_rosc_0.PH4.t9 VSS 0.02584f
C2011 6ph_rosc_0.PH4.t4 VSS 0.02584f
C2012 6ph_rosc_0.PH4.n2 VSS 0.01006f
C2013 6ph_rosc_0.PH4.n3 VSS 0.06124f
C2014 6ph_rosc_0.PH4.n4 VSS 0.04197f
C2015 6ph_rosc_0.PH4.t7 VSS 0.02584f
C2016 6ph_rosc_0.PH4.t5 VSS 0.02584f
C2017 6ph_rosc_0.PH4.n5 VSS 0.01006f
C2018 6ph_rosc_0.PH4.n6 VSS 0.06124f
C2019 6ph_rosc_0.PH4.n7 VSS 0.04197f
C2020 6ph_rosc_0.PH4.t8 VSS 0.02584f
C2021 6ph_rosc_0.PH4.t3 VSS 0.02584f
C2022 6ph_rosc_0.PH4.n8 VSS 0.01006f
C2023 6ph_rosc_0.PH4.n9 VSS 0.06124f
C2024 6ph_rosc_0.PH4.n10 VSS 0.04197f
C2025 6ph_rosc_0.PH4.t6 VSS 0.02584f
C2026 6ph_rosc_0.PH4.t2 VSS 0.02584f
C2027 6ph_rosc_0.PH4.n11 VSS 0.01006f
C2028 6ph_rosc_0.PH4.n12 VSS 0.06124f
C2029 6ph_rosc_0.PH4.n13 VSS 0.04753f
C2030 6ph_rosc_0.PH4.n14 VSS 0.14833f
C2031 6ph_rosc_0.PH4.n15 VSS 0.08754f
C2032 6ph_rosc_0.PH4.n16 VSS 0.24226f
C2033 6ph_rosc_0.PH4.t10 VSS 1.35574f
C2034 6ph_rosc_0.PH4.n17 VSS 0.27296f
C2035 6ph_rosc_0.PH4.t11 VSS 0.19268f
C2036 6ph_rosc_0.PH4.n18 VSS 0.02586f
C2037 6ph_rosc_0.PH4.t14 VSS 0.19268f
C2038 6ph_rosc_0.PH4.n19 VSS 0.01152f
C2039 6ph_rosc_0.PH4.n20 VSS 0.14243f
C2040 6ph_rosc_0.PH4.n21 VSS 7.13289f
C2041 6ph_rosc_0.PH4.t13 VSS 0.05847f
C2042 6ph_rosc_0.PH4.n22 VSS 0.08752f
C2043 6ph_rosc_0.PH4.n23 VSS 0.13349f
C2044 6ph_rosc_0.PH4.t0 VSS 0.02584f
C2045 6ph_rosc_0.PH4.n24 VSS 0.01233f
C2046 6ph_rosc_0.PH4.n25 VSS 0.00509f
C2047 PH180.t62 VSS 0.05442f
C2048 PH180.t53 VSS 0.05442f
C2049 PH180.t14 VSS 0.05569f
C2050 PH180.t86 VSS 0.0493f
C2051 PH180.t76 VSS 0.0493f
C2052 PH180.t0 VSS 0.05569f
C2053 PH180.t52 VSS 0.05442f
C2054 PH180.t75 VSS 0.05442f
C2055 PH180.t7 VSS 0.05569f
C2056 PH180.t83 VSS 0.0493f
C2057 PH180.t67 VSS 0.0493f
C2058 PH180.t31 VSS 0.05569f
C2059 PH180.t43 VSS 0.05442f
C2060 PH180.t35 VSS 0.05442f
C2061 PH180.t29 VSS 0.05569f
C2062 PH180.t51 VSS 0.0493f
C2063 PH180.t66 VSS 0.0493f
C2064 PH180.t21 VSS 0.05569f
C2065 PH180.t78 VSS 0.05442f
C2066 PH180.t87 VSS 0.05442f
C2067 PH180.t16 VSS 0.05569f
C2068 PH180.t41 VSS 0.0493f
C2069 PH180.t55 VSS 0.0493f
C2070 PH180.t15 VSS 0.05569f
C2071 PH180.t68 VSS 0.05553f
C2072 PH180.n0 VSS 0.10343f
C2073 PH180.n1 VSS 0.09221f
C2074 PH180.n2 VSS 0.07192f
C2075 PH180.n3 VSS 0.10148f
C2076 PH180.n4 VSS 0.13318f
C2077 PH180.n5 VSS 0.13318f
C2078 PH180.n6 VSS 0.10343f
C2079 PH180.n7 VSS 0.09221f
C2080 PH180.n8 VSS 0.07192f
C2081 PH180.n9 VSS 0.10148f
C2082 PH180.n10 VSS 0.12089f
C2083 PH180.n11 VSS 0.13318f
C2084 PH180.n12 VSS 0.10343f
C2085 PH180.n13 VSS 0.09221f
C2086 PH180.n14 VSS 0.07192f
C2087 PH180.n15 VSS 0.10148f
C2088 PH180.n16 VSS 0.13318f
C2089 PH180.n17 VSS 0.13318f
C2090 PH180.n18 VSS 0.10343f
C2091 PH180.n19 VSS 0.09221f
C2092 PH180.n20 VSS 0.07192f
C2093 PH180.n21 VSS 0.10148f
C2094 PH180.n22 VSS 0.16276f
C2095 PH180.t82 VSS 0.05442f
C2096 PH180.t4 VSS 0.05569f
C2097 PH180.t74 VSS 0.0493f
C2098 PH180.t50 VSS 0.0493f
C2099 PH180.t30 VSS 0.05569f
C2100 PH180.t72 VSS 0.05442f
C2101 PH180.t49 VSS 0.05442f
C2102 PH180.t17 VSS 0.05569f
C2103 PH180.t65 VSS 0.0493f
C2104 PH180.t42 VSS 0.0493f
C2105 PH180.t28 VSS 0.05569f
C2106 PH180.t64 VSS 0.05442f
C2107 PH180.t40 VSS 0.05442f
C2108 PH180.t25 VSS 0.05569f
C2109 PH180.t95 VSS 0.0493f
C2110 PH180.t39 VSS 0.0493f
C2111 PH180.t11 VSS 0.05569f
C2112 PH180.t54 VSS 0.05442f
C2113 PH180.t77 VSS 0.05442f
C2114 PH180.t6 VSS 0.05569f
C2115 PH180.t92 VSS 0.0493f
C2116 PH180.t32 VSS 0.0493f
C2117 PH180.t5 VSS 0.05569f
C2118 PH180.t44 VSS 0.05553f
C2119 PH180.n23 VSS 0.10343f
C2120 PH180.n24 VSS 0.09221f
C2121 PH180.n25 VSS 0.07192f
C2122 PH180.n26 VSS 0.10148f
C2123 PH180.n27 VSS 0.13318f
C2124 PH180.n28 VSS 0.13318f
C2125 PH180.n29 VSS 0.10343f
C2126 PH180.n30 VSS 0.09221f
C2127 PH180.n31 VSS 0.07192f
C2128 PH180.n32 VSS 0.10148f
C2129 PH180.n33 VSS 0.12089f
C2130 PH180.n34 VSS 0.13318f
C2131 PH180.n35 VSS 0.10343f
C2132 PH180.n36 VSS 0.09221f
C2133 PH180.n37 VSS 0.07192f
C2134 PH180.n38 VSS 0.10148f
C2135 PH180.n39 VSS 0.13318f
C2136 PH180.n40 VSS 0.13318f
C2137 PH180.n41 VSS 0.10343f
C2138 PH180.n42 VSS 0.09221f
C2139 PH180.n43 VSS 0.07192f
C2140 PH180.n44 VSS 0.10148f
C2141 PH180.n45 VSS 0.16276f
C2142 PH180.t69 VSS 0.05442f
C2143 PH180.t23 VSS 0.05569f
C2144 PH180.t57 VSS 0.0493f
C2145 PH180.t34 VSS 0.0493f
C2146 PH180.t22 VSS 0.05569f
C2147 PH180.t56 VSS 0.05442f
C2148 PH180.t33 VSS 0.05442f
C2149 PH180.t1 VSS 0.05569f
C2150 PH180.t46 VSS 0.0493f
C2151 PH180.t94 VSS 0.0493f
C2152 PH180.t20 VSS 0.05569f
C2153 PH180.t45 VSS 0.05442f
C2154 PH180.t84 VSS 0.05442f
C2155 PH180.t13 VSS 0.05569f
C2156 PH180.t90 VSS 0.0493f
C2157 PH180.t93 VSS 0.0493f
C2158 PH180.t27 VSS 0.05569f
C2159 PH180.t37 VSS 0.05442f
C2160 PH180.t59 VSS 0.05442f
C2161 PH180.t19 VSS 0.05569f
C2162 PH180.t88 VSS 0.0493f
C2163 PH180.t91 VSS 0.0493f
C2164 PH180.t24 VSS 0.05569f
C2165 PH180.t58 VSS 0.05553f
C2166 PH180.n46 VSS 0.10343f
C2167 PH180.n47 VSS 0.09221f
C2168 PH180.n48 VSS 0.07192f
C2169 PH180.n49 VSS 0.10148f
C2170 PH180.n50 VSS 0.13318f
C2171 PH180.n51 VSS 0.13318f
C2172 PH180.n52 VSS 0.10343f
C2173 PH180.n53 VSS 0.09221f
C2174 PH180.n54 VSS 0.07192f
C2175 PH180.n55 VSS 0.10148f
C2176 PH180.n56 VSS 0.12089f
C2177 PH180.n57 VSS 0.13318f
C2178 PH180.n58 VSS 0.10343f
C2179 PH180.n59 VSS 0.09221f
C2180 PH180.n60 VSS 0.07192f
C2181 PH180.n61 VSS 0.10148f
C2182 PH180.n62 VSS 0.13318f
C2183 PH180.n63 VSS 0.13318f
C2184 PH180.n64 VSS 0.10343f
C2185 PH180.n65 VSS 0.09221f
C2186 PH180.n66 VSS 0.07192f
C2187 PH180.n67 VSS 0.10148f
C2188 PH180.n68 VSS 0.16276f
C2189 PH180.n69 VSS 0.16889f
C2190 PH180.t10 VSS 0.05569f
C2191 PH180.t89 VSS 0.0493f
C2192 PH180.t80 VSS 0.0493f
C2193 PH180.t9 VSS 0.05569f
C2194 PH180.t61 VSS 0.05442f
C2195 PH180.t79 VSS 0.05442f
C2196 PH180.t26 VSS 0.05569f
C2197 PH180.t85 VSS 0.0493f
C2198 PH180.t71 VSS 0.0493f
C2199 PH180.t3 VSS 0.05569f
C2200 PH180.t48 VSS 0.05442f
C2201 PH180.t38 VSS 0.05442f
C2202 PH180.t60 VSS 0.0493f
C2203 PH180.t70 VSS 0.0493f
C2204 PH180.t18 VSS 0.05569f
C2205 PH180.t81 VSS 0.05442f
C2206 PH180.t36 VSS 0.05442f
C2207 PH180.t2 VSS 0.05569f
C2208 PH180.t47 VSS 0.0493f
C2209 PH180.t63 VSS 0.0493f
C2210 PH180.t12 VSS 0.05569f
C2211 PH180.t73 VSS 0.05553f
C2212 PH180.n70 VSS 0.10343f
C2213 PH180.n71 VSS 0.09221f
C2214 PH180.n72 VSS 0.07192f
C2215 PH180.n73 VSS 0.10148f
C2216 PH180.n74 VSS 0.13318f
C2217 PH180.n75 VSS 0.13318f
C2218 PH180.n76 VSS 0.10343f
C2219 PH180.n77 VSS 0.09221f
C2220 PH180.n78 VSS 0.07192f
C2221 PH180.t8 VSS 0.05569f
C2222 PH180.n79 VSS 0.10148f
C2223 PH180.n80 VSS 0.12089f
C2224 PH180.n81 VSS 0.13318f
C2225 PH180.n82 VSS 0.10343f
C2226 PH180.n83 VSS 0.09221f
C2227 PH180.n84 VSS 0.07192f
C2228 PH180.n85 VSS 0.10148f
C2229 PH180.n86 VSS 0.13318f
C2230 PH180.n87 VSS 0.13318f
C2231 PH180.n88 VSS 0.10343f
C2232 PH180.n89 VSS 0.09221f
C2233 PH180.n90 VSS 0.07192f
C2234 PH180.n91 VSS 0.10148f
C2235 6ph_rosc_0.psdiff_2.buff_d8$1_1.VIN.t32 VSS 0.04833f
C2236 6ph_rosc_0.psdiff_2.buff_d8$1_1.VIN.t13 VSS 0.02159f
C2237 6ph_rosc_0.psdiff_2.buff_d8$1_1.VIN.t4 VSS 0.02136f
C2238 6ph_rosc_0.psdiff_2.buff_d8$1_1.VIN.n0 VSS 0.02731f
C2239 6ph_rosc_0.psdiff_2.buff_d8$1_1.VIN.t11 VSS 0.02136f
C2240 6ph_rosc_0.psdiff_2.buff_d8$1_1.VIN.n1 VSS 0.01262f
C2241 6ph_rosc_0.psdiff_2.buff_d8$1_1.VIN.t8 VSS 0.02159f
C2242 6ph_rosc_0.psdiff_2.buff_d8$1_1.VIN.t2 VSS 0.02136f
C2243 6ph_rosc_0.psdiff_2.buff_d8$1_1.VIN.n2 VSS 0.02731f
C2244 6ph_rosc_0.psdiff_2.buff_d8$1_1.VIN.t6 VSS 0.02136f
C2245 6ph_rosc_0.psdiff_2.buff_d8$1_1.VIN.n3 VSS 0.01262f
C2246 6ph_rosc_0.psdiff_2.buff_d8$1_1.VIN.t25 VSS 0.01945f
C2247 6ph_rosc_0.psdiff_2.buff_d8$1_1.VIN.t12 VSS 0.02159f
C2248 6ph_rosc_0.psdiff_2.buff_d8$1_1.VIN.t3 VSS 0.02136f
C2249 6ph_rosc_0.psdiff_2.buff_d8$1_1.VIN.n4 VSS 0.02731f
C2250 6ph_rosc_0.psdiff_2.buff_d8$1_1.VIN.t10 VSS 0.02136f
C2251 6ph_rosc_0.psdiff_2.buff_d8$1_1.VIN.n5 VSS 0.01262f
C2252 6ph_rosc_0.psdiff_2.buff_d8$1_1.VIN.t23 VSS 0.02159f
C2253 6ph_rosc_0.psdiff_2.buff_d8$1_1.VIN.t19 VSS 0.02136f
C2254 6ph_rosc_0.psdiff_2.buff_d8$1_1.VIN.n6 VSS 0.0328f
C2255 6ph_rosc_0.psdiff_2.buff_d8$1_1.VIN.t31 VSS 0.02136f
C2256 6ph_rosc_0.psdiff_2.buff_d8$1_1.VIN.t16 VSS 0.02159f
C2257 6ph_rosc_0.psdiff_2.buff_d8$1_1.VIN.t21 VSS 0.02136f
C2258 6ph_rosc_0.psdiff_2.buff_d8$1_1.VIN.n7 VSS 0.03339f
C2259 6ph_rosc_0.psdiff_2.buff_d8$1_1.VIN.t28 VSS 0.02136f
C2260 6ph_rosc_0.psdiff_2.buff_d8$1_1.VIN.n8 VSS 0.0187f
C2261 6ph_rosc_0.psdiff_2.buff_d8$1_1.VIN.t17 VSS 0.02159f
C2262 6ph_rosc_0.psdiff_2.buff_d8$1_1.VIN.t22 VSS 0.02136f
C2263 6ph_rosc_0.psdiff_2.buff_d8$1_1.VIN.n9 VSS 0.03339f
C2264 6ph_rosc_0.psdiff_2.buff_d8$1_1.VIN.t30 VSS 0.02136f
C2265 6ph_rosc_0.psdiff_2.buff_d8$1_1.VIN.n10 VSS 0.0187f
C2266 6ph_rosc_0.psdiff_2.buff_d8$1_1.VIN.t15 VSS 0.02159f
C2267 6ph_rosc_0.psdiff_2.buff_d8$1_1.VIN.t20 VSS 0.02136f
C2268 6ph_rosc_0.psdiff_2.buff_d8$1_1.VIN.n11 VSS 0.03339f
C2269 6ph_rosc_0.psdiff_2.buff_d8$1_1.VIN.t27 VSS 0.02136f
C2270 6ph_rosc_0.psdiff_2.buff_d8$1_1.VIN.n12 VSS 0.0187f
C2271 6ph_rosc_0.psdiff_2.buff_d8$1_1.VIN.t18 VSS 0.02159f
C2272 6ph_rosc_0.psdiff_2.buff_d8$1_1.VIN.t24 VSS 0.02136f
C2273 6ph_rosc_0.psdiff_2.buff_d8$1_1.VIN.n13 VSS 0.03339f
C2274 6ph_rosc_0.psdiff_2.buff_d8$1_1.VIN.t29 VSS 0.02136f
C2275 6ph_rosc_0.psdiff_2.buff_d8$1_1.VIN.n14 VSS 0.03818f
C2276 6ph_rosc_0.psdiff_2.buff_d8$1_1.VIN.n15 VSS 0.04516f
C2277 6ph_rosc_0.psdiff_2.buff_d8$1_1.VIN.n16 VSS 0.03986f
C2278 6ph_rosc_0.psdiff_2.buff_d8$1_1.VIN.n17 VSS 0.04446f
C2279 6ph_rosc_0.psdiff_2.buff_d8$1_1.VIN.n18 VSS 0.09792f
C2280 6ph_rosc_0.psdiff_2.buff_d8$1_1.VIN.t26 VSS 0.01933f
C2281 6ph_rosc_0.psdiff_2.buff_d8$1_1.VIN.n19 VSS 0.066f
C2282 6ph_rosc_0.psdiff_2.buff_d8$1_1.VIN.t0 VSS 0.02159f
C2283 6ph_rosc_0.psdiff_2.buff_d8$1_1.VIN.t7 VSS 0.02136f
C2284 6ph_rosc_0.psdiff_2.buff_d8$1_1.VIN.n20 VSS 0.02731f
C2285 6ph_rosc_0.psdiff_2.buff_d8$1_1.VIN.t14 VSS 0.02136f
C2286 6ph_rosc_0.psdiff_2.buff_d8$1_1.VIN.n21 VSS 0.01262f
C2287 6ph_rosc_0.psdiff_2.buff_d8$1_1.VIN.n22 VSS 0.02934f
C2288 6ph_rosc_0.psdiff_2.buff_d8$1_1.VIN.n23 VSS 0.05345f
C2289 6ph_rosc_0.psdiff_2.buff_d8$1_1.VIN.n24 VSS 0.03986f
C2290 6ph_rosc_0.psdiff_2.buff_d8$1_1.VIN.n25 VSS 0.04446f
C2291 6ph_rosc_0.psdiff_2.buff_d8$1_1.VIN.t1 VSS 0.02159f
C2292 6ph_rosc_0.psdiff_2.buff_d8$1_1.VIN.t9 VSS 0.02136f
C2293 6ph_rosc_0.psdiff_2.buff_d8$1_1.VIN.n26 VSS 0.02684f
C2294 6ph_rosc_0.psdiff_2.buff_d8$1_1.VIN.t5 VSS 0.02136f
C2295 6ph_rosc_0.psdiff_2.buff_d8$1_1.VIN.n27 VSS 0.23885f
C2296 6ph_rosc_0.psdiff_2.buff_d8$1_1.VIN.n28 VSS 0.21576f
C2297 6ph_rosc_0.psdiff_2.buff_d8$1_1.inv$3_0.VIN VSS 0.0075f
C2298 6ph_rosc_0.psdiff_2.CLKP.t7 VSS 0.01269f
C2299 6ph_rosc_0.psdiff_2.CLKP.t0 VSS 0.01269f
C2300 6ph_rosc_0.psdiff_2.CLKP.n0 VSS 0.00494f
C2301 6ph_rosc_0.psdiff_2.CLKP.n1 VSS 0.03008f
C2302 6ph_rosc_0.psdiff_2.CLKP.n2 VSS 0.02061f
C2303 6ph_rosc_0.psdiff_2.CLKP.t4 VSS 0.01269f
C2304 6ph_rosc_0.psdiff_2.CLKP.t2 VSS 0.01269f
C2305 6ph_rosc_0.psdiff_2.CLKP.n3 VSS 0.00494f
C2306 6ph_rosc_0.psdiff_2.CLKP.n4 VSS 0.03008f
C2307 6ph_rosc_0.psdiff_2.CLKP.n5 VSS 0.02061f
C2308 6ph_rosc_0.psdiff_2.CLKP.t8 VSS 0.26727f
C2309 6ph_rosc_0.psdiff_2.CLKP.t9 VSS 0.02872f
C2310 6ph_rosc_0.psdiff_2.CLKP.n6 VSS 0.00642f
C2311 6ph_rosc_0.psdiff_2.CLKP.n7 VSS 0.90514f
C2312 6ph_rosc_0.psdiff_2.CLKP.n8 VSS 0.03596f
C2313 6ph_rosc_0.psdiff_2.CLKP.n9 VSS 0.04299f
C2314 6ph_rosc_0.psdiff_2.CLKP.t6 VSS 0.01269f
C2315 6ph_rosc_0.psdiff_2.CLKP.t1 VSS 0.01269f
C2316 6ph_rosc_0.psdiff_2.CLKP.n10 VSS 0.00494f
C2317 6ph_rosc_0.psdiff_2.CLKP.n11 VSS 0.03008f
C2318 6ph_rosc_0.psdiff_2.CLKP.n12 VSS 0.02334f
C2319 6ph_rosc_0.psdiff_2.CLKP.n13 VSS 0.07285f
C2320 6ph_rosc_0.psdiff_2.CLKP.t5 VSS 0.01269f
C2321 6ph_rosc_0.psdiff_2.CLKP.n14 VSS 0.02061f
C2322 6ph_rosc_0.psdiff_2.CLKP.n15 VSS 0.03008f
C2323 6ph_rosc_0.psdiff_2.CLKP.t3 VSS 0.01269f
C2324 6ph_rosc_0.psdiff_2.CLKP.n16 VSS 0.00494f
C2325 6ph_rosc_0.psdiff_1.buff_d8$1_1.VIN.t32 VSS 0.05063f
C2326 6ph_rosc_0.psdiff_1.buff_d8$1_1.VIN.t27 VSS 0.02262f
C2327 6ph_rosc_0.psdiff_1.buff_d8$1_1.VIN.t31 VSS 0.02237f
C2328 6ph_rosc_0.psdiff_1.buff_d8$1_1.VIN.n0 VSS 0.02861f
C2329 6ph_rosc_0.psdiff_1.buff_d8$1_1.VIN.t25 VSS 0.02237f
C2330 6ph_rosc_0.psdiff_1.buff_d8$1_1.VIN.n1 VSS 0.01322f
C2331 6ph_rosc_0.psdiff_1.buff_d8$1_1.VIN.t24 VSS 0.02262f
C2332 6ph_rosc_0.psdiff_1.buff_d8$1_1.VIN.t30 VSS 0.02237f
C2333 6ph_rosc_0.psdiff_1.buff_d8$1_1.VIN.n2 VSS 0.02861f
C2334 6ph_rosc_0.psdiff_1.buff_d8$1_1.VIN.t21 VSS 0.02237f
C2335 6ph_rosc_0.psdiff_1.buff_d8$1_1.VIN.n3 VSS 0.01322f
C2336 6ph_rosc_0.psdiff_1.buff_d8$1_1.VIN.t10 VSS 0.02037f
C2337 6ph_rosc_0.psdiff_1.buff_d8$1_1.VIN.t18 VSS 0.02262f
C2338 6ph_rosc_0.psdiff_1.buff_d8$1_1.VIN.t28 VSS 0.02237f
C2339 6ph_rosc_0.psdiff_1.buff_d8$1_1.VIN.n4 VSS 0.02861f
C2340 6ph_rosc_0.psdiff_1.buff_d8$1_1.VIN.t17 VSS 0.02237f
C2341 6ph_rosc_0.psdiff_1.buff_d8$1_1.VIN.n5 VSS 0.01322f
C2342 6ph_rosc_0.psdiff_1.buff_d8$1_1.VIN.t22 VSS 0.02262f
C2343 6ph_rosc_0.psdiff_1.buff_d8$1_1.VIN.t29 VSS 0.02237f
C2344 6ph_rosc_0.psdiff_1.buff_d8$1_1.VIN.n6 VSS 0.02861f
C2345 6ph_rosc_0.psdiff_1.buff_d8$1_1.VIN.t20 VSS 0.02237f
C2346 6ph_rosc_0.psdiff_1.buff_d8$1_1.VIN.n7 VSS 0.01322f
C2347 6ph_rosc_0.psdiff_1.buff_d8$1_1.VIN.t11 VSS 0.02026f
C2348 6ph_rosc_0.psdiff_1.buff_d8$1_1.VIN.t7 VSS 0.02262f
C2349 6ph_rosc_0.psdiff_1.buff_d8$1_1.VIN.t0 VSS 0.02237f
C2350 6ph_rosc_0.psdiff_1.buff_d8$1_1.VIN.n8 VSS 0.03437f
C2351 6ph_rosc_0.psdiff_1.buff_d8$1_1.VIN.t3 VSS 0.02262f
C2352 6ph_rosc_0.psdiff_1.buff_d8$1_1.VIN.t5 VSS 0.02237f
C2353 6ph_rosc_0.psdiff_1.buff_d8$1_1.VIN.n9 VSS 0.03498f
C2354 6ph_rosc_0.psdiff_1.buff_d8$1_1.VIN.t16 VSS 0.02237f
C2355 6ph_rosc_0.psdiff_1.buff_d8$1_1.VIN.n10 VSS 0.01959f
C2356 6ph_rosc_0.psdiff_1.buff_d8$1_1.VIN.t6 VSS 0.02262f
C2357 6ph_rosc_0.psdiff_1.buff_d8$1_1.VIN.t1 VSS 0.02237f
C2358 6ph_rosc_0.psdiff_1.buff_d8$1_1.VIN.n11 VSS 0.03498f
C2359 6ph_rosc_0.psdiff_1.buff_d8$1_1.VIN.t12 VSS 0.02237f
C2360 6ph_rosc_0.psdiff_1.buff_d8$1_1.VIN.n12 VSS 0.01959f
C2361 6ph_rosc_0.psdiff_1.buff_d8$1_1.VIN.t8 VSS 0.02262f
C2362 6ph_rosc_0.psdiff_1.buff_d8$1_1.VIN.t4 VSS 0.02237f
C2363 6ph_rosc_0.psdiff_1.buff_d8$1_1.VIN.n13 VSS 0.03498f
C2364 6ph_rosc_0.psdiff_1.buff_d8$1_1.VIN.t14 VSS 0.02237f
C2365 6ph_rosc_0.psdiff_1.buff_d8$1_1.VIN.n14 VSS 0.01959f
C2366 6ph_rosc_0.psdiff_1.buff_d8$1_1.VIN.t2 VSS 0.02262f
C2367 6ph_rosc_0.psdiff_1.buff_d8$1_1.VIN.t9 VSS 0.02237f
C2368 6ph_rosc_0.psdiff_1.buff_d8$1_1.VIN.n15 VSS 0.03498f
C2369 6ph_rosc_0.psdiff_1.buff_d8$1_1.VIN.t15 VSS 0.02237f
C2370 6ph_rosc_0.psdiff_1.buff_d8$1_1.VIN.n16 VSS 0.04f
C2371 6ph_rosc_0.psdiff_1.buff_d8$1_1.VIN.n17 VSS 0.04731f
C2372 6ph_rosc_0.psdiff_1.buff_d8$1_1.VIN.n18 VSS 0.04176f
C2373 6ph_rosc_0.psdiff_1.buff_d8$1_1.VIN.n19 VSS 0.04657f
C2374 6ph_rosc_0.psdiff_1.buff_d8$1_1.VIN.t13 VSS 0.02237f
C2375 6ph_rosc_0.psdiff_1.buff_d8$1_1.VIN.n20 VSS 0.10258f
C2376 6ph_rosc_0.psdiff_1.buff_d8$1_1.VIN.n21 VSS 0.06915f
C2377 6ph_rosc_0.psdiff_1.buff_d8$1_1.VIN.n22 VSS 0.03074f
C2378 6ph_rosc_0.psdiff_1.buff_d8$1_1.VIN.n23 VSS 0.05599f
C2379 6ph_rosc_0.psdiff_1.buff_d8$1_1.VIN.n24 VSS 0.04176f
C2380 6ph_rosc_0.psdiff_1.buff_d8$1_1.VIN.n25 VSS 0.04657f
C2381 6ph_rosc_0.psdiff_1.buff_d8$1_1.VIN.t23 VSS 0.02237f
C2382 6ph_rosc_0.psdiff_1.buff_d8$1_1.VIN.t26 VSS 0.02262f
C2383 6ph_rosc_0.psdiff_1.buff_d8$1_1.VIN.t19 VSS 0.02237f
C2384 6ph_rosc_0.psdiff_1.buff_d8$1_1.VIN.n26 VSS 0.02812f
C2385 6ph_rosc_0.psdiff_1.buff_d8$1_1.VIN.n27 VSS 0.25023f
C2386 6ph_rosc_0.psdiff_1.buff_d8$1_1.VIN.n28 VSS 0.22604f
C2387 6ph_rosc_0.psdiff_1.buff_d8$1_1.inv$3_0.VIN VSS 0.00786f
C2388 6to4_0.buff_PI_d32_3.inv_PI_d16$1_0.VIN.t26 VSS 0.04302f
C2389 6to4_0.buff_PI_d32_3.inv_PI_d16$1_0.VIN.t58 VSS 0.31922f
C2390 6to4_0.buff_PI_d32_3.inv_PI_d16$1_0.VIN.n0 VSS 0.01909f
C2391 6to4_0.buff_PI_d32_3.inv_PI_d16$1_0.VIN.n1 VSS 0.1691f
C2392 6to4_0.buff_PI_d32_3.inv_PI_d16$1_0.VIN.t62 VSS 0.31922f
C2393 6to4_0.buff_PI_d32_3.inv_PI_d16$1_0.VIN.n2 VSS 0.01909f
C2394 6to4_0.buff_PI_d32_3.inv_PI_d16$1_0.VIN.n3 VSS 0.15175f
C2395 6to4_0.buff_PI_d32_3.inv_PI_d16$1_0.VIN.t50 VSS 0.31922f
C2396 6to4_0.buff_PI_d32_3.inv_PI_d16$1_0.VIN.n4 VSS 0.01909f
C2397 6to4_0.buff_PI_d32_3.inv_PI_d16$1_0.VIN.n5 VSS 0.15175f
C2398 6to4_0.buff_PI_d32_3.inv_PI_d16$1_0.VIN.t56 VSS 0.31922f
C2399 6to4_0.buff_PI_d32_3.inv_PI_d16$1_0.VIN.n6 VSS 0.04284f
C2400 6to4_0.buff_PI_d32_3.inv_PI_d16$1_0.VIN.t53 VSS 0.31922f
C2401 6to4_0.buff_PI_d32_3.inv_PI_d16$1_0.VIN.n7 VSS 0.01909f
C2402 6to4_0.buff_PI_d32_3.inv_PI_d16$1_0.VIN.n8 VSS 0.26413f
C2403 6to4_0.buff_PI_d32_3.inv_PI_d16$1_0.VIN.t52 VSS 0.31922f
C2404 6to4_0.buff_PI_d32_3.inv_PI_d16$1_0.VIN.n9 VSS 0.04284f
C2405 6to4_0.buff_PI_d32_3.inv_PI_d16$1_0.VIN.t59 VSS 0.31922f
C2406 6to4_0.buff_PI_d32_3.inv_PI_d16$1_0.VIN.n10 VSS 0.01909f
C2407 6to4_0.buff_PI_d32_3.inv_PI_d16$1_0.VIN.n11 VSS 0.26413f
C2408 6to4_0.buff_PI_d32_3.inv_PI_d16$1_0.VIN.t57 VSS 0.31922f
C2409 6to4_0.buff_PI_d32_3.inv_PI_d16$1_0.VIN.n12 VSS 0.02603f
C2410 6to4_0.buff_PI_d32_3.inv_PI_d16$1_0.VIN.n13 VSS 0.15156f
C2411 6to4_0.buff_PI_d32_3.inv_PI_d16$1_0.VIN.n14 VSS 0.39234f
C2412 6to4_0.buff_PI_d32_3.inv_PI_d16$1_0.VIN.n15 VSS 0.39234f
C2413 6to4_0.buff_PI_d32_3.inv_PI_d16$1_0.VIN.t49 VSS 0.31922f
C2414 6to4_0.buff_PI_d32_3.inv_PI_d16$1_0.VIN.n16 VSS 0.02603f
C2415 6to4_0.buff_PI_d32_3.inv_PI_d16$1_0.VIN.n17 VSS 0.15156f
C2416 6to4_0.buff_PI_d32_3.inv_PI_d16$1_0.VIN.t51 VSS 0.31922f
C2417 6to4_0.buff_PI_d32_3.inv_PI_d16$1_0.VIN.n18 VSS 0.01909f
C2418 6to4_0.buff_PI_d32_3.inv_PI_d16$1_0.VIN.n19 VSS 0.15175f
C2419 6to4_0.buff_PI_d32_3.inv_PI_d16$1_0.VIN.t61 VSS 0.31922f
C2420 6to4_0.buff_PI_d32_3.inv_PI_d16$1_0.VIN.n20 VSS 0.02603f
C2421 6to4_0.buff_PI_d32_3.inv_PI_d16$1_0.VIN.n21 VSS 0.15156f
C2422 6to4_0.buff_PI_d32_3.inv_PI_d16$1_0.VIN.n22 VSS 0.39234f
C2423 6to4_0.buff_PI_d32_3.inv_PI_d16$1_0.VIN.n23 VSS 0.39234f
C2424 6to4_0.buff_PI_d32_3.inv_PI_d16$1_0.VIN.t60 VSS 0.31922f
C2425 6to4_0.buff_PI_d32_3.inv_PI_d16$1_0.VIN.n24 VSS 0.02603f
C2426 6to4_0.buff_PI_d32_3.inv_PI_d16$1_0.VIN.n25 VSS 0.15156f
C2427 6to4_0.buff_PI_d32_3.inv_PI_d16$1_0.VIN.t55 VSS 0.31922f
C2428 6to4_0.buff_PI_d32_3.inv_PI_d16$1_0.VIN.n26 VSS 0.01909f
C2429 6to4_0.buff_PI_d32_3.inv_PI_d16$1_0.VIN.n27 VSS 0.15175f
C2430 6to4_0.buff_PI_d32_3.inv_PI_d16$1_0.VIN.t54 VSS 0.31922f
C2431 6to4_0.buff_PI_d32_3.inv_PI_d16$1_0.VIN.n28 VSS 0.02603f
C2432 6to4_0.buff_PI_d32_3.inv_PI_d16$1_0.VIN.n29 VSS 0.15156f
C2433 6to4_0.buff_PI_d32_3.inv_PI_d16$1_0.VIN.n30 VSS 0.11467f
C2434 6to4_0.buff_PI_d32_3.inv_PI_d16$1_0.VIN.n31 VSS 0.1116f
C2435 6to4_0.buff_PI_d32_3.inv_PI_d16$1_0.VIN.t63 VSS 0.31922f
C2436 6to4_0.buff_PI_d32_3.inv_PI_d16$1_0.VIN.n32 VSS 0.02603f
C2437 6to4_0.buff_PI_d32_3.inv_PI_d16$1_0.VIN.n33 VSS 0.15156f
C2438 6to4_0.buff_PI_d32_3.inv_PI_d16$1_0.VIN.t48 VSS 0.31922f
C2439 6to4_0.buff_PI_d32_3.inv_PI_d16$1_0.VIN.n34 VSS 0.01909f
C2440 6to4_0.buff_PI_d32_3.inv_PI_d16$1_0.VIN.n35 VSS 0.16967f
C2441 6to4_0.buff_PI_d32_3.inv_PI_d16$1_0.VIN.t40 VSS 0.04302f
C2442 6to4_0.buff_PI_d32_3.inv_PI_d16$1_0.VIN.t39 VSS 0.04403f
C2443 6to4_0.buff_PI_d32_3.inv_PI_d16$1_0.VIN.t41 VSS 0.03897f
C2444 6to4_0.buff_PI_d32_3.inv_PI_d16$1_0.VIN.t43 VSS 0.03897f
C2445 6to4_0.buff_PI_d32_3.inv_PI_d16$1_0.VIN.t42 VSS 0.04403f
C2446 6to4_0.buff_PI_d32_3.inv_PI_d16$1_0.VIN.t44 VSS 0.04302f
C2447 6to4_0.buff_PI_d32_3.inv_PI_d16$1_0.VIN.t46 VSS 0.04302f
C2448 6to4_0.buff_PI_d32_3.inv_PI_d16$1_0.VIN.t45 VSS 0.04403f
C2449 6to4_0.buff_PI_d32_3.inv_PI_d16$1_0.VIN.t47 VSS 0.03897f
C2450 6to4_0.buff_PI_d32_3.inv_PI_d16$1_0.VIN.t16 VSS 0.03897f
C2451 6to4_0.buff_PI_d32_3.inv_PI_d16$1_0.VIN.t15 VSS 0.04403f
C2452 6to4_0.buff_PI_d32_3.inv_PI_d16$1_0.VIN.t17 VSS 0.04302f
C2453 6to4_0.buff_PI_d32_3.inv_PI_d16$1_0.VIN.t14 VSS 0.04302f
C2454 6to4_0.buff_PI_d32_3.inv_PI_d16$1_0.VIN.t12 VSS 0.04403f
C2455 6to4_0.buff_PI_d32_3.inv_PI_d16$1_0.VIN.t13 VSS 0.03897f
C2456 6to4_0.buff_PI_d32_3.inv_PI_d16$1_0.VIN.t35 VSS 0.03897f
C2457 6to4_0.buff_PI_d32_3.inv_PI_d16$1_0.VIN.t33 VSS 0.04403f
C2458 6to4_0.buff_PI_d32_3.inv_PI_d16$1_0.VIN.t34 VSS 0.04302f
C2459 6to4_0.buff_PI_d32_3.inv_PI_d16$1_0.VIN.t11 VSS 0.04302f
C2460 6to4_0.buff_PI_d32_3.inv_PI_d16$1_0.VIN.t9 VSS 0.04403f
C2461 6to4_0.buff_PI_d32_3.inv_PI_d16$1_0.VIN.t10 VSS 0.03897f
C2462 6to4_0.buff_PI_d32_3.inv_PI_d16$1_0.VIN.t32 VSS 0.03897f
C2463 6to4_0.buff_PI_d32_3.inv_PI_d16$1_0.VIN.t30 VSS 0.04403f
C2464 6to4_0.buff_PI_d32_3.inv_PI_d16$1_0.VIN.t31 VSS 0.0439f
C2465 6to4_0.buff_PI_d32_3.inv_PI_d16$1_0.VIN.n36 VSS 0.08177f
C2466 6to4_0.buff_PI_d32_3.inv_PI_d16$1_0.VIN.n37 VSS 0.0729f
C2467 6to4_0.buff_PI_d32_3.inv_PI_d16$1_0.VIN.n38 VSS 0.05686f
C2468 6to4_0.buff_PI_d32_3.inv_PI_d16$1_0.VIN.n39 VSS 0.08023f
C2469 6to4_0.buff_PI_d32_3.inv_PI_d16$1_0.VIN.n40 VSS 0.10529f
C2470 6to4_0.buff_PI_d32_3.inv_PI_d16$1_0.VIN.n41 VSS 0.10529f
C2471 6to4_0.buff_PI_d32_3.inv_PI_d16$1_0.VIN.n42 VSS 0.08177f
C2472 6to4_0.buff_PI_d32_3.inv_PI_d16$1_0.VIN.n43 VSS 0.0729f
C2473 6to4_0.buff_PI_d32_3.inv_PI_d16$1_0.VIN.n44 VSS 0.05686f
C2474 6to4_0.buff_PI_d32_3.inv_PI_d16$1_0.VIN.n45 VSS 0.08023f
C2475 6to4_0.buff_PI_d32_3.inv_PI_d16$1_0.VIN.n46 VSS 0.09558f
C2476 6to4_0.buff_PI_d32_3.inv_PI_d16$1_0.VIN.n47 VSS 0.10529f
C2477 6to4_0.buff_PI_d32_3.inv_PI_d16$1_0.VIN.n48 VSS 0.08177f
C2478 6to4_0.buff_PI_d32_3.inv_PI_d16$1_0.VIN.n49 VSS 0.0729f
C2479 6to4_0.buff_PI_d32_3.inv_PI_d16$1_0.VIN.n50 VSS 0.05686f
C2480 6to4_0.buff_PI_d32_3.inv_PI_d16$1_0.VIN.n51 VSS 0.08023f
C2481 6to4_0.buff_PI_d32_3.inv_PI_d16$1_0.VIN.n52 VSS 0.10529f
C2482 6to4_0.buff_PI_d32_3.inv_PI_d16$1_0.VIN.n53 VSS 0.10529f
C2483 6to4_0.buff_PI_d32_3.inv_PI_d16$1_0.VIN.n54 VSS 0.08177f
C2484 6to4_0.buff_PI_d32_3.inv_PI_d16$1_0.VIN.n55 VSS 0.0729f
C2485 6to4_0.buff_PI_d32_3.inv_PI_d16$1_0.VIN.n56 VSS 0.05686f
C2486 6to4_0.buff_PI_d32_3.inv_PI_d16$1_0.VIN.n57 VSS 0.08023f
C2487 6to4_0.buff_PI_d32_3.inv_PI_d16$1_0.VIN.n58 VSS 0.12867f
C2488 6to4_0.buff_PI_d32_3.inv_PI_d16$1_0.VIN.n59 VSS 0.11086f
C2489 6to4_0.buff_PI_d32_3.inv_PI_d16$1_0.VIN.n60 VSS 0.15759f
C2490 6to4_0.buff_PI_d32_3.inv_PI_d16$1_0.VIN.n61 VSS 0.12867f
C2491 6to4_0.buff_PI_d32_3.inv_PI_d16$1_0.VIN.t24 VSS 0.04403f
C2492 6to4_0.buff_PI_d32_3.inv_PI_d16$1_0.VIN.t25 VSS 0.03897f
C2493 6to4_0.buff_PI_d32_3.inv_PI_d16$1_0.VIN.t5 VSS 0.03897f
C2494 6to4_0.buff_PI_d32_3.inv_PI_d16$1_0.VIN.t3 VSS 0.04403f
C2495 6to4_0.buff_PI_d32_3.inv_PI_d16$1_0.VIN.t4 VSS 0.04302f
C2496 6to4_0.buff_PI_d32_3.inv_PI_d16$1_0.VIN.t37 VSS 0.04302f
C2497 6to4_0.buff_PI_d32_3.inv_PI_d16$1_0.VIN.t36 VSS 0.04403f
C2498 6to4_0.buff_PI_d32_3.inv_PI_d16$1_0.VIN.t38 VSS 0.03897f
C2499 6to4_0.buff_PI_d32_3.inv_PI_d16$1_0.VIN.t29 VSS 0.03897f
C2500 6to4_0.buff_PI_d32_3.inv_PI_d16$1_0.VIN.t27 VSS 0.04403f
C2501 6to4_0.buff_PI_d32_3.inv_PI_d16$1_0.VIN.t28 VSS 0.04302f
C2502 6to4_0.buff_PI_d32_3.inv_PI_d16$1_0.VIN.t1 VSS 0.04302f
C2503 6to4_0.buff_PI_d32_3.inv_PI_d16$1_0.VIN.t2 VSS 0.03897f
C2504 6to4_0.buff_PI_d32_3.inv_PI_d16$1_0.VIN.t19 VSS 0.03897f
C2505 6to4_0.buff_PI_d32_3.inv_PI_d16$1_0.VIN.t18 VSS 0.04403f
C2506 6to4_0.buff_PI_d32_3.inv_PI_d16$1_0.VIN.t20 VSS 0.04302f
C2507 6to4_0.buff_PI_d32_3.inv_PI_d16$1_0.VIN.t22 VSS 0.04302f
C2508 6to4_0.buff_PI_d32_3.inv_PI_d16$1_0.VIN.t21 VSS 0.04403f
C2509 6to4_0.buff_PI_d32_3.inv_PI_d16$1_0.VIN.t23 VSS 0.03897f
C2510 6to4_0.buff_PI_d32_3.inv_PI_d16$1_0.VIN.t8 VSS 0.03897f
C2511 6to4_0.buff_PI_d32_3.inv_PI_d16$1_0.VIN.t6 VSS 0.04403f
C2512 6to4_0.buff_PI_d32_3.inv_PI_d16$1_0.VIN.t7 VSS 0.0439f
C2513 6to4_0.buff_PI_d32_3.inv_PI_d16$1_0.VIN.n62 VSS 0.08177f
C2514 6to4_0.buff_PI_d32_3.inv_PI_d16$1_0.VIN.n63 VSS 0.0729f
C2515 6to4_0.buff_PI_d32_3.inv_PI_d16$1_0.VIN.n64 VSS 0.05686f
C2516 6to4_0.buff_PI_d32_3.inv_PI_d16$1_0.VIN.n65 VSS 0.08023f
C2517 6to4_0.buff_PI_d32_3.inv_PI_d16$1_0.VIN.n66 VSS 0.10529f
C2518 6to4_0.buff_PI_d32_3.inv_PI_d16$1_0.VIN.n67 VSS 0.10529f
C2519 6to4_0.buff_PI_d32_3.inv_PI_d16$1_0.VIN.n68 VSS 0.08177f
C2520 6to4_0.buff_PI_d32_3.inv_PI_d16$1_0.VIN.n69 VSS 0.0729f
C2521 6to4_0.buff_PI_d32_3.inv_PI_d16$1_0.VIN.n70 VSS 0.05686f
C2522 6to4_0.buff_PI_d32_3.inv_PI_d16$1_0.VIN.t0 VSS 0.04403f
C2523 6to4_0.buff_PI_d32_3.inv_PI_d16$1_0.VIN.n71 VSS 0.08023f
C2524 6to4_0.buff_PI_d32_3.inv_PI_d16$1_0.VIN.n72 VSS 0.09558f
C2525 6to4_0.buff_PI_d32_3.inv_PI_d16$1_0.VIN.n73 VSS 0.10529f
C2526 6to4_0.buff_PI_d32_3.inv_PI_d16$1_0.VIN.n74 VSS 0.08177f
C2527 6to4_0.buff_PI_d32_3.inv_PI_d16$1_0.VIN.n75 VSS 0.0729f
C2528 6to4_0.buff_PI_d32_3.inv_PI_d16$1_0.VIN.n76 VSS 0.05686f
C2529 6to4_0.buff_PI_d32_3.inv_PI_d16$1_0.VIN.n77 VSS 0.08023f
C2530 6to4_0.buff_PI_d32_3.inv_PI_d16$1_0.VIN.n78 VSS 0.10529f
C2531 6to4_0.buff_PI_d32_3.inv_PI_d16$1_0.VIN.n79 VSS 0.10529f
C2532 6to4_0.buff_PI_d32_3.inv_PI_d16$1_0.VIN.n80 VSS 0.08177f
C2533 6to4_0.buff_PI_d32_3.inv_PI_d16$1_0.VIN.n81 VSS 0.0729f
C2534 6to4_0.buff_PI_d32_3.inv_PI_d16$1_0.VIN.n82 VSS 0.05686f
C2535 6to4_0.buff_PI_d32_3.inv_PI_d16$1_0.VIN.n83 VSS 0.08023f
C2536 6ph_rosc_0.psdiff_0.buff_d8$1_0.inv$3_0.VIN VSS 0.01372f
C2537 6ph_rosc_0.psdiff_0.buff_d8$1_0.VIN.t32 VSS 0.05604f
C2538 6ph_rosc_0.psdiff_0.buff_d8$1_0.VIN.t23 VSS 0.02504f
C2539 6ph_rosc_0.psdiff_0.buff_d8$1_0.VIN.t18 VSS 0.02476f
C2540 6ph_rosc_0.psdiff_0.buff_d8$1_0.VIN.n0 VSS 0.03167f
C2541 6ph_rosc_0.psdiff_0.buff_d8$1_0.VIN.t21 VSS 0.02476f
C2542 6ph_rosc_0.psdiff_0.buff_d8$1_0.VIN.n1 VSS 0.01463f
C2543 6ph_rosc_0.psdiff_0.buff_d8$1_0.VIN.t17 VSS 0.02504f
C2544 6ph_rosc_0.psdiff_0.buff_d8$1_0.VIN.t30 VSS 0.02476f
C2545 6ph_rosc_0.psdiff_0.buff_d8$1_0.VIN.n2 VSS 0.03167f
C2546 6ph_rosc_0.psdiff_0.buff_d8$1_0.VIN.t31 VSS 0.02476f
C2547 6ph_rosc_0.psdiff_0.buff_d8$1_0.VIN.n3 VSS 0.01463f
C2548 6ph_rosc_0.psdiff_0.buff_d8$1_0.VIN.t11 VSS 0.02255f
C2549 6ph_rosc_0.psdiff_0.buff_d8$1_0.VIN.t22 VSS 0.02504f
C2550 6ph_rosc_0.psdiff_0.buff_d8$1_0.VIN.t19 VSS 0.02476f
C2551 6ph_rosc_0.psdiff_0.buff_d8$1_0.VIN.n4 VSS 0.03167f
C2552 6ph_rosc_0.psdiff_0.buff_d8$1_0.VIN.t20 VSS 0.02476f
C2553 6ph_rosc_0.psdiff_0.buff_d8$1_0.VIN.n5 VSS 0.01463f
C2554 6ph_rosc_0.psdiff_0.buff_d8$1_0.VIN.t29 VSS 0.02504f
C2555 6ph_rosc_0.psdiff_0.buff_d8$1_0.VIN.t25 VSS 0.02476f
C2556 6ph_rosc_0.psdiff_0.buff_d8$1_0.VIN.n6 VSS 0.03167f
C2557 6ph_rosc_0.psdiff_0.buff_d8$1_0.VIN.t26 VSS 0.02476f
C2558 6ph_rosc_0.psdiff_0.buff_d8$1_0.VIN.n7 VSS 0.01463f
C2559 6ph_rosc_0.psdiff_0.buff_d8$1_0.VIN.t10 VSS 0.02242f
C2560 6ph_rosc_0.psdiff_0.buff_d8$1_0.VIN.t7 VSS 0.02504f
C2561 6ph_rosc_0.psdiff_0.buff_d8$1_0.VIN.t3 VSS 0.02476f
C2562 6ph_rosc_0.psdiff_0.buff_d8$1_0.VIN.n8 VSS 0.03804f
C2563 6ph_rosc_0.psdiff_0.buff_d8$1_0.VIN.t1 VSS 0.02504f
C2564 6ph_rosc_0.psdiff_0.buff_d8$1_0.VIN.t6 VSS 0.02476f
C2565 6ph_rosc_0.psdiff_0.buff_d8$1_0.VIN.n9 VSS 0.03872f
C2566 6ph_rosc_0.psdiff_0.buff_d8$1_0.VIN.t13 VSS 0.02476f
C2567 6ph_rosc_0.psdiff_0.buff_d8$1_0.VIN.n10 VSS 0.02168f
C2568 6ph_rosc_0.psdiff_0.buff_d8$1_0.VIN.t4 VSS 0.02504f
C2569 6ph_rosc_0.psdiff_0.buff_d8$1_0.VIN.t8 VSS 0.02476f
C2570 6ph_rosc_0.psdiff_0.buff_d8$1_0.VIN.n11 VSS 0.03872f
C2571 6ph_rosc_0.psdiff_0.buff_d8$1_0.VIN.t12 VSS 0.02476f
C2572 6ph_rosc_0.psdiff_0.buff_d8$1_0.VIN.n12 VSS 0.02168f
C2573 6ph_rosc_0.psdiff_0.buff_d8$1_0.VIN.t2 VSS 0.02504f
C2574 6ph_rosc_0.psdiff_0.buff_d8$1_0.VIN.t5 VSS 0.02476f
C2575 6ph_rosc_0.psdiff_0.buff_d8$1_0.VIN.n13 VSS 0.03872f
C2576 6ph_rosc_0.psdiff_0.buff_d8$1_0.VIN.t16 VSS 0.02476f
C2577 6ph_rosc_0.psdiff_0.buff_d8$1_0.VIN.n14 VSS 0.04427f
C2578 6ph_rosc_0.psdiff_0.buff_d8$1_0.VIN.n15 VSS 0.05236f
C2579 6ph_rosc_0.psdiff_0.buff_d8$1_0.VIN.n16 VSS 0.04622f
C2580 6ph_rosc_0.psdiff_0.buff_d8$1_0.VIN.t9 VSS 0.02504f
C2581 6ph_rosc_0.psdiff_0.buff_d8$1_0.VIN.t0 VSS 0.02476f
C2582 6ph_rosc_0.psdiff_0.buff_d8$1_0.VIN.n17 VSS 0.03872f
C2583 6ph_rosc_0.psdiff_0.buff_d8$1_0.VIN.t15 VSS 0.02476f
C2584 6ph_rosc_0.psdiff_0.buff_d8$1_0.VIN.n18 VSS 0.02168f
C2585 6ph_rosc_0.psdiff_0.buff_d8$1_0.VIN.n19 VSS 0.05155f
C2586 6ph_rosc_0.psdiff_0.buff_d8$1_0.VIN.t14 VSS 0.02476f
C2587 6ph_rosc_0.psdiff_0.buff_d8$1_0.VIN.n20 VSS 0.14936f
C2588 6ph_rosc_0.psdiff_0.buff_d8$1_0.VIN.n21 VSS 0.11155f
C2589 6ph_rosc_0.psdiff_0.buff_d8$1_0.VIN.n22 VSS 0.03402f
C2590 6ph_rosc_0.psdiff_0.buff_d8$1_0.VIN.n23 VSS 0.06198f
C2591 6ph_rosc_0.psdiff_0.buff_d8$1_0.VIN.n24 VSS 0.04622f
C2592 6ph_rosc_0.psdiff_0.buff_d8$1_0.VIN.n25 VSS 0.05236f
C2593 6ph_rosc_0.psdiff_0.buff_d8$1_0.VIN.t24 VSS 0.02476f
C2594 6ph_rosc_0.psdiff_0.buff_d8$1_0.VIN.n26 VSS 0.03722f
C2595 6ph_rosc_0.psdiff_0.buff_d8$1_0.VIN.t28 VSS 0.02476f
C2596 6ph_rosc_0.psdiff_0.buff_d8$1_0.VIN.n27 VSS 0.01766f
C2597 6ph_rosc_0.psdiff_0.buff_d8$1_0.VIN.t27 VSS 0.02476f
C2598 6ph_rosc_0.psdiff_0.buff_d8$1_0.VIN.n28 VSS 0.15048f
C2599 6ph_rosc_0.psdiff_0.buff_d8$1_0.VIN.n29 VSS 0.1415f
C2600 6ph_rosc_0.PH0.t6 VSS 0.01527f
C2601 6ph_rosc_0.PH0.t0 VSS 0.01527f
C2602 6ph_rosc_0.PH0.n0 VSS 0.00594f
C2603 6ph_rosc_0.PH0.n1 VSS 0.03618f
C2604 6ph_rosc_0.PH0.n2 VSS 0.0248f
C2605 6ph_rosc_0.PH0.t7 VSS 0.01527f
C2606 6ph_rosc_0.PH0.t2 VSS 0.01527f
C2607 6ph_rosc_0.PH0.n3 VSS 0.00594f
C2608 6ph_rosc_0.PH0.n4 VSS 0.03618f
C2609 6ph_rosc_0.PH0.n5 VSS 0.02808f
C2610 6ph_rosc_0.PH0.n6 VSS 0.08764f
C2611 6ph_rosc_0.PH0.t9 VSS 0.01545f
C2612 6ph_rosc_0.PH0.n7 VSS 0.00804f
C2613 6ph_rosc_0.PH0.t8 VSS 0.01527f
C2614 6ph_rosc_0.PH0.n8 VSS 0.003f
C2615 6ph_rosc_0.PH0.n9 VSS 0.00729f
C2616 6ph_rosc_0.PH0.t11 VSS 0.03455f
C2617 6ph_rosc_0.PH0.n10 VSS 0.00371f
C2618 6ph_rosc_0.PH0.n11 VSS 0.07887f
C2619 6ph_rosc_0.PH0.t13 VSS 0.03455f
C2620 6ph_rosc_0.PH0.n12 VSS 0.05171f
C2621 6ph_rosc_0.PH0.t12 VSS 0.11384f
C2622 6ph_rosc_0.PH0.n13 VSS 0.01528f
C2623 6ph_rosc_0.PH0.t14 VSS 0.11384f
C2624 6ph_rosc_0.PH0.n14 VSS 0.00681f
C2625 6ph_rosc_0.PH0.n15 VSS 0.08415f
C2626 6ph_rosc_0.PH0.n16 VSS 2.4199f
C2627 6ph_rosc_0.PH0.t10 VSS 0.801f
C2628 6ph_rosc_0.PH0.n17 VSS 0.16127f
C2629 6ph_rosc_0.PH0.t4 VSS 0.01527f
C2630 6ph_rosc_0.PH0.t1 VSS 0.01527f
C2631 6ph_rosc_0.PH0.n18 VSS 0.00594f
C2632 6ph_rosc_0.PH0.n19 VSS 0.03618f
C2633 6ph_rosc_0.PH0.n20 VSS 0.0248f
C2634 6ph_rosc_0.PH0.n21 VSS 0.14313f
C2635 6ph_rosc_0.PH0.n22 VSS 0.05172f
C2636 6ph_rosc_0.PH0.t5 VSS 0.01527f
C2637 6ph_rosc_0.PH0.n23 VSS 0.0248f
C2638 6ph_rosc_0.PH0.n24 VSS 0.03618f
C2639 6ph_rosc_0.PH0.t3 VSS 0.01527f
C2640 6ph_rosc_0.PH0.n25 VSS 0.00594f
C2641 6ph_rosc_0.PH1.t4 VSS 0.02459f
C2642 6ph_rosc_0.PH1.t2 VSS 0.02459f
C2643 6ph_rosc_0.PH1.n0 VSS 0.00957f
C2644 6ph_rosc_0.PH1.n1 VSS 0.05829f
C2645 6ph_rosc_0.PH1.n2 VSS 0.03995f
C2646 6ph_rosc_0.PH1.t7 VSS 0.02459f
C2647 6ph_rosc_0.PH1.t0 VSS 0.02459f
C2648 6ph_rosc_0.PH1.n3 VSS 0.00957f
C2649 6ph_rosc_0.PH1.n4 VSS 0.05829f
C2650 6ph_rosc_0.PH1.n5 VSS 0.03995f
C2651 6ph_rosc_0.PH1.t5 VSS 0.02459f
C2652 6ph_rosc_0.PH1.t3 VSS 0.02459f
C2653 6ph_rosc_0.PH1.n6 VSS 0.00957f
C2654 6ph_rosc_0.PH1.n7 VSS 0.05829f
C2655 6ph_rosc_0.PH1.n8 VSS 0.04524f
C2656 6ph_rosc_0.PH1.n9 VSS 0.14118f
C2657 6ph_rosc_0.PH1.n10 VSS 0.0801f
C2658 6ph_rosc_0.PH1.t9 VSS 0.02459f
C2659 6ph_rosc_0.PH1.t8 VSS 0.02459f
C2660 6ph_rosc_0.PH1.n11 VSS 0.00957f
C2661 6ph_rosc_0.PH1.n12 VSS 0.05829f
C2662 6ph_rosc_0.PH1.n13 VSS 0.04468f
C2663 6ph_rosc_0.PH1.t14 VSS 0.05565f
C2664 6ph_rosc_0.PH1.n14 VSS 0.0113f
C2665 6ph_rosc_0.PH1.n15 VSS 0.12665f
C2666 6ph_rosc_0.PH1.t13 VSS 0.05565f
C2667 6ph_rosc_0.PH1.n16 VSS 0.0833f
C2668 6ph_rosc_0.PH1.t11 VSS 0.18339f
C2669 6ph_rosc_0.PH1.n17 VSS 0.02461f
C2670 6ph_rosc_0.PH1.t12 VSS 0.18339f
C2671 6ph_rosc_0.PH1.n18 VSS 0.01097f
C2672 6ph_rosc_0.PH1.n19 VSS 0.13557f
C2673 6ph_rosc_0.PH1.n20 VSS 8.68792f
C2674 6ph_rosc_0.PH1.t10 VSS 1.29037f
C2675 6ph_rosc_0.PH1.n21 VSS 0.00382f
C2676 6ph_rosc_0.PH1.n22 VSS 0.87885f
C2677 6ph_rosc_0.PH1.n23 VSS 0.82879f
C2678 6ph_rosc_0.PH1.t6 VSS 0.02459f
C2679 6ph_rosc_0.PH1.n24 VSS 0.04003f
C2680 6ph_rosc_0.PH1.n25 VSS 0.05829f
C2681 6ph_rosc_0.PH1.t1 VSS 0.02459f
C2682 6ph_rosc_0.PH1.n26 VSS 0.00957f
C2683 6to4_0.buff_PI_d32_0.inv_PI_d16$1_0.VIN.t41 VSS 0.04302f
C2684 6to4_0.buff_PI_d32_0.inv_PI_d16$1_0.VIN.t51 VSS 0.31922f
C2685 6to4_0.buff_PI_d32_0.inv_PI_d16$1_0.VIN.n0 VSS 0.01909f
C2686 6to4_0.buff_PI_d32_0.inv_PI_d16$1_0.VIN.n1 VSS 0.1691f
C2687 6to4_0.buff_PI_d32_0.inv_PI_d16$1_0.VIN.t48 VSS 0.31922f
C2688 6to4_0.buff_PI_d32_0.inv_PI_d16$1_0.VIN.n2 VSS 0.01909f
C2689 6to4_0.buff_PI_d32_0.inv_PI_d16$1_0.VIN.n3 VSS 0.15175f
C2690 6to4_0.buff_PI_d32_0.inv_PI_d16$1_0.VIN.t55 VSS 0.31922f
C2691 6to4_0.buff_PI_d32_0.inv_PI_d16$1_0.VIN.n4 VSS 0.01909f
C2692 6to4_0.buff_PI_d32_0.inv_PI_d16$1_0.VIN.n5 VSS 0.15175f
C2693 6to4_0.buff_PI_d32_0.inv_PI_d16$1_0.VIN.t53 VSS 0.31922f
C2694 6to4_0.buff_PI_d32_0.inv_PI_d16$1_0.VIN.n6 VSS 0.04284f
C2695 6to4_0.buff_PI_d32_0.inv_PI_d16$1_0.VIN.t59 VSS 0.31922f
C2696 6to4_0.buff_PI_d32_0.inv_PI_d16$1_0.VIN.n7 VSS 0.01909f
C2697 6to4_0.buff_PI_d32_0.inv_PI_d16$1_0.VIN.n8 VSS 0.26413f
C2698 6to4_0.buff_PI_d32_0.inv_PI_d16$1_0.VIN.t56 VSS 0.31922f
C2699 6to4_0.buff_PI_d32_0.inv_PI_d16$1_0.VIN.n9 VSS 0.04284f
C2700 6to4_0.buff_PI_d32_0.inv_PI_d16$1_0.VIN.t52 VSS 0.31922f
C2701 6to4_0.buff_PI_d32_0.inv_PI_d16$1_0.VIN.n10 VSS 0.01909f
C2702 6to4_0.buff_PI_d32_0.inv_PI_d16$1_0.VIN.n11 VSS 0.26413f
C2703 6to4_0.buff_PI_d32_0.inv_PI_d16$1_0.VIN.t57 VSS 0.31922f
C2704 6to4_0.buff_PI_d32_0.inv_PI_d16$1_0.VIN.n12 VSS 0.02603f
C2705 6to4_0.buff_PI_d32_0.inv_PI_d16$1_0.VIN.n13 VSS 0.15156f
C2706 6to4_0.buff_PI_d32_0.inv_PI_d16$1_0.VIN.n14 VSS 0.39234f
C2707 6to4_0.buff_PI_d32_0.inv_PI_d16$1_0.VIN.n15 VSS 0.39234f
C2708 6to4_0.buff_PI_d32_0.inv_PI_d16$1_0.VIN.t58 VSS 0.31922f
C2709 6to4_0.buff_PI_d32_0.inv_PI_d16$1_0.VIN.n16 VSS 0.02603f
C2710 6to4_0.buff_PI_d32_0.inv_PI_d16$1_0.VIN.n17 VSS 0.15156f
C2711 6to4_0.buff_PI_d32_0.inv_PI_d16$1_0.VIN.t50 VSS 0.31922f
C2712 6to4_0.buff_PI_d32_0.inv_PI_d16$1_0.VIN.n18 VSS 0.01909f
C2713 6to4_0.buff_PI_d32_0.inv_PI_d16$1_0.VIN.n19 VSS 0.15175f
C2714 6to4_0.buff_PI_d32_0.inv_PI_d16$1_0.VIN.t60 VSS 0.31922f
C2715 6to4_0.buff_PI_d32_0.inv_PI_d16$1_0.VIN.n20 VSS 0.02603f
C2716 6to4_0.buff_PI_d32_0.inv_PI_d16$1_0.VIN.n21 VSS 0.15156f
C2717 6to4_0.buff_PI_d32_0.inv_PI_d16$1_0.VIN.n22 VSS 0.39234f
C2718 6to4_0.buff_PI_d32_0.inv_PI_d16$1_0.VIN.n23 VSS 0.39234f
C2719 6to4_0.buff_PI_d32_0.inv_PI_d16$1_0.VIN.t49 VSS 0.31922f
C2720 6to4_0.buff_PI_d32_0.inv_PI_d16$1_0.VIN.n24 VSS 0.02603f
C2721 6to4_0.buff_PI_d32_0.inv_PI_d16$1_0.VIN.n25 VSS 0.15156f
C2722 6to4_0.buff_PI_d32_0.inv_PI_d16$1_0.VIN.t61 VSS 0.31922f
C2723 6to4_0.buff_PI_d32_0.inv_PI_d16$1_0.VIN.n26 VSS 0.01909f
C2724 6to4_0.buff_PI_d32_0.inv_PI_d16$1_0.VIN.n27 VSS 0.15175f
C2725 6to4_0.buff_PI_d32_0.inv_PI_d16$1_0.VIN.t62 VSS 0.31922f
C2726 6to4_0.buff_PI_d32_0.inv_PI_d16$1_0.VIN.n28 VSS 0.02603f
C2727 6to4_0.buff_PI_d32_0.inv_PI_d16$1_0.VIN.n29 VSS 0.15156f
C2728 6to4_0.buff_PI_d32_0.inv_PI_d16$1_0.VIN.n30 VSS 0.11467f
C2729 6to4_0.buff_PI_d32_0.inv_PI_d16$1_0.VIN.n31 VSS 0.1116f
C2730 6to4_0.buff_PI_d32_0.inv_PI_d16$1_0.VIN.t54 VSS 0.31922f
C2731 6to4_0.buff_PI_d32_0.inv_PI_d16$1_0.VIN.n32 VSS 0.02603f
C2732 6to4_0.buff_PI_d32_0.inv_PI_d16$1_0.VIN.n33 VSS 0.15156f
C2733 6to4_0.buff_PI_d32_0.inv_PI_d16$1_0.VIN.t63 VSS 0.31922f
C2734 6to4_0.buff_PI_d32_0.inv_PI_d16$1_0.VIN.n34 VSS 0.01909f
C2735 6to4_0.buff_PI_d32_0.inv_PI_d16$1_0.VIN.n35 VSS 0.16967f
C2736 6to4_0.buff_PI_d32_0.inv_PI_d16$1_0.VIN.t10 VSS 0.04302f
C2737 6to4_0.buff_PI_d32_0.inv_PI_d16$1_0.VIN.t9 VSS 0.04403f
C2738 6to4_0.buff_PI_d32_0.inv_PI_d16$1_0.VIN.t11 VSS 0.03897f
C2739 6to4_0.buff_PI_d32_0.inv_PI_d16$1_0.VIN.t22 VSS 0.03897f
C2740 6to4_0.buff_PI_d32_0.inv_PI_d16$1_0.VIN.t21 VSS 0.04403f
C2741 6to4_0.buff_PI_d32_0.inv_PI_d16$1_0.VIN.t23 VSS 0.04302f
C2742 6to4_0.buff_PI_d32_0.inv_PI_d16$1_0.VIN.t43 VSS 0.04302f
C2743 6to4_0.buff_PI_d32_0.inv_PI_d16$1_0.VIN.t42 VSS 0.04403f
C2744 6to4_0.buff_PI_d32_0.inv_PI_d16$1_0.VIN.t44 VSS 0.03897f
C2745 6to4_0.buff_PI_d32_0.inv_PI_d16$1_0.VIN.t8 VSS 0.03897f
C2746 6to4_0.buff_PI_d32_0.inv_PI_d16$1_0.VIN.t6 VSS 0.04403f
C2747 6to4_0.buff_PI_d32_0.inv_PI_d16$1_0.VIN.t7 VSS 0.04302f
C2748 6to4_0.buff_PI_d32_0.inv_PI_d16$1_0.VIN.t16 VSS 0.04302f
C2749 6to4_0.buff_PI_d32_0.inv_PI_d16$1_0.VIN.t15 VSS 0.04403f
C2750 6to4_0.buff_PI_d32_0.inv_PI_d16$1_0.VIN.t17 VSS 0.03897f
C2751 6to4_0.buff_PI_d32_0.inv_PI_d16$1_0.VIN.t37 VSS 0.03897f
C2752 6to4_0.buff_PI_d32_0.inv_PI_d16$1_0.VIN.t36 VSS 0.04403f
C2753 6to4_0.buff_PI_d32_0.inv_PI_d16$1_0.VIN.t38 VSS 0.04302f
C2754 6to4_0.buff_PI_d32_0.inv_PI_d16$1_0.VIN.t31 VSS 0.04302f
C2755 6to4_0.buff_PI_d32_0.inv_PI_d16$1_0.VIN.t30 VSS 0.04403f
C2756 6to4_0.buff_PI_d32_0.inv_PI_d16$1_0.VIN.t32 VSS 0.03897f
C2757 6to4_0.buff_PI_d32_0.inv_PI_d16$1_0.VIN.t5 VSS 0.03897f
C2758 6to4_0.buff_PI_d32_0.inv_PI_d16$1_0.VIN.t3 VSS 0.04403f
C2759 6to4_0.buff_PI_d32_0.inv_PI_d16$1_0.VIN.t4 VSS 0.0439f
C2760 6to4_0.buff_PI_d32_0.inv_PI_d16$1_0.VIN.n36 VSS 0.08177f
C2761 6to4_0.buff_PI_d32_0.inv_PI_d16$1_0.VIN.n37 VSS 0.0729f
C2762 6to4_0.buff_PI_d32_0.inv_PI_d16$1_0.VIN.n38 VSS 0.05686f
C2763 6to4_0.buff_PI_d32_0.inv_PI_d16$1_0.VIN.n39 VSS 0.08023f
C2764 6to4_0.buff_PI_d32_0.inv_PI_d16$1_0.VIN.n40 VSS 0.10529f
C2765 6to4_0.buff_PI_d32_0.inv_PI_d16$1_0.VIN.n41 VSS 0.10529f
C2766 6to4_0.buff_PI_d32_0.inv_PI_d16$1_0.VIN.n42 VSS 0.08177f
C2767 6to4_0.buff_PI_d32_0.inv_PI_d16$1_0.VIN.n43 VSS 0.0729f
C2768 6to4_0.buff_PI_d32_0.inv_PI_d16$1_0.VIN.n44 VSS 0.05686f
C2769 6to4_0.buff_PI_d32_0.inv_PI_d16$1_0.VIN.n45 VSS 0.08023f
C2770 6to4_0.buff_PI_d32_0.inv_PI_d16$1_0.VIN.n46 VSS 0.09558f
C2771 6to4_0.buff_PI_d32_0.inv_PI_d16$1_0.VIN.n47 VSS 0.10529f
C2772 6to4_0.buff_PI_d32_0.inv_PI_d16$1_0.VIN.n48 VSS 0.08177f
C2773 6to4_0.buff_PI_d32_0.inv_PI_d16$1_0.VIN.n49 VSS 0.0729f
C2774 6to4_0.buff_PI_d32_0.inv_PI_d16$1_0.VIN.n50 VSS 0.05686f
C2775 6to4_0.buff_PI_d32_0.inv_PI_d16$1_0.VIN.n51 VSS 0.08023f
C2776 6to4_0.buff_PI_d32_0.inv_PI_d16$1_0.VIN.n52 VSS 0.10529f
C2777 6to4_0.buff_PI_d32_0.inv_PI_d16$1_0.VIN.n53 VSS 0.10529f
C2778 6to4_0.buff_PI_d32_0.inv_PI_d16$1_0.VIN.n54 VSS 0.08177f
C2779 6to4_0.buff_PI_d32_0.inv_PI_d16$1_0.VIN.n55 VSS 0.0729f
C2780 6to4_0.buff_PI_d32_0.inv_PI_d16$1_0.VIN.n56 VSS 0.05686f
C2781 6to4_0.buff_PI_d32_0.inv_PI_d16$1_0.VIN.n57 VSS 0.08023f
C2782 6to4_0.buff_PI_d32_0.inv_PI_d16$1_0.VIN.n58 VSS 0.12867f
C2783 6to4_0.buff_PI_d32_0.inv_PI_d16$1_0.VIN.n59 VSS 0.11086f
C2784 6to4_0.buff_PI_d32_0.inv_PI_d16$1_0.VIN.n60 VSS 0.15759f
C2785 6to4_0.buff_PI_d32_0.inv_PI_d16$1_0.VIN.n61 VSS 0.12867f
C2786 6to4_0.buff_PI_d32_0.inv_PI_d16$1_0.VIN.t39 VSS 0.04403f
C2787 6to4_0.buff_PI_d32_0.inv_PI_d16$1_0.VIN.t40 VSS 0.03897f
C2788 6to4_0.buff_PI_d32_0.inv_PI_d16$1_0.VIN.t20 VSS 0.03897f
C2789 6to4_0.buff_PI_d32_0.inv_PI_d16$1_0.VIN.t18 VSS 0.04403f
C2790 6to4_0.buff_PI_d32_0.inv_PI_d16$1_0.VIN.t19 VSS 0.04302f
C2791 6to4_0.buff_PI_d32_0.inv_PI_d16$1_0.VIN.t13 VSS 0.04302f
C2792 6to4_0.buff_PI_d32_0.inv_PI_d16$1_0.VIN.t12 VSS 0.04403f
C2793 6to4_0.buff_PI_d32_0.inv_PI_d16$1_0.VIN.t14 VSS 0.03897f
C2794 6to4_0.buff_PI_d32_0.inv_PI_d16$1_0.VIN.t35 VSS 0.03897f
C2795 6to4_0.buff_PI_d32_0.inv_PI_d16$1_0.VIN.t33 VSS 0.04403f
C2796 6to4_0.buff_PI_d32_0.inv_PI_d16$1_0.VIN.t34 VSS 0.04302f
C2797 6to4_0.buff_PI_d32_0.inv_PI_d16$1_0.VIN.t28 VSS 0.04302f
C2798 6to4_0.buff_PI_d32_0.inv_PI_d16$1_0.VIN.t27 VSS 0.04403f
C2799 6to4_0.buff_PI_d32_0.inv_PI_d16$1_0.VIN.t29 VSS 0.03897f
C2800 6to4_0.buff_PI_d32_0.inv_PI_d16$1_0.VIN.t1 VSS 0.03897f
C2801 6to4_0.buff_PI_d32_0.inv_PI_d16$1_0.VIN.t2 VSS 0.04302f
C2802 6to4_0.buff_PI_d32_0.inv_PI_d16$1_0.VIN.t25 VSS 0.04302f
C2803 6to4_0.buff_PI_d32_0.inv_PI_d16$1_0.VIN.t24 VSS 0.04403f
C2804 6to4_0.buff_PI_d32_0.inv_PI_d16$1_0.VIN.t26 VSS 0.03897f
C2805 6to4_0.buff_PI_d32_0.inv_PI_d16$1_0.VIN.t47 VSS 0.03897f
C2806 6to4_0.buff_PI_d32_0.inv_PI_d16$1_0.VIN.t45 VSS 0.04403f
C2807 6to4_0.buff_PI_d32_0.inv_PI_d16$1_0.VIN.t46 VSS 0.0439f
C2808 6to4_0.buff_PI_d32_0.inv_PI_d16$1_0.VIN.n62 VSS 0.08177f
C2809 6to4_0.buff_PI_d32_0.inv_PI_d16$1_0.VIN.n63 VSS 0.0729f
C2810 6to4_0.buff_PI_d32_0.inv_PI_d16$1_0.VIN.n64 VSS 0.05686f
C2811 6to4_0.buff_PI_d32_0.inv_PI_d16$1_0.VIN.n65 VSS 0.08023f
C2812 6to4_0.buff_PI_d32_0.inv_PI_d16$1_0.VIN.n66 VSS 0.10529f
C2813 6to4_0.buff_PI_d32_0.inv_PI_d16$1_0.VIN.n67 VSS 0.10529f
C2814 6to4_0.buff_PI_d32_0.inv_PI_d16$1_0.VIN.t0 VSS 0.04403f
C2815 6to4_0.buff_PI_d32_0.inv_PI_d16$1_0.VIN.n68 VSS 0.08177f
C2816 6to4_0.buff_PI_d32_0.inv_PI_d16$1_0.VIN.n69 VSS 0.0729f
C2817 6to4_0.buff_PI_d32_0.inv_PI_d16$1_0.VIN.n70 VSS 0.05686f
C2818 6to4_0.buff_PI_d32_0.inv_PI_d16$1_0.VIN.n71 VSS 0.08023f
C2819 6to4_0.buff_PI_d32_0.inv_PI_d16$1_0.VIN.n72 VSS 0.09558f
C2820 6to4_0.buff_PI_d32_0.inv_PI_d16$1_0.VIN.n73 VSS 0.10529f
C2821 6to4_0.buff_PI_d32_0.inv_PI_d16$1_0.VIN.n74 VSS 0.08177f
C2822 6to4_0.buff_PI_d32_0.inv_PI_d16$1_0.VIN.n75 VSS 0.0729f
C2823 6to4_0.buff_PI_d32_0.inv_PI_d16$1_0.VIN.n76 VSS 0.05686f
C2824 6to4_0.buff_PI_d32_0.inv_PI_d16$1_0.VIN.n77 VSS 0.08023f
C2825 6to4_0.buff_PI_d32_0.inv_PI_d16$1_0.VIN.n78 VSS 0.10529f
C2826 6to4_0.buff_PI_d32_0.inv_PI_d16$1_0.VIN.n79 VSS 0.10529f
C2827 6to4_0.buff_PI_d32_0.inv_PI_d16$1_0.VIN.n80 VSS 0.08177f
C2828 6to4_0.buff_PI_d32_0.inv_PI_d16$1_0.VIN.n81 VSS 0.0729f
C2829 6to4_0.buff_PI_d32_0.inv_PI_d16$1_0.VIN.n82 VSS 0.05686f
C2830 6to4_0.buff_PI_d32_0.inv_PI_d16$1_0.VIN.n83 VSS 0.08023f
C2831 6to4_0.buff_PI_d32_2.inv_PI_d16$1_0.VIN.t19 VSS 0.04302f
C2832 6to4_0.buff_PI_d32_2.inv_PI_d16$1_0.VIN.t53 VSS 0.31922f
C2833 6to4_0.buff_PI_d32_2.inv_PI_d16$1_0.VIN.n0 VSS 0.01909f
C2834 6to4_0.buff_PI_d32_2.inv_PI_d16$1_0.VIN.n1 VSS 0.1691f
C2835 6to4_0.buff_PI_d32_2.inv_PI_d16$1_0.VIN.t52 VSS 0.31922f
C2836 6to4_0.buff_PI_d32_2.inv_PI_d16$1_0.VIN.n2 VSS 0.01909f
C2837 6to4_0.buff_PI_d32_2.inv_PI_d16$1_0.VIN.n3 VSS 0.15175f
C2838 6to4_0.buff_PI_d32_2.inv_PI_d16$1_0.VIN.t63 VSS 0.31922f
C2839 6to4_0.buff_PI_d32_2.inv_PI_d16$1_0.VIN.n4 VSS 0.01909f
C2840 6to4_0.buff_PI_d32_2.inv_PI_d16$1_0.VIN.n5 VSS 0.15175f
C2841 6to4_0.buff_PI_d32_2.inv_PI_d16$1_0.VIN.t59 VSS 0.31922f
C2842 6to4_0.buff_PI_d32_2.inv_PI_d16$1_0.VIN.n6 VSS 0.04284f
C2843 6to4_0.buff_PI_d32_2.inv_PI_d16$1_0.VIN.t55 VSS 0.31922f
C2844 6to4_0.buff_PI_d32_2.inv_PI_d16$1_0.VIN.n7 VSS 0.01909f
C2845 6to4_0.buff_PI_d32_2.inv_PI_d16$1_0.VIN.n8 VSS 0.26413f
C2846 6to4_0.buff_PI_d32_2.inv_PI_d16$1_0.VIN.t58 VSS 0.31922f
C2847 6to4_0.buff_PI_d32_2.inv_PI_d16$1_0.VIN.n9 VSS 0.04284f
C2848 6to4_0.buff_PI_d32_2.inv_PI_d16$1_0.VIN.t49 VSS 0.31922f
C2849 6to4_0.buff_PI_d32_2.inv_PI_d16$1_0.VIN.n10 VSS 0.01909f
C2850 6to4_0.buff_PI_d32_2.inv_PI_d16$1_0.VIN.n11 VSS 0.26413f
C2851 6to4_0.buff_PI_d32_2.inv_PI_d16$1_0.VIN.t48 VSS 0.31922f
C2852 6to4_0.buff_PI_d32_2.inv_PI_d16$1_0.VIN.n12 VSS 0.02603f
C2853 6to4_0.buff_PI_d32_2.inv_PI_d16$1_0.VIN.n13 VSS 0.15156f
C2854 6to4_0.buff_PI_d32_2.inv_PI_d16$1_0.VIN.n14 VSS 0.39234f
C2855 6to4_0.buff_PI_d32_2.inv_PI_d16$1_0.VIN.n15 VSS 0.39234f
C2856 6to4_0.buff_PI_d32_2.inv_PI_d16$1_0.VIN.t62 VSS 0.31922f
C2857 6to4_0.buff_PI_d32_2.inv_PI_d16$1_0.VIN.n16 VSS 0.02603f
C2858 6to4_0.buff_PI_d32_2.inv_PI_d16$1_0.VIN.n17 VSS 0.15156f
C2859 6to4_0.buff_PI_d32_2.inv_PI_d16$1_0.VIN.t57 VSS 0.31922f
C2860 6to4_0.buff_PI_d32_2.inv_PI_d16$1_0.VIN.n18 VSS 0.01909f
C2861 6to4_0.buff_PI_d32_2.inv_PI_d16$1_0.VIN.n19 VSS 0.15175f
C2862 6to4_0.buff_PI_d32_2.inv_PI_d16$1_0.VIN.t56 VSS 0.31922f
C2863 6to4_0.buff_PI_d32_2.inv_PI_d16$1_0.VIN.n20 VSS 0.02603f
C2864 6to4_0.buff_PI_d32_2.inv_PI_d16$1_0.VIN.n21 VSS 0.15156f
C2865 6to4_0.buff_PI_d32_2.inv_PI_d16$1_0.VIN.n22 VSS 0.39234f
C2866 6to4_0.buff_PI_d32_2.inv_PI_d16$1_0.VIN.n23 VSS 0.39234f
C2867 6to4_0.buff_PI_d32_2.inv_PI_d16$1_0.VIN.t54 VSS 0.31922f
C2868 6to4_0.buff_PI_d32_2.inv_PI_d16$1_0.VIN.n24 VSS 0.02603f
C2869 6to4_0.buff_PI_d32_2.inv_PI_d16$1_0.VIN.n25 VSS 0.15156f
C2870 6to4_0.buff_PI_d32_2.inv_PI_d16$1_0.VIN.t60 VSS 0.31922f
C2871 6to4_0.buff_PI_d32_2.inv_PI_d16$1_0.VIN.n26 VSS 0.01909f
C2872 6to4_0.buff_PI_d32_2.inv_PI_d16$1_0.VIN.n27 VSS 0.15175f
C2873 6to4_0.buff_PI_d32_2.inv_PI_d16$1_0.VIN.t50 VSS 0.31922f
C2874 6to4_0.buff_PI_d32_2.inv_PI_d16$1_0.VIN.n28 VSS 0.02603f
C2875 6to4_0.buff_PI_d32_2.inv_PI_d16$1_0.VIN.n29 VSS 0.15156f
C2876 6to4_0.buff_PI_d32_2.inv_PI_d16$1_0.VIN.n30 VSS 0.11467f
C2877 6to4_0.buff_PI_d32_2.inv_PI_d16$1_0.VIN.n31 VSS 0.1116f
C2878 6to4_0.buff_PI_d32_2.inv_PI_d16$1_0.VIN.t51 VSS 0.31922f
C2879 6to4_0.buff_PI_d32_2.inv_PI_d16$1_0.VIN.n32 VSS 0.02603f
C2880 6to4_0.buff_PI_d32_2.inv_PI_d16$1_0.VIN.n33 VSS 0.15156f
C2881 6to4_0.buff_PI_d32_2.inv_PI_d16$1_0.VIN.t61 VSS 0.31922f
C2882 6to4_0.buff_PI_d32_2.inv_PI_d16$1_0.VIN.n34 VSS 0.01909f
C2883 6to4_0.buff_PI_d32_2.inv_PI_d16$1_0.VIN.n35 VSS 0.16967f
C2884 6to4_0.buff_PI_d32_2.inv_PI_d16$1_0.VIN.t38 VSS 0.04302f
C2885 6to4_0.buff_PI_d32_2.inv_PI_d16$1_0.VIN.t5 VSS 0.04403f
C2886 6to4_0.buff_PI_d32_2.inv_PI_d16$1_0.VIN.t44 VSS 0.03897f
C2887 6to4_0.buff_PI_d32_2.inv_PI_d16$1_0.VIN.t20 VSS 0.03897f
C2888 6to4_0.buff_PI_d32_2.inv_PI_d16$1_0.VIN.t9 VSS 0.04403f
C2889 6to4_0.buff_PI_d32_2.inv_PI_d16$1_0.VIN.t41 VSS 0.04302f
C2890 6to4_0.buff_PI_d32_2.inv_PI_d16$1_0.VIN.t22 VSS 0.04302f
C2891 6to4_0.buff_PI_d32_2.inv_PI_d16$1_0.VIN.t10 VSS 0.04403f
C2892 6to4_0.buff_PI_d32_2.inv_PI_d16$1_0.VIN.t23 VSS 0.03897f
C2893 6to4_0.buff_PI_d32_2.inv_PI_d16$1_0.VIN.t39 VSS 0.03897f
C2894 6to4_0.buff_PI_d32_2.inv_PI_d16$1_0.VIN.t6 VSS 0.04403f
C2895 6to4_0.buff_PI_d32_2.inv_PI_d16$1_0.VIN.t24 VSS 0.04302f
C2896 6to4_0.buff_PI_d32_2.inv_PI_d16$1_0.VIN.t25 VSS 0.04302f
C2897 6to4_0.buff_PI_d32_2.inv_PI_d16$1_0.VIN.t4 VSS 0.04403f
C2898 6to4_0.buff_PI_d32_2.inv_PI_d16$1_0.VIN.t35 VSS 0.03897f
C2899 6to4_0.buff_PI_d32_2.inv_PI_d16$1_0.VIN.t47 VSS 0.03897f
C2900 6to4_0.buff_PI_d32_2.inv_PI_d16$1_0.VIN.t15 VSS 0.04403f
C2901 6to4_0.buff_PI_d32_2.inv_PI_d16$1_0.VIN.t26 VSS 0.04302f
C2902 6to4_0.buff_PI_d32_2.inv_PI_d16$1_0.VIN.t30 VSS 0.04302f
C2903 6to4_0.buff_PI_d32_2.inv_PI_d16$1_0.VIN.t0 VSS 0.04403f
C2904 6to4_0.buff_PI_d32_2.inv_PI_d16$1_0.VIN.t40 VSS 0.03897f
C2905 6to4_0.buff_PI_d32_2.inv_PI_d16$1_0.VIN.t46 VSS 0.03897f
C2906 6to4_0.buff_PI_d32_2.inv_PI_d16$1_0.VIN.t1 VSS 0.04403f
C2907 6to4_0.buff_PI_d32_2.inv_PI_d16$1_0.VIN.t32 VSS 0.0439f
C2908 6to4_0.buff_PI_d32_2.inv_PI_d16$1_0.VIN.n36 VSS 0.08177f
C2909 6to4_0.buff_PI_d32_2.inv_PI_d16$1_0.VIN.n37 VSS 0.0729f
C2910 6to4_0.buff_PI_d32_2.inv_PI_d16$1_0.VIN.n38 VSS 0.05686f
C2911 6to4_0.buff_PI_d32_2.inv_PI_d16$1_0.VIN.n39 VSS 0.08023f
C2912 6to4_0.buff_PI_d32_2.inv_PI_d16$1_0.VIN.n40 VSS 0.10529f
C2913 6to4_0.buff_PI_d32_2.inv_PI_d16$1_0.VIN.n41 VSS 0.10529f
C2914 6to4_0.buff_PI_d32_2.inv_PI_d16$1_0.VIN.n42 VSS 0.08177f
C2915 6to4_0.buff_PI_d32_2.inv_PI_d16$1_0.VIN.n43 VSS 0.0729f
C2916 6to4_0.buff_PI_d32_2.inv_PI_d16$1_0.VIN.n44 VSS 0.05686f
C2917 6to4_0.buff_PI_d32_2.inv_PI_d16$1_0.VIN.n45 VSS 0.08023f
C2918 6to4_0.buff_PI_d32_2.inv_PI_d16$1_0.VIN.n46 VSS 0.09558f
C2919 6to4_0.buff_PI_d32_2.inv_PI_d16$1_0.VIN.n47 VSS 0.10529f
C2920 6to4_0.buff_PI_d32_2.inv_PI_d16$1_0.VIN.n48 VSS 0.08177f
C2921 6to4_0.buff_PI_d32_2.inv_PI_d16$1_0.VIN.n49 VSS 0.0729f
C2922 6to4_0.buff_PI_d32_2.inv_PI_d16$1_0.VIN.n50 VSS 0.05686f
C2923 6to4_0.buff_PI_d32_2.inv_PI_d16$1_0.VIN.n51 VSS 0.08023f
C2924 6to4_0.buff_PI_d32_2.inv_PI_d16$1_0.VIN.n52 VSS 0.10529f
C2925 6to4_0.buff_PI_d32_2.inv_PI_d16$1_0.VIN.n53 VSS 0.10529f
C2926 6to4_0.buff_PI_d32_2.inv_PI_d16$1_0.VIN.n54 VSS 0.08177f
C2927 6to4_0.buff_PI_d32_2.inv_PI_d16$1_0.VIN.n55 VSS 0.0729f
C2928 6to4_0.buff_PI_d32_2.inv_PI_d16$1_0.VIN.n56 VSS 0.05686f
C2929 6to4_0.buff_PI_d32_2.inv_PI_d16$1_0.VIN.n57 VSS 0.08023f
C2930 6to4_0.buff_PI_d32_2.inv_PI_d16$1_0.VIN.n58 VSS 0.12867f
C2931 6to4_0.buff_PI_d32_2.inv_PI_d16$1_0.VIN.n59 VSS 0.11086f
C2932 6to4_0.buff_PI_d32_2.inv_PI_d16$1_0.VIN.n60 VSS 0.15759f
C2933 6to4_0.buff_PI_d32_2.inv_PI_d16$1_0.VIN.n61 VSS 0.12867f
C2934 6to4_0.buff_PI_d32_2.inv_PI_d16$1_0.VIN.t11 VSS 0.04403f
C2935 6to4_0.buff_PI_d32_2.inv_PI_d16$1_0.VIN.t16 VSS 0.03897f
C2936 6to4_0.buff_PI_d32_2.inv_PI_d16$1_0.VIN.t29 VSS 0.03897f
C2937 6to4_0.buff_PI_d32_2.inv_PI_d16$1_0.VIN.t13 VSS 0.04403f
C2938 6to4_0.buff_PI_d32_2.inv_PI_d16$1_0.VIN.t17 VSS 0.04302f
C2939 6to4_0.buff_PI_d32_2.inv_PI_d16$1_0.VIN.t31 VSS 0.04302f
C2940 6to4_0.buff_PI_d32_2.inv_PI_d16$1_0.VIN.t33 VSS 0.03897f
C2941 6to4_0.buff_PI_d32_2.inv_PI_d16$1_0.VIN.t43 VSS 0.03897f
C2942 6to4_0.buff_PI_d32_2.inv_PI_d16$1_0.VIN.t12 VSS 0.04403f
C2943 6to4_0.buff_PI_d32_2.inv_PI_d16$1_0.VIN.t34 VSS 0.04302f
C2944 6to4_0.buff_PI_d32_2.inv_PI_d16$1_0.VIN.t36 VSS 0.04302f
C2945 6to4_0.buff_PI_d32_2.inv_PI_d16$1_0.VIN.t2 VSS 0.04403f
C2946 6to4_0.buff_PI_d32_2.inv_PI_d16$1_0.VIN.t42 VSS 0.03897f
C2947 6to4_0.buff_PI_d32_2.inv_PI_d16$1_0.VIN.t27 VSS 0.03897f
C2948 6to4_0.buff_PI_d32_2.inv_PI_d16$1_0.VIN.t3 VSS 0.04403f
C2949 6to4_0.buff_PI_d32_2.inv_PI_d16$1_0.VIN.t37 VSS 0.04302f
C2950 6to4_0.buff_PI_d32_2.inv_PI_d16$1_0.VIN.t28 VSS 0.04302f
C2951 6to4_0.buff_PI_d32_2.inv_PI_d16$1_0.VIN.t7 VSS 0.04403f
C2952 6to4_0.buff_PI_d32_2.inv_PI_d16$1_0.VIN.t45 VSS 0.03897f
C2953 6to4_0.buff_PI_d32_2.inv_PI_d16$1_0.VIN.t21 VSS 0.03897f
C2954 6to4_0.buff_PI_d32_2.inv_PI_d16$1_0.VIN.t8 VSS 0.04403f
C2955 6to4_0.buff_PI_d32_2.inv_PI_d16$1_0.VIN.t18 VSS 0.0439f
C2956 6to4_0.buff_PI_d32_2.inv_PI_d16$1_0.VIN.n62 VSS 0.08177f
C2957 6to4_0.buff_PI_d32_2.inv_PI_d16$1_0.VIN.n63 VSS 0.0729f
C2958 6to4_0.buff_PI_d32_2.inv_PI_d16$1_0.VIN.n64 VSS 0.05686f
C2959 6to4_0.buff_PI_d32_2.inv_PI_d16$1_0.VIN.n65 VSS 0.08023f
C2960 6to4_0.buff_PI_d32_2.inv_PI_d16$1_0.VIN.n66 VSS 0.10529f
C2961 6to4_0.buff_PI_d32_2.inv_PI_d16$1_0.VIN.n67 VSS 0.10529f
C2962 6to4_0.buff_PI_d32_2.inv_PI_d16$1_0.VIN.n68 VSS 0.08177f
C2963 6to4_0.buff_PI_d32_2.inv_PI_d16$1_0.VIN.n69 VSS 0.0729f
C2964 6to4_0.buff_PI_d32_2.inv_PI_d16$1_0.VIN.n70 VSS 0.05686f
C2965 6to4_0.buff_PI_d32_2.inv_PI_d16$1_0.VIN.n71 VSS 0.08023f
C2966 6to4_0.buff_PI_d32_2.inv_PI_d16$1_0.VIN.n72 VSS 0.09558f
C2967 6to4_0.buff_PI_d32_2.inv_PI_d16$1_0.VIN.n73 VSS 0.10529f
C2968 6to4_0.buff_PI_d32_2.inv_PI_d16$1_0.VIN.n74 VSS 0.08177f
C2969 6to4_0.buff_PI_d32_2.inv_PI_d16$1_0.VIN.n75 VSS 0.0729f
C2970 6to4_0.buff_PI_d32_2.inv_PI_d16$1_0.VIN.n76 VSS 0.05686f
C2971 6to4_0.buff_PI_d32_2.inv_PI_d16$1_0.VIN.t14 VSS 0.04403f
C2972 6to4_0.buff_PI_d32_2.inv_PI_d16$1_0.VIN.n77 VSS 0.08023f
C2973 6to4_0.buff_PI_d32_2.inv_PI_d16$1_0.VIN.n78 VSS 0.10529f
C2974 6to4_0.buff_PI_d32_2.inv_PI_d16$1_0.VIN.n79 VSS 0.10529f
C2975 6to4_0.buff_PI_d32_2.inv_PI_d16$1_0.VIN.n80 VSS 0.08177f
C2976 6to4_0.buff_PI_d32_2.inv_PI_d16$1_0.VIN.n81 VSS 0.0729f
C2977 6to4_0.buff_PI_d32_2.inv_PI_d16$1_0.VIN.n82 VSS 0.05686f
C2978 6to4_0.buff_PI_d32_2.inv_PI_d16$1_0.VIN.n83 VSS 0.08023f
C2979 6to4_0.buff_PI_d32_2.buff_PI_d16$1_0.inv_PI_d8$1_0.VOUT.t12 VSS 0.0351f
C2980 6to4_0.buff_PI_d32_2.buff_PI_d16$1_0.inv_PI_d8$1_0.VOUT.t26 VSS 0.2604f
C2981 6to4_0.buff_PI_d32_2.buff_PI_d16$1_0.inv_PI_d16$1_0.inv_PI_d8$1_1.inv_PI_d4$1_1.inv_PI_d2$1_0.inv_PI$1_1.VIN VSS 0.00566f
C2982 6to4_0.buff_PI_d32_2.buff_PI_d16$1_0.inv_PI_d16$1_0.inv_PI_d8$1_1.inv_PI_d4$1_1.inv_PI_d2$1_0.VIN VSS 0.00708f
C2983 6to4_0.buff_PI_d32_2.buff_PI_d16$1_0.inv_PI_d8$1_0.VOUT.n0 VSS 0.01557f
C2984 6to4_0.buff_PI_d32_2.buff_PI_d16$1_0.inv_PI_d8$1_0.VOUT.n1 VSS 0.12379f
C2985 6to4_0.buff_PI_d32_2.buff_PI_d16$1_0.inv_PI_d8$1_0.VOUT.t36 VSS 0.2604f
C2986 6to4_0.buff_PI_d32_2.buff_PI_d16$1_0.inv_PI_d16$1_0.inv_PI_d8$1_0.inv_PI_d4$1_1.inv_PI_d2$1_1.inv_PI$1_1.VIN VSS 0.00472f
C2987 6to4_0.buff_PI_d32_2.buff_PI_d16$1_0.inv_PI_d16$1_0.inv_PI_d8$1_0.inv_PI_d4$1_1.VIN VSS 0.00566f
C2988 6to4_0.buff_PI_d32_2.buff_PI_d16$1_0.inv_PI_d16$1_0.inv_PI_d8$1_0.inv_PI_d4$1_1.inv_PI_d2$1_1.VIN VSS 0.00236f
C2989 6to4_0.buff_PI_d32_2.buff_PI_d16$1_0.inv_PI_d8$1_0.VOUT.n2 VSS 0.02929f
C2990 6to4_0.buff_PI_d32_2.buff_PI_d16$1_0.inv_PI_d8$1_0.VOUT.t35 VSS 0.2604f
C2991 6to4_0.buff_PI_d32_2.buff_PI_d16$1_0.inv_PI_d16$1_0.inv_PI_d8$1_0.inv_PI_d4$1_1.inv_PI_d2$1_1.inv_PI$1_0.VIN VSS 0.00708f
C2992 6to4_0.buff_PI_d32_2.buff_PI_d16$1_0.inv_PI_d8$1_0.VOUT.n3 VSS 0.02123f
C2993 6to4_0.buff_PI_d32_2.buff_PI_d16$1_0.inv_PI_d8$1_0.VOUT.n4 VSS 0.2153f
C2994 6to4_0.buff_PI_d32_2.buff_PI_d16$1_0.inv_PI_d8$1_0.VOUT.t28 VSS 0.2604f
C2995 6to4_0.buff_PI_d32_2.buff_PI_d16$1_0.inv_PI_d16$1_0.inv_PI_d8$1_0.inv_PI_d4$1_0.inv_PI_d2$1_1.inv_PI$1_1.VIN VSS 0.00472f
C2996 6to4_0.buff_PI_d32_2.buff_PI_d16$1_0.inv_PI_d16$1_0.inv_PI_d8$1_0.inv_PI_d4$1_0.VIN VSS 0.00566f
C2997 6to4_0.buff_PI_d32_2.buff_PI_d16$1_0.inv_PI_d16$1_0.inv_PI_d8$1_0.inv_PI_d4$1_0.inv_PI_d2$1_1.VIN VSS 0.00236f
C2998 6to4_0.buff_PI_d32_2.buff_PI_d16$1_0.inv_PI_d8$1_0.VOUT.n5 VSS 0.01557f
C2999 6to4_0.buff_PI_d32_2.buff_PI_d16$1_0.inv_PI_d8$1_0.VOUT.n6 VSS 0.12379f
C3000 6to4_0.buff_PI_d32_2.buff_PI_d16$1_0.inv_PI_d8$1_0.VOUT.t32 VSS 0.2604f
C3001 6to4_0.buff_PI_d32_2.buff_PI_d16$1_0.inv_PI_d16$1_0.inv_PI_d8$1_1.inv_PI_d4$1_1.inv_PI_d2$1_0.inv_PI$1_0.VIN VSS 0.00708f
C3002 6to4_0.buff_PI_d32_2.buff_PI_d16$1_0.inv_PI_d8$1_0.VOUT.n7 VSS 0.02123f
C3003 6to4_0.buff_PI_d32_2.buff_PI_d16$1_0.inv_PI_d8$1_0.VOUT.n8 VSS 0.12363f
C3004 6to4_0.buff_PI_d32_2.buff_PI_d16$1_0.inv_PI_d8$1_0.VOUT.t31 VSS 0.2604f
C3005 6to4_0.buff_PI_d32_2.buff_PI_d16$1_0.inv_PI_d16$1_0.inv_PI_d8$1_1.inv_PI_d4$1_0.inv_PI_d2$1_0.inv_PI$1_0.VIN VSS 0.00708f
C3006 6to4_0.buff_PI_d32_2.buff_PI_d16$1_0.inv_PI_d8$1_0.VOUT.n9 VSS 0.03495f
C3007 6to4_0.buff_PI_d32_2.buff_PI_d16$1_0.inv_PI_d8$1_0.VOUT.t33 VSS 0.2604f
C3008 6to4_0.buff_PI_d32_2.buff_PI_d16$1_0.inv_PI_d16$1_0.inv_PI_d8$1_1.inv_PI_d4$1_0.inv_PI_d2$1_0.inv_PI$1_1.VIN VSS 0.00566f
C3009 6to4_0.buff_PI_d32_2.buff_PI_d16$1_0.inv_PI_d16$1_0.inv_PI_d8$1_1.inv_PI_d4$1_0.inv_PI_d2$1_0.VIN VSS 0.00708f
C3010 6to4_0.buff_PI_d32_2.buff_PI_d16$1_0.inv_PI_d8$1_0.VOUT.n10 VSS 0.01557f
C3011 6to4_0.buff_PI_d32_2.buff_PI_d16$1_0.inv_PI_d8$1_0.VOUT.n11 VSS 0.21546f
C3012 6to4_0.buff_PI_d32_2.buff_PI_d16$1_0.inv_PI_d8$1_0.VOUT.t25 VSS 0.2604f
C3013 6to4_0.buff_PI_d32_2.buff_PI_d16$1_0.inv_PI_d16$1_0.inv_PI_d8$1_0.inv_PI_d4$1_0.inv_PI_d2$1_1.inv_PI$1_0.VIN VSS 0.00708f
C3014 6to4_0.buff_PI_d32_2.buff_PI_d16$1_0.inv_PI_d8$1_0.VOUT.n12 VSS 0.02123f
C3015 6to4_0.buff_PI_d32_2.buff_PI_d16$1_0.inv_PI_d8$1_0.VOUT.n13 VSS 0.12363f
C3016 6to4_0.buff_PI_d32_2.buff_PI_d16$1_0.inv_PI_d8$1_0.VOUT.t39 VSS 0.2604f
C3017 6to4_0.buff_PI_d32_2.buff_PI_d16$1_0.inv_PI_d16$1_0.inv_PI_d8$1_0.inv_PI_d4$1_0.inv_PI_d2$1_0.inv_PI$1_0.VIN VSS 0.00708f
C3018 6to4_0.buff_PI_d32_2.buff_PI_d16$1_0.inv_PI_d8$1_0.VOUT.n14 VSS 0.03495f
C3019 6to4_0.buff_PI_d32_2.buff_PI_d16$1_0.inv_PI_d8$1_0.VOUT.t27 VSS 0.2604f
C3020 6to4_0.buff_PI_d32_2.buff_PI_d16$1_0.inv_PI_d16$1_0.inv_PI_d8$1_0.inv_PI_d4$1_0.inv_PI_d2$1_0.inv_PI$1_1.VIN VSS 0.00566f
C3021 6to4_0.buff_PI_d32_2.buff_PI_d16$1_0.inv_PI_d16$1_0.inv_PI_d8$1_0.inv_PI_d4$1_0.inv_PI_d2$1_0.VIN VSS 0.00708f
C3022 6to4_0.buff_PI_d32_2.buff_PI_d16$1_0.inv_PI_d8$1_0.VOUT.n15 VSS 0.01557f
C3023 6to4_0.buff_PI_d32_2.buff_PI_d16$1_0.inv_PI_d8$1_0.VOUT.n16 VSS 0.21546f
C3024 6to4_0.buff_PI_d32_2.buff_PI_d16$1_0.inv_PI_d8$1_0.VOUT.n17 VSS 0.32005f
C3025 6to4_0.buff_PI_d32_2.buff_PI_d16$1_0.inv_PI_d8$1_0.VOUT.n18 VSS 0.32005f
C3026 6to4_0.buff_PI_d32_2.buff_PI_d16$1_0.inv_PI_d8$1_0.VOUT.t34 VSS 0.2604f
C3027 6to4_0.buff_PI_d32_2.buff_PI_d16$1_0.inv_PI_d16$1_0.inv_PI_d8$1_1.inv_PI_d4$1_0.inv_PI_d2$1_1.inv_PI$1_0.VIN VSS 0.00708f
C3028 6to4_0.buff_PI_d32_2.buff_PI_d16$1_0.inv_PI_d8$1_0.VOUT.n19 VSS 0.02123f
C3029 6to4_0.buff_PI_d32_2.buff_PI_d16$1_0.inv_PI_d8$1_0.VOUT.n20 VSS 0.12363f
C3030 6to4_0.buff_PI_d32_2.buff_PI_d16$1_0.inv_PI_d8$1_0.VOUT.t38 VSS 0.2604f
C3031 6to4_0.buff_PI_d32_2.buff_PI_d16$1_0.inv_PI_d16$1_0.inv_PI_d8$1_1.inv_PI_d4$1_0.inv_PI_d2$1_1.inv_PI$1_1.VIN VSS 0.00472f
C3032 6to4_0.buff_PI_d32_2.buff_PI_d16$1_0.inv_PI_d16$1_0.inv_PI_d8$1_1.inv_PI_d4$1_0.VIN VSS 0.00566f
C3033 6to4_0.buff_PI_d32_2.buff_PI_d16$1_0.inv_PI_d16$1_0.inv_PI_d8$1_1.inv_PI_d4$1_0.inv_PI_d2$1_1.VIN VSS 0.00236f
C3034 6to4_0.buff_PI_d32_2.buff_PI_d16$1_0.inv_PI_d8$1_0.VOUT.n21 VSS 0.01557f
C3035 6to4_0.buff_PI_d32_2.buff_PI_d16$1_0.inv_PI_d8$1_0.VOUT.n22 VSS 0.12379f
C3036 6to4_0.buff_PI_d32_2.buff_PI_d16$1_0.inv_PI_d8$1_0.VOUT.n23 VSS 0.32005f
C3037 6to4_0.buff_PI_d32_2.buff_PI_d16$1_0.inv_PI_d8$1_0.VOUT.n24 VSS 0.32005f
C3038 6to4_0.buff_PI_d32_2.buff_PI_d16$1_0.inv_PI_d8$1_0.VOUT.t37 VSS 0.2604f
C3039 6to4_0.buff_PI_d32_2.buff_PI_d16$1_0.inv_PI_d16$1_0.inv_PI_d8$1_0.inv_PI_d4$1_1.inv_PI_d2$1_0.inv_PI$1_0.VIN VSS 0.00708f
C3040 6to4_0.buff_PI_d32_2.buff_PI_d16$1_0.inv_PI_d8$1_0.VOUT.n25 VSS 0.02123f
C3041 6to4_0.buff_PI_d32_2.buff_PI_d16$1_0.inv_PI_d8$1_0.VOUT.n26 VSS 0.12363f
C3042 6to4_0.buff_PI_d32_2.buff_PI_d16$1_0.inv_PI_d8$1_0.VOUT.t29 VSS 0.2604f
C3043 6to4_0.buff_PI_d32_2.buff_PI_d16$1_0.inv_PI_d16$1_0.inv_PI_d8$1_0.inv_PI_d4$1_1.inv_PI_d2$1_0.inv_PI$1_1.VIN VSS 0.00566f
C3044 6to4_0.buff_PI_d32_2.buff_PI_d16$1_0.inv_PI_d16$1_0.inv_PI_d8$1_0.inv_PI_d4$1_1.inv_PI_d2$1_0.VIN VSS 0.00708f
C3045 6to4_0.buff_PI_d32_2.buff_PI_d16$1_0.inv_PI_d8$1_0.VOUT.n27 VSS 0.01557f
C3046 6to4_0.buff_PI_d32_2.buff_PI_d16$1_0.inv_PI_d8$1_0.VOUT.n28 VSS 0.12379f
C3047 6to4_0.buff_PI_d32_2.buff_PI_d16$1_0.inv_PI_d8$1_0.VOUT.n29 VSS 0.09354f
C3048 6to4_0.buff_PI_d32_2.buff_PI_d16$1_0.inv_PI_d16$1_0.VIN VSS 0.45552f
C3049 6to4_0.buff_PI_d32_2.buff_PI_d16$1_0.inv_PI_d8$1_0.VOUT.n30 VSS 0.09103f
C3050 6to4_0.buff_PI_d32_2.buff_PI_d16$1_0.inv_PI_d8$1_0.VOUT.t24 VSS 0.2604f
C3051 6to4_0.buff_PI_d32_2.buff_PI_d16$1_0.inv_PI_d16$1_0.inv_PI_d8$1_1.inv_PI_d4$1_1.inv_PI_d2$1_1.inv_PI$1_0.VIN VSS 0.00708f
C3052 6to4_0.buff_PI_d32_2.buff_PI_d16$1_0.inv_PI_d8$1_0.VOUT.n31 VSS 0.02123f
C3053 6to4_0.buff_PI_d32_2.buff_PI_d16$1_0.inv_PI_d8$1_0.VOUT.n32 VSS 0.2153f
C3054 6to4_0.buff_PI_d32_2.buff_PI_d16$1_0.inv_PI_d8$1_0.VOUT.t30 VSS 0.2604f
C3055 6to4_0.buff_PI_d32_2.buff_PI_d16$1_0.inv_PI_d8$1_0.VOUT.n33 VSS 0.02929f
C3056 6to4_0.buff_PI_d32_2.buff_PI_d16$1_0.inv_PI_d16$1_0.inv_PI_d8$1_1.inv_PI_d4$1_1.inv_PI_d2$1_1.VIN VSS 0.00236f
C3057 6to4_0.buff_PI_d32_2.buff_PI_d16$1_0.inv_PI_d16$1_0.inv_PI_d8$1_1.inv_PI_d4$1_1.VIN VSS 0.00566f
C3058 6to4_0.buff_PI_d32_2.buff_PI_d16$1_0.inv_PI_d16$1_0.inv_PI_d8$1_1.inv_PI_d4$1_1.inv_PI_d2$1_1.inv_PI$1_1.VIN VSS 0.06501f
C3059 6to4_0.buff_PI_d32_2.buff_PI_d16$1_0.inv_PI_d8$1_0.VOUT.n34 VSS 0.08613f
C3060 6to4_0.buff_PI_d32_2.buff_PI_d16$1_0.inv_PI_d8$1_0.VOUT.t4 VSS 0.03591f
C3061 6to4_0.buff_PI_d32_2.buff_PI_d16$1_0.inv_PI_d8$1_0.VOUT.t10 VSS 0.03179f
C3062 6to4_0.buff_PI_d32_2.buff_PI_d16$1_0.inv_PI_d8$1_0.VOUT.t18 VSS 0.03179f
C3063 6to4_0.buff_PI_d32_2.buff_PI_d16$1_0.inv_PI_d8$1_0.VOUT.t0 VSS 0.03591f
C3064 6to4_0.buff_PI_d32_2.buff_PI_d16$1_0.inv_PI_d8$1_0.VOUT.t11 VSS 0.0351f
C3065 6to4_0.buff_PI_d32_2.buff_PI_d16$1_0.inv_PI_d8$1_0.VOUT.t20 VSS 0.0351f
C3066 6to4_0.buff_PI_d32_2.buff_PI_d16$1_0.inv_PI_d8$1_0.VOUT.t6 VSS 0.03591f
C3067 6to4_0.buff_PI_d32_2.buff_PI_d16$1_0.inv_PI_d8$1_0.VOUT.t14 VSS 0.03179f
C3068 6to4_0.buff_PI_d32_2.buff_PI_d16$1_0.inv_PI_d8$1_0.VOUT.t21 VSS 0.03179f
C3069 6to4_0.buff_PI_d32_2.buff_PI_d16$1_0.inv_PI_d8$1_0.VOUT.t3 VSS 0.03591f
C3070 6to4_0.buff_PI_d32_2.buff_PI_d16$1_0.inv_PI_d8$1_0.VOUT.t8 VSS 0.0351f
C3071 6to4_0.buff_PI_d32_2.buff_PI_d16$1_0.inv_PI_d8$1_0.VOUT.t16 VSS 0.0351f
C3072 6to4_0.buff_PI_d32_2.buff_PI_d16$1_0.inv_PI_d8$1_0.VOUT.t5 VSS 0.03591f
C3073 6to4_0.buff_PI_d32_2.buff_PI_d16$1_0.inv_PI_d8$1_0.VOUT.t23 VSS 0.03179f
C3074 6to4_0.buff_PI_d32_2.buff_PI_d16$1_0.inv_PI_d8$1_0.VOUT.t9 VSS 0.03179f
C3075 6to4_0.buff_PI_d32_2.buff_PI_d16$1_0.inv_PI_d8$1_0.VOUT.t17 VSS 0.0351f
C3076 6to4_0.buff_PI_d32_2.buff_PI_d16$1_0.inv_PI_d8$1_0.VOUT.t19 VSS 0.0351f
C3077 6to4_0.buff_PI_d32_2.buff_PI_d16$1_0.inv_PI_d8$1_0.VOUT.t1 VSS 0.03591f
C3078 6to4_0.buff_PI_d32_2.buff_PI_d16$1_0.inv_PI_d8$1_0.VOUT.t22 VSS 0.03179f
C3079 6to4_0.buff_PI_d32_2.buff_PI_d16$1_0.inv_PI_d8$1_0.VOUT.t13 VSS 0.03179f
C3080 6to4_0.buff_PI_d32_2.buff_PI_d16$1_0.inv_PI_d8$1_0.VOUT.t2 VSS 0.03591f
C3081 6to4_0.buff_PI_d32_2.buff_PI_d16$1_0.inv_PI_d8$1_0.VOUT.t15 VSS 0.03581f
C3082 6to4_0.buff_PI_d32_2.buff_PI_d16$1_0.inv_PI_d8$1_0.inv_PI_d4$1_1.inv_PI_d2$1_1.inv_PI$1_1.VOUT VSS 0.0517f
C3083 6to4_0.buff_PI_d32_2.buff_PI_d16$1_0.inv_PI_d8$1_0.VOUT.n35 VSS 0.0667f
C3084 6to4_0.buff_PI_d32_2.buff_PI_d16$1_0.inv_PI_d8$1_0.VOUT.n36 VSS 0.05947f
C3085 6to4_0.buff_PI_d32_2.buff_PI_d16$1_0.inv_PI_d8$1_0.VOUT.n37 VSS 0.04638f
C3086 6to4_0.buff_PI_d32_2.buff_PI_d16$1_0.inv_PI_d8$1_0.inv_PI_d4$1_1.inv_PI_d2$1_1.VOUT VSS 0.01435f
C3087 6to4_0.buff_PI_d32_2.buff_PI_d16$1_0.inv_PI_d8$1_0.VOUT.n38 VSS 0.06544f
C3088 6to4_0.buff_PI_d32_2.buff_PI_d16$1_0.inv_PI_d8$1_0.inv_PI_d4$1_1.inv_PI_d2$1_1.inv_PI$1_0.VOUT VSS 0.01435f
C3089 6to4_0.buff_PI_d32_2.buff_PI_d16$1_0.inv_PI_d8$1_0.VOUT.n39 VSS 0.08589f
C3090 6to4_0.buff_PI_d32_2.buff_PI_d16$1_0.inv_PI_d8$1_0.VOUT.n40 VSS 0.08589f
C3091 6to4_0.buff_PI_d32_2.buff_PI_d16$1_0.inv_PI_d8$1_0.inv_PI_d4$1_1.inv_PI_d2$1_0.inv_PI$1_1.VOUT VSS 0.01435f
C3092 6to4_0.buff_PI_d32_2.buff_PI_d16$1_0.inv_PI_d8$1_0.VOUT.t7 VSS 0.03591f
C3093 6to4_0.buff_PI_d32_2.buff_PI_d16$1_0.inv_PI_d8$1_0.VOUT.n41 VSS 0.0667f
C3094 6to4_0.buff_PI_d32_2.buff_PI_d16$1_0.inv_PI_d8$1_0.VOUT.n42 VSS 0.05947f
C3095 6to4_0.buff_PI_d32_2.buff_PI_d16$1_0.inv_PI_d8$1_0.VOUT.n43 VSS 0.04638f
C3096 6to4_0.buff_PI_d32_2.buff_PI_d16$1_0.inv_PI_d8$1_0.inv_PI_d4$1_1.inv_PI_d2$1_0.VOUT VSS 0.01435f
C3097 6to4_0.buff_PI_d32_2.buff_PI_d16$1_0.inv_PI_d8$1_0.VOUT.n44 VSS 0.06544f
C3098 6to4_0.buff_PI_d32_2.buff_PI_d16$1_0.inv_PI_d8$1_0.inv_PI_d4$1_1.inv_PI_d2$1_0.inv_PI$1_0.VOUT VSS 0.01019f
C3099 6to4_0.buff_PI_d32_2.buff_PI_d16$1_0.inv_PI_d8$1_0.inv_PI_d4$1_1.VOUT VSS 0.01208f
C3100 6to4_0.buff_PI_d32_2.buff_PI_d16$1_0.inv_PI_d8$1_0.VOUT.n45 VSS 0.07796f
C3101 6to4_0.buff_PI_d32_2.buff_PI_d16$1_0.inv_PI_d8$1_0.VOUT.n46 VSS 0.08589f
C3102 6to4_0.buff_PI_d32_2.buff_PI_d16$1_0.inv_PI_d8$1_0.inv_PI_d4$1_0.inv_PI_d2$1_1.inv_PI$1_1.VOUT VSS 0.01435f
C3103 6to4_0.buff_PI_d32_2.buff_PI_d16$1_0.inv_PI_d8$1_0.VOUT.n47 VSS 0.0667f
C3104 6to4_0.buff_PI_d32_2.buff_PI_d16$1_0.inv_PI_d8$1_0.VOUT.n48 VSS 0.05947f
C3105 6to4_0.buff_PI_d32_2.buff_PI_d16$1_0.inv_PI_d8$1_0.VOUT.n49 VSS 0.04638f
C3106 6to4_0.buff_PI_d32_2.buff_PI_d16$1_0.inv_PI_d8$1_0.inv_PI_d4$1_0.inv_PI_d2$1_1.VOUT VSS 0.01435f
C3107 6to4_0.buff_PI_d32_2.buff_PI_d16$1_0.inv_PI_d8$1_0.VOUT.n50 VSS 0.06544f
C3108 6to4_0.buff_PI_d32_2.buff_PI_d16$1_0.inv_PI_d8$1_0.inv_PI_d4$1_0.inv_PI_d2$1_1.inv_PI$1_0.VOUT VSS 0.01435f
C3109 6to4_0.buff_PI_d32_2.buff_PI_d16$1_0.inv_PI_d8$1_0.VOUT.n51 VSS 0.08589f
C3110 6to4_0.buff_PI_d32_2.buff_PI_d16$1_0.inv_PI_d8$1_0.VOUT.n52 VSS 0.08589f
C3111 6to4_0.buff_PI_d32_2.buff_PI_d16$1_0.inv_PI_d8$1_0.inv_PI_d4$1_0.inv_PI_d2$1_0.inv_PI$1_1.VOUT VSS 0.01435f
C3112 6to4_0.buff_PI_d32_2.buff_PI_d16$1_0.inv_PI_d8$1_0.VOUT.n53 VSS 0.0667f
C3113 6to4_0.buff_PI_d32_2.buff_PI_d16$1_0.inv_PI_d8$1_0.VOUT.n54 VSS 0.05947f
C3114 6to4_0.buff_PI_d32_2.buff_PI_d16$1_0.inv_PI_d8$1_0.VOUT.n55 VSS 0.04638f
C3115 6to4_0.buff_PI_d32_2.buff_PI_d16$1_0.inv_PI_d8$1_0.inv_PI_d4$1_0.inv_PI_d2$1_0.VOUT VSS 0.01435f
C3116 6to4_0.buff_PI_d32_2.buff_PI_d16$1_0.inv_PI_d8$1_0.VOUT.n56 VSS 0.06544f
C3117 6to4_0.buff_PI_d32_2.buff_PI_d16$1_0.inv_PI_d8$1_0.inv_PI_d4$1_0.inv_PI_d2$1_0.inv_PI$1_0.VOUT VSS 0.01019f
C3118 6to4_0.buff_PI_d32_2.buff_PI_d16$1_0.inv_PI_d8$1_0.inv_PI_d4$1_0.VOUT VSS 0.01208f
C3119 6ph_rosc_0.psdiff_0.buff_d8$1_1.VIN.t32 VSS 0.05063f
C3120 6ph_rosc_0.psdiff_0.buff_d8$1_1.VIN.t25 VSS 0.02262f
C3121 6ph_rosc_0.psdiff_0.buff_d8$1_1.VIN.t29 VSS 0.02237f
C3122 6ph_rosc_0.psdiff_0.buff_d8$1_1.VIN.n0 VSS 0.02861f
C3123 6ph_rosc_0.psdiff_0.buff_d8$1_1.VIN.t22 VSS 0.02237f
C3124 6ph_rosc_0.psdiff_0.buff_d8$1_1.VIN.n1 VSS 0.01322f
C3125 6ph_rosc_0.psdiff_0.buff_d8$1_1.VIN.t20 VSS 0.02262f
C3126 6ph_rosc_0.psdiff_0.buff_d8$1_1.VIN.t26 VSS 0.02237f
C3127 6ph_rosc_0.psdiff_0.buff_d8$1_1.VIN.n2 VSS 0.02861f
C3128 6ph_rosc_0.psdiff_0.buff_d8$1_1.VIN.t18 VSS 0.02237f
C3129 6ph_rosc_0.psdiff_0.buff_d8$1_1.VIN.n3 VSS 0.01322f
C3130 6ph_rosc_0.psdiff_0.buff_d8$1_1.VIN.t11 VSS 0.02037f
C3131 6ph_rosc_0.psdiff_0.buff_d8$1_1.VIN.t31 VSS 0.02262f
C3132 6ph_rosc_0.psdiff_0.buff_d8$1_1.VIN.t17 VSS 0.02237f
C3133 6ph_rosc_0.psdiff_0.buff_d8$1_1.VIN.n4 VSS 0.02861f
C3134 6ph_rosc_0.psdiff_0.buff_d8$1_1.VIN.t30 VSS 0.02237f
C3135 6ph_rosc_0.psdiff_0.buff_d8$1_1.VIN.n5 VSS 0.01322f
C3136 6ph_rosc_0.psdiff_0.buff_d8$1_1.VIN.t28 VSS 0.02262f
C3137 6ph_rosc_0.psdiff_0.buff_d8$1_1.VIN.t23 VSS 0.02237f
C3138 6ph_rosc_0.psdiff_0.buff_d8$1_1.VIN.n6 VSS 0.02861f
C3139 6ph_rosc_0.psdiff_0.buff_d8$1_1.VIN.t27 VSS 0.02237f
C3140 6ph_rosc_0.psdiff_0.buff_d8$1_1.VIN.n7 VSS 0.01322f
C3141 6ph_rosc_0.psdiff_0.buff_d8$1_1.VIN.t10 VSS 0.02026f
C3142 6ph_rosc_0.psdiff_0.buff_d8$1_1.VIN.t8 VSS 0.02262f
C3143 6ph_rosc_0.psdiff_0.buff_d8$1_1.VIN.t6 VSS 0.02237f
C3144 6ph_rosc_0.psdiff_0.buff_d8$1_1.VIN.n8 VSS 0.03437f
C3145 6ph_rosc_0.psdiff_0.buff_d8$1_1.VIN.t4 VSS 0.02262f
C3146 6ph_rosc_0.psdiff_0.buff_d8$1_1.VIN.t3 VSS 0.02237f
C3147 6ph_rosc_0.psdiff_0.buff_d8$1_1.VIN.n9 VSS 0.03498f
C3148 6ph_rosc_0.psdiff_0.buff_d8$1_1.VIN.t15 VSS 0.02237f
C3149 6ph_rosc_0.psdiff_0.buff_d8$1_1.VIN.n10 VSS 0.01959f
C3150 6ph_rosc_0.psdiff_0.buff_d8$1_1.VIN.t1 VSS 0.02262f
C3151 6ph_rosc_0.psdiff_0.buff_d8$1_1.VIN.t0 VSS 0.02237f
C3152 6ph_rosc_0.psdiff_0.buff_d8$1_1.VIN.n11 VSS 0.03498f
C3153 6ph_rosc_0.psdiff_0.buff_d8$1_1.VIN.t13 VSS 0.02237f
C3154 6ph_rosc_0.psdiff_0.buff_d8$1_1.VIN.n12 VSS 0.01959f
C3155 6ph_rosc_0.psdiff_0.buff_d8$1_1.VIN.t5 VSS 0.02262f
C3156 6ph_rosc_0.psdiff_0.buff_d8$1_1.VIN.t2 VSS 0.02237f
C3157 6ph_rosc_0.psdiff_0.buff_d8$1_1.VIN.n13 VSS 0.03498f
C3158 6ph_rosc_0.psdiff_0.buff_d8$1_1.VIN.t14 VSS 0.02237f
C3159 6ph_rosc_0.psdiff_0.buff_d8$1_1.VIN.n14 VSS 0.01959f
C3160 6ph_rosc_0.psdiff_0.buff_d8$1_1.VIN.t7 VSS 0.02262f
C3161 6ph_rosc_0.psdiff_0.buff_d8$1_1.VIN.t9 VSS 0.02237f
C3162 6ph_rosc_0.psdiff_0.buff_d8$1_1.VIN.n15 VSS 0.03498f
C3163 6ph_rosc_0.psdiff_0.buff_d8$1_1.VIN.t16 VSS 0.02237f
C3164 6ph_rosc_0.psdiff_0.buff_d8$1_1.VIN.n16 VSS 0.04f
C3165 6ph_rosc_0.psdiff_0.buff_d8$1_1.VIN.n17 VSS 0.04731f
C3166 6ph_rosc_0.psdiff_0.buff_d8$1_1.VIN.n18 VSS 0.04176f
C3167 6ph_rosc_0.psdiff_0.buff_d8$1_1.VIN.n19 VSS 0.04657f
C3168 6ph_rosc_0.psdiff_0.buff_d8$1_1.VIN.t12 VSS 0.02237f
C3169 6ph_rosc_0.psdiff_0.buff_d8$1_1.VIN.n20 VSS 0.10258f
C3170 6ph_rosc_0.psdiff_0.buff_d8$1_1.VIN.n21 VSS 0.06915f
C3171 6ph_rosc_0.psdiff_0.buff_d8$1_1.VIN.n22 VSS 0.03074f
C3172 6ph_rosc_0.psdiff_0.buff_d8$1_1.VIN.n23 VSS 0.05599f
C3173 6ph_rosc_0.psdiff_0.buff_d8$1_1.VIN.n24 VSS 0.04176f
C3174 6ph_rosc_0.psdiff_0.buff_d8$1_1.VIN.n25 VSS 0.04657f
C3175 6ph_rosc_0.psdiff_0.buff_d8$1_1.VIN.t19 VSS 0.02237f
C3176 6ph_rosc_0.psdiff_0.buff_d8$1_1.VIN.t21 VSS 0.02262f
C3177 6ph_rosc_0.psdiff_0.buff_d8$1_1.VIN.t24 VSS 0.02237f
C3178 6ph_rosc_0.psdiff_0.buff_d8$1_1.VIN.n26 VSS 0.02812f
C3179 6ph_rosc_0.psdiff_0.buff_d8$1_1.VIN.n27 VSS 0.25023f
C3180 6ph_rosc_0.psdiff_0.buff_d8$1_1.VIN.n28 VSS 0.22604f
C3181 6ph_rosc_0.psdiff_0.buff_d8$1_1.inv$3_0.VIN VSS 0.00786f
C3182 PH0.t38 VSS 0.05505f
C3183 PH0.t68 VSS 0.05505f
C3184 PH0.t22 VSS 0.05633f
C3185 PH0.t69 VSS 0.04987f
C3186 PH0.t82 VSS 0.04987f
C3187 PH0.t13 VSS 0.05633f
C3188 PH0.t35 VSS 0.05505f
C3189 PH0.t65 VSS 0.05505f
C3190 PH0.t10 VSS 0.05633f
C3191 PH0.t80 VSS 0.04987f
C3192 PH0.t90 VSS 0.04987f
C3193 PH0.t24 VSS 0.05633f
C3194 PH0.t54 VSS 0.05505f
C3195 PH0.t56 VSS 0.05505f
C3196 PH0.t30 VSS 0.05633f
C3197 PH0.t33 VSS 0.04987f
C3198 PH0.t58 VSS 0.04987f
C3199 PH0.t18 VSS 0.05633f
C3200 PH0.t85 VSS 0.05505f
C3201 PH0.t78 VSS 0.05505f
C3202 PH0.t19 VSS 0.05633f
C3203 PH0.t51 VSS 0.04987f
C3204 PH0.t72 VSS 0.04987f
C3205 PH0.t0 VSS 0.05633f
C3206 PH0.t44 VSS 0.05617f
C3207 PH0.n0 VSS 0.10462f
C3208 PH0.n1 VSS 0.09327f
C3209 PH0.n2 VSS 0.07274f
C3210 PH0.n3 VSS 0.10264f
C3211 PH0.n4 VSS 0.13472f
C3212 PH0.n5 VSS 0.13472f
C3213 PH0.n6 VSS 0.10462f
C3214 PH0.n7 VSS 0.09327f
C3215 PH0.n8 VSS 0.07274f
C3216 PH0.n9 VSS 0.10264f
C3217 PH0.n10 VSS 0.12228f
C3218 PH0.n11 VSS 0.13472f
C3219 PH0.n12 VSS 0.10462f
C3220 PH0.n13 VSS 0.09327f
C3221 PH0.n14 VSS 0.07274f
C3222 PH0.n15 VSS 0.10264f
C3223 PH0.n16 VSS 0.13472f
C3224 PH0.n17 VSS 0.13472f
C3225 PH0.n18 VSS 0.10462f
C3226 PH0.n19 VSS 0.09327f
C3227 PH0.n20 VSS 0.07274f
C3228 PH0.n21 VSS 0.10264f
C3229 PH0.n22 VSS 0.16835f
C3230 PH0.t34 VSS 0.05505f
C3231 PH0.t12 VSS 0.05633f
C3232 PH0.t81 VSS 0.04987f
C3233 PH0.t89 VSS 0.04987f
C3234 PH0.t23 VSS 0.05633f
C3235 PH0.t62 VSS 0.05505f
C3236 PH0.t39 VSS 0.05505f
C3237 PH0.t11 VSS 0.05633f
C3238 PH0.t87 VSS 0.04987f
C3239 PH0.t41 VSS 0.04987f
C3240 PH0.t3 VSS 0.05633f
C3241 PH0.t74 VSS 0.05505f
C3242 PH0.t57 VSS 0.05505f
C3243 PH0.t4 VSS 0.05633f
C3244 PH0.t59 VSS 0.04987f
C3245 PH0.t76 VSS 0.04987f
C3246 PH0.t5 VSS 0.05633f
C3247 PH0.t47 VSS 0.05505f
C3248 PH0.t86 VSS 0.05505f
C3249 PH0.t1 VSS 0.05633f
C3250 PH0.t73 VSS 0.04987f
C3251 PH0.t83 VSS 0.04987f
C3252 PH0.t15 VSS 0.05633f
C3253 PH0.t45 VSS 0.05617f
C3254 PH0.n23 VSS 0.10462f
C3255 PH0.n24 VSS 0.09327f
C3256 PH0.n25 VSS 0.07274f
C3257 PH0.n26 VSS 0.10264f
C3258 PH0.n27 VSS 0.13472f
C3259 PH0.n28 VSS 0.13472f
C3260 PH0.n29 VSS 0.10462f
C3261 PH0.n30 VSS 0.09327f
C3262 PH0.n31 VSS 0.07274f
C3263 PH0.n32 VSS 0.10264f
C3264 PH0.n33 VSS 0.12228f
C3265 PH0.n34 VSS 0.13472f
C3266 PH0.n35 VSS 0.10462f
C3267 PH0.n36 VSS 0.09327f
C3268 PH0.n37 VSS 0.07274f
C3269 PH0.n38 VSS 0.10264f
C3270 PH0.n39 VSS 0.13472f
C3271 PH0.n40 VSS 0.13472f
C3272 PH0.n41 VSS 0.10462f
C3273 PH0.n42 VSS 0.09327f
C3274 PH0.n43 VSS 0.07274f
C3275 PH0.n44 VSS 0.10264f
C3276 PH0.n45 VSS 0.16463f
C3277 PH0.t75 VSS 0.05505f
C3278 PH0.t27 VSS 0.05633f
C3279 PH0.t66 VSS 0.04987f
C3280 PH0.t43 VSS 0.04987f
C3281 PH0.t26 VSS 0.05633f
C3282 PH0.t64 VSS 0.05505f
C3283 PH0.t42 VSS 0.05505f
C3284 PH0.t9 VSS 0.05633f
C3285 PH0.t55 VSS 0.04987f
C3286 PH0.t95 VSS 0.04987f
C3287 PH0.t21 VSS 0.05633f
C3288 PH0.t53 VSS 0.05505f
C3289 PH0.t84 VSS 0.05505f
C3290 PH0.t16 VSS 0.05633f
C3291 PH0.t91 VSS 0.04987f
C3292 PH0.t94 VSS 0.04987f
C3293 PH0.t2 VSS 0.05633f
C3294 PH0.t46 VSS 0.05505f
C3295 PH0.t67 VSS 0.05505f
C3296 PH0.t20 VSS 0.05633f
C3297 PH0.t88 VSS 0.04987f
C3298 PH0.t92 VSS 0.04987f
C3299 PH0.t28 VSS 0.05633f
C3300 PH0.t32 VSS 0.05617f
C3301 PH0.n46 VSS 0.10462f
C3302 PH0.n47 VSS 0.09327f
C3303 PH0.n48 VSS 0.07274f
C3304 PH0.n49 VSS 0.10264f
C3305 PH0.n50 VSS 0.13472f
C3306 PH0.n51 VSS 0.13472f
C3307 PH0.n52 VSS 0.10462f
C3308 PH0.n53 VSS 0.09327f
C3309 PH0.n54 VSS 0.07274f
C3310 PH0.n55 VSS 0.10264f
C3311 PH0.n56 VSS 0.12228f
C3312 PH0.n57 VSS 0.13472f
C3313 PH0.n58 VSS 0.10462f
C3314 PH0.n59 VSS 0.09327f
C3315 PH0.n60 VSS 0.07274f
C3316 PH0.n61 VSS 0.10264f
C3317 PH0.n62 VSS 0.13472f
C3318 PH0.n63 VSS 0.13472f
C3319 PH0.n64 VSS 0.10462f
C3320 PH0.n65 VSS 0.09327f
C3321 PH0.n66 VSS 0.07274f
C3322 PH0.n67 VSS 0.10264f
C3323 PH0.n68 VSS 0.16463f
C3324 PH0.n69 VSS 0.16463f
C3325 PH0.t6 VSS 0.05633f
C3326 PH0.t77 VSS 0.04987f
C3327 PH0.t61 VSS 0.04987f
C3328 PH0.t31 VSS 0.05633f
C3329 PH0.t37 VSS 0.05505f
C3330 PH0.t60 VSS 0.05505f
C3331 PH0.t71 VSS 0.04987f
C3332 PH0.t50 VSS 0.04987f
C3333 PH0.t29 VSS 0.05633f
C3334 PH0.t70 VSS 0.05505f
C3335 PH0.t49 VSS 0.05505f
C3336 PH0.t25 VSS 0.05633f
C3337 PH0.t36 VSS 0.04987f
C3338 PH0.t48 VSS 0.04987f
C3339 PH0.t14 VSS 0.05633f
C3340 PH0.t63 VSS 0.05505f
C3341 PH0.t79 VSS 0.05505f
C3342 PH0.t8 VSS 0.05633f
C3343 PH0.t93 VSS 0.04987f
C3344 PH0.t40 VSS 0.04987f
C3345 PH0.t7 VSS 0.05633f
C3346 PH0.t52 VSS 0.05617f
C3347 PH0.n70 VSS 0.10462f
C3348 PH0.n71 VSS 0.09327f
C3349 PH0.n72 VSS 0.07274f
C3350 PH0.n73 VSS 0.10264f
C3351 PH0.n74 VSS 0.13472f
C3352 PH0.n75 VSS 0.13472f
C3353 PH0.n76 VSS 0.10462f
C3354 PH0.n77 VSS 0.09327f
C3355 PH0.n78 VSS 0.07274f
C3356 PH0.n79 VSS 0.10264f
C3357 PH0.n80 VSS 0.12228f
C3358 PH0.n81 VSS 0.13472f
C3359 PH0.n82 VSS 0.10462f
C3360 PH0.n83 VSS 0.09327f
C3361 PH0.n84 VSS 0.07274f
C3362 PH0.t17 VSS 0.05633f
C3363 PH0.n85 VSS 0.10264f
C3364 PH0.n86 VSS 0.13472f
C3365 PH0.n87 VSS 0.13472f
C3366 PH0.n88 VSS 0.10462f
C3367 PH0.n89 VSS 0.09327f
C3368 PH0.n90 VSS 0.07274f
C3369 PH0.n91 VSS 0.10264f
C3370 6to4_0.buff_PI_d32_2.buff_PI_d16$1_0.inv_PI_d4$1_0.VOUT.t7 VSS 0.02523f
C3371 6to4_0.buff_PI_d32_2.buff_PI_d16$1_0.inv_PI_d4$1_0.VOUT.t16 VSS 0.1872f
C3372 6to4_0.buff_PI_d32_2.buff_PI_d16$1_0.inv_PI_d4$1_0.VOUT.n0 VSS 0.02105f
C3373 6to4_0.buff_PI_d32_2.buff_PI_d16$1_0.inv_PI_d4$1_0.VOUT.t12 VSS 0.1872f
C3374 6to4_0.buff_PI_d32_2.buff_PI_d16$1_0.inv_PI_d4$1_0.VOUT.n1 VSS 0.01527f
C3375 6to4_0.buff_PI_d32_2.buff_PI_d16$1_0.inv_PI_d4$1_0.VOUT.n2 VSS 0.18487f
C3376 6to4_0.buff_PI_d32_2.buff_PI_d16$1_0.inv_PI_d4$1_0.VOUT.t13 VSS 0.1872f
C3377 6to4_0.buff_PI_d32_2.buff_PI_d16$1_0.inv_PI_d4$1_0.VOUT.n3 VSS 0.01119f
C3378 6to4_0.buff_PI_d32_2.buff_PI_d16$1_0.inv_PI_d4$1_0.VOUT.n4 VSS 0.11896f
C3379 6to4_0.buff_PI_d32_2.buff_PI_d16$1_0.inv_PI_d4$1_0.VOUT.t14 VSS 0.1872f
C3380 6to4_0.buff_PI_d32_2.buff_PI_d16$1_0.inv_PI_d4$1_0.VOUT.n5 VSS 0.01527f
C3381 6to4_0.buff_PI_d32_2.buff_PI_d16$1_0.inv_PI_d4$1_0.VOUT.n6 VSS 0.11896f
C3382 6to4_0.buff_PI_d32_2.buff_PI_d16$1_0.inv_PI_d4$1_0.VOUT.t19 VSS 0.1872f
C3383 6to4_0.buff_PI_d32_2.buff_PI_d16$1_0.inv_PI_d4$1_0.VOUT.n7 VSS 0.01119f
C3384 6to4_0.buff_PI_d32_2.buff_PI_d16$1_0.inv_PI_d4$1_0.VOUT.n8 VSS 0.11896f
C3385 6to4_0.buff_PI_d32_2.buff_PI_d16$1_0.inv_PI_d4$1_0.VOUT.t15 VSS 0.1872f
C3386 6to4_0.buff_PI_d32_2.buff_PI_d16$1_0.inv_PI_d4$1_0.VOUT.n9 VSS 0.01527f
C3387 6to4_0.buff_PI_d32_2.buff_PI_d16$1_0.inv_PI_d4$1_0.VOUT.n10 VSS 0.11896f
C3388 6to4_0.buff_PI_d32_2.buff_PI_d16$1_0.inv_PI_d4$1_0.VOUT.t17 VSS 0.1872f
C3389 6to4_0.buff_PI_d32_2.buff_PI_d16$1_0.inv_PI_d4$1_0.VOUT.n11 VSS 0.01119f
C3390 6to4_0.buff_PI_d32_2.buff_PI_d16$1_0.inv_PI_d4$1_0.VOUT.n12 VSS 0.11896f
C3391 6to4_0.buff_PI_d32_2.buff_PI_d16$1_0.inv_PI_d4$1_0.VOUT.t18 VSS 0.1872f
C3392 6to4_0.buff_PI_d32_2.buff_PI_d16$1_0.inv_PI_d4$1_0.VOUT.n13 VSS 0.01527f
C3393 6to4_0.buff_PI_d32_2.buff_PI_d16$1_0.inv_PI_d4$1_0.VOUT.n14 VSS 0.27467f
C3394 6to4_0.buff_PI_d32_2.buff_PI_d16$1_0.inv_PI_d4$1_0.VOUT.n15 VSS 0.11905f
C3395 6to4_0.buff_PI_d32_2.buff_PI_d16$1_0.inv_PI_d4$1_0.VOUT.t6 VSS 0.02286f
C3396 6to4_0.buff_PI_d32_2.buff_PI_d16$1_0.inv_PI_d4$1_0.VOUT.t9 VSS 0.02286f
C3397 6to4_0.buff_PI_d32_2.buff_PI_d16$1_0.inv_PI_d4$1_0.VOUT.t1 VSS 0.02582f
C3398 6to4_0.buff_PI_d32_2.buff_PI_d16$1_0.inv_PI_d4$1_0.VOUT.t4 VSS 0.02523f
C3399 6to4_0.buff_PI_d32_2.buff_PI_d16$1_0.inv_PI_d4$1_0.VOUT.t10 VSS 0.02523f
C3400 6to4_0.buff_PI_d32_2.buff_PI_d16$1_0.inv_PI_d4$1_0.VOUT.t0 VSS 0.02582f
C3401 6to4_0.buff_PI_d32_2.buff_PI_d16$1_0.inv_PI_d4$1_0.VOUT.t8 VSS 0.02286f
C3402 6to4_0.buff_PI_d32_2.buff_PI_d16$1_0.inv_PI_d4$1_0.VOUT.t11 VSS 0.02286f
C3403 6to4_0.buff_PI_d32_2.buff_PI_d16$1_0.inv_PI_d4$1_0.VOUT.t2 VSS 0.02582f
C3404 6to4_0.buff_PI_d32_2.buff_PI_d16$1_0.inv_PI_d4$1_0.VOUT.t5 VSS 0.02575f
C3405 6to4_0.buff_PI_d32_2.buff_PI_d16$1_0.inv_PI_d4$1_0.VOUT.n16 VSS 0.04795f
C3406 6to4_0.buff_PI_d32_2.buff_PI_d16$1_0.inv_PI_d4$1_0.VOUT.n17 VSS 0.04275f
C3407 6to4_0.buff_PI_d32_2.buff_PI_d16$1_0.inv_PI_d4$1_0.VOUT.n18 VSS 0.03334f
C3408 6to4_0.buff_PI_d32_2.buff_PI_d16$1_0.inv_PI_d4$1_0.VOUT.n19 VSS 0.04705f
C3409 6to4_0.buff_PI_d32_2.buff_PI_d16$1_0.inv_PI_d4$1_0.VOUT.n20 VSS 0.06175f
C3410 6to4_0.buff_PI_d32_2.buff_PI_d16$1_0.inv_PI_d4$1_0.VOUT.n21 VSS 0.06175f
C3411 6to4_0.buff_PI_d32_2.buff_PI_d16$1_0.inv_PI_d4$1_0.VOUT.n22 VSS 0.04795f
C3412 6to4_0.buff_PI_d32_2.buff_PI_d16$1_0.inv_PI_d4$1_0.VOUT.n23 VSS 0.04275f
C3413 6to4_0.buff_PI_d32_2.buff_PI_d16$1_0.inv_PI_d4$1_0.VOUT.n24 VSS 0.03334f
C3414 6to4_0.buff_PI_d32_2.buff_PI_d16$1_0.inv_PI_d4$1_0.VOUT.t3 VSS 0.02582f
C3415 6to4_0.buff_PI_d32_2.buff_PI_d16$1_0.inv_PI_d4$1_0.VOUT.n25 VSS 0.04705f
C3416 6to4_0.buff_PI_d32_3.buff_PI_d16$1_0.inv_PI_d4$1_0.VOUT.t5 VSS 0.02523f
C3417 6to4_0.buff_PI_d32_3.buff_PI_d16$1_0.inv_PI_d4$1_0.VOUT.t12 VSS 0.1872f
C3418 6to4_0.buff_PI_d32_3.buff_PI_d16$1_0.inv_PI_d4$1_0.VOUT.n0 VSS 0.02105f
C3419 6to4_0.buff_PI_d32_3.buff_PI_d16$1_0.inv_PI_d4$1_0.VOUT.t17 VSS 0.1872f
C3420 6to4_0.buff_PI_d32_3.buff_PI_d16$1_0.inv_PI_d4$1_0.VOUT.n1 VSS 0.01527f
C3421 6to4_0.buff_PI_d32_3.buff_PI_d16$1_0.inv_PI_d4$1_0.VOUT.n2 VSS 0.18487f
C3422 6to4_0.buff_PI_d32_3.buff_PI_d16$1_0.inv_PI_d4$1_0.VOUT.t13 VSS 0.1872f
C3423 6to4_0.buff_PI_d32_3.buff_PI_d16$1_0.inv_PI_d4$1_0.VOUT.n3 VSS 0.01119f
C3424 6to4_0.buff_PI_d32_3.buff_PI_d16$1_0.inv_PI_d4$1_0.VOUT.n4 VSS 0.11896f
C3425 6to4_0.buff_PI_d32_3.buff_PI_d16$1_0.inv_PI_d4$1_0.VOUT.t16 VSS 0.1872f
C3426 6to4_0.buff_PI_d32_3.buff_PI_d16$1_0.inv_PI_d4$1_0.VOUT.n5 VSS 0.01527f
C3427 6to4_0.buff_PI_d32_3.buff_PI_d16$1_0.inv_PI_d4$1_0.VOUT.n6 VSS 0.11896f
C3428 6to4_0.buff_PI_d32_3.buff_PI_d16$1_0.inv_PI_d4$1_0.VOUT.t15 VSS 0.1872f
C3429 6to4_0.buff_PI_d32_3.buff_PI_d16$1_0.inv_PI_d4$1_0.VOUT.n7 VSS 0.01119f
C3430 6to4_0.buff_PI_d32_3.buff_PI_d16$1_0.inv_PI_d4$1_0.VOUT.n8 VSS 0.11896f
C3431 6to4_0.buff_PI_d32_3.buff_PI_d16$1_0.inv_PI_d4$1_0.VOUT.t19 VSS 0.1872f
C3432 6to4_0.buff_PI_d32_3.buff_PI_d16$1_0.inv_PI_d4$1_0.VOUT.n9 VSS 0.01527f
C3433 6to4_0.buff_PI_d32_3.buff_PI_d16$1_0.inv_PI_d4$1_0.VOUT.n10 VSS 0.11896f
C3434 6to4_0.buff_PI_d32_3.buff_PI_d16$1_0.inv_PI_d4$1_0.VOUT.t14 VSS 0.1872f
C3435 6to4_0.buff_PI_d32_3.buff_PI_d16$1_0.inv_PI_d4$1_0.VOUT.n11 VSS 0.01119f
C3436 6to4_0.buff_PI_d32_3.buff_PI_d16$1_0.inv_PI_d4$1_0.VOUT.n12 VSS 0.11896f
C3437 6to4_0.buff_PI_d32_3.buff_PI_d16$1_0.inv_PI_d4$1_0.VOUT.t18 VSS 0.1872f
C3438 6to4_0.buff_PI_d32_3.buff_PI_d16$1_0.inv_PI_d4$1_0.VOUT.n13 VSS 0.01527f
C3439 6to4_0.buff_PI_d32_3.buff_PI_d16$1_0.inv_PI_d4$1_0.VOUT.n14 VSS 0.27467f
C3440 6to4_0.buff_PI_d32_3.buff_PI_d16$1_0.inv_PI_d4$1_0.VOUT.n15 VSS 0.11905f
C3441 6to4_0.buff_PI_d32_3.buff_PI_d16$1_0.inv_PI_d4$1_0.VOUT.t2 VSS 0.02582f
C3442 6to4_0.buff_PI_d32_3.buff_PI_d16$1_0.inv_PI_d4$1_0.VOUT.t8 VSS 0.02286f
C3443 6to4_0.buff_PI_d32_3.buff_PI_d16$1_0.inv_PI_d4$1_0.VOUT.t4 VSS 0.02286f
C3444 6to4_0.buff_PI_d32_3.buff_PI_d16$1_0.inv_PI_d4$1_0.VOUT.t0 VSS 0.02582f
C3445 6to4_0.buff_PI_d32_3.buff_PI_d16$1_0.inv_PI_d4$1_0.VOUT.t7 VSS 0.02523f
C3446 6to4_0.buff_PI_d32_3.buff_PI_d16$1_0.inv_PI_d4$1_0.VOUT.t10 VSS 0.02523f
C3447 6to4_0.buff_PI_d32_3.buff_PI_d16$1_0.inv_PI_d4$1_0.VOUT.t1 VSS 0.02582f
C3448 6to4_0.buff_PI_d32_3.buff_PI_d16$1_0.inv_PI_d4$1_0.VOUT.t6 VSS 0.02286f
C3449 6to4_0.buff_PI_d32_3.buff_PI_d16$1_0.inv_PI_d4$1_0.VOUT.t11 VSS 0.02286f
C3450 6to4_0.buff_PI_d32_3.buff_PI_d16$1_0.inv_PI_d4$1_0.VOUT.t9 VSS 0.02575f
C3451 6to4_0.buff_PI_d32_3.buff_PI_d16$1_0.inv_PI_d4$1_0.VOUT.t3 VSS 0.02582f
C3452 6to4_0.buff_PI_d32_3.buff_PI_d16$1_0.inv_PI_d4$1_0.VOUT.n16 VSS 0.04795f
C3453 6to4_0.buff_PI_d32_3.buff_PI_d16$1_0.inv_PI_d4$1_0.VOUT.n17 VSS 0.04275f
C3454 6to4_0.buff_PI_d32_3.buff_PI_d16$1_0.inv_PI_d4$1_0.VOUT.n18 VSS 0.03334f
C3455 6to4_0.buff_PI_d32_3.buff_PI_d16$1_0.inv_PI_d4$1_0.VOUT.n19 VSS 0.04705f
C3456 6to4_0.buff_PI_d32_3.buff_PI_d16$1_0.inv_PI_d4$1_0.VOUT.n20 VSS 0.06175f
C3457 6to4_0.buff_PI_d32_3.buff_PI_d16$1_0.inv_PI_d4$1_0.VOUT.n21 VSS 0.06175f
C3458 6to4_0.buff_PI_d32_3.buff_PI_d16$1_0.inv_PI_d4$1_0.VOUT.n22 VSS 0.04795f
C3459 6to4_0.buff_PI_d32_3.buff_PI_d16$1_0.inv_PI_d4$1_0.VOUT.n23 VSS 0.04275f
C3460 6to4_0.buff_PI_d32_3.buff_PI_d16$1_0.inv_PI_d4$1_0.VOUT.n24 VSS 0.03334f
C3461 6to4_0.buff_PI_d32_3.buff_PI_d16$1_0.inv_PI_d4$1_0.VOUT.n25 VSS 0.04705f
C3462 PH270.t71 VSS 0.05505f
C3463 PH270.t41 VSS 0.05505f
C3464 PH270.t15 VSS 0.05633f
C3465 PH270.t43 VSS 0.04987f
C3466 PH270.t61 VSS 0.04987f
C3467 PH270.t1 VSS 0.05633f
C3468 PH270.t55 VSS 0.05505f
C3469 PH270.t37 VSS 0.05505f
C3470 PH270.t30 VSS 0.05633f
C3471 PH270.t56 VSS 0.04987f
C3472 PH270.t79 VSS 0.04987f
C3473 PH270.t18 VSS 0.05633f
C3474 PH270.t69 VSS 0.05505f
C3475 PH270.t86 VSS 0.05505f
C3476 PH270.t25 VSS 0.05633f
C3477 PH270.t88 VSS 0.04987f
C3478 PH270.t33 VSS 0.04987f
C3479 PH270.t6 VSS 0.05633f
C3480 PH270.t72 VSS 0.05505f
C3481 PH270.t54 VSS 0.05505f
C3482 PH270.t8 VSS 0.05633f
C3483 PH270.t93 VSS 0.04987f
C3484 PH270.t48 VSS 0.04987f
C3485 PH270.t19 VSS 0.05633f
C3486 PH270.t81 VSS 0.05617f
C3487 PH270.n0 VSS 0.10462f
C3488 PH270.n1 VSS 0.09327f
C3489 PH270.n2 VSS 0.07274f
C3490 PH270.n3 VSS 0.10264f
C3491 PH270.n4 VSS 0.13472f
C3492 PH270.n5 VSS 0.13472f
C3493 PH270.n6 VSS 0.10462f
C3494 PH270.n7 VSS 0.09327f
C3495 PH270.n8 VSS 0.07274f
C3496 PH270.n9 VSS 0.10264f
C3497 PH270.n10 VSS 0.12228f
C3498 PH270.n11 VSS 0.13472f
C3499 PH270.n12 VSS 0.10462f
C3500 PH270.n13 VSS 0.09327f
C3501 PH270.n14 VSS 0.07274f
C3502 PH270.n15 VSS 0.10264f
C3503 PH270.n16 VSS 0.13472f
C3504 PH270.n17 VSS 0.13472f
C3505 PH270.n18 VSS 0.10462f
C3506 PH270.n19 VSS 0.09327f
C3507 PH270.n20 VSS 0.07274f
C3508 PH270.n21 VSS 0.10264f
C3509 PH270.n22 VSS 0.16463f
C3510 PH270.t64 VSS 0.05505f
C3511 PH270.t28 VSS 0.05633f
C3512 PH270.t91 VSS 0.04987f
C3513 PH270.t49 VSS 0.04987f
C3514 PH270.t16 VSS 0.05633f
C3515 PH270.t40 VSS 0.05505f
C3516 PH270.t66 VSS 0.05505f
C3517 PH270.t26 VSS 0.05633f
C3518 PH270.t42 VSS 0.04987f
C3519 PH270.t68 VSS 0.04987f
C3520 PH270.t3 VSS 0.05633f
C3521 PH270.t53 VSS 0.05505f
C3522 PH270.t76 VSS 0.05505f
C3523 PH270.t14 VSS 0.05633f
C3524 PH270.t78 VSS 0.04987f
C3525 PH270.t89 VSS 0.04987f
C3526 PH270.t24 VSS 0.05633f
C3527 PH270.t57 VSS 0.05505f
C3528 PH270.t39 VSS 0.05505f
C3529 PH270.t23 VSS 0.05633f
C3530 PH270.t87 VSS 0.04987f
C3531 PH270.t95 VSS 0.04987f
C3532 PH270.t4 VSS 0.05633f
C3533 PH270.t70 VSS 0.05617f
C3534 PH270.n23 VSS 0.10462f
C3535 PH270.n24 VSS 0.09327f
C3536 PH270.n25 VSS 0.07274f
C3537 PH270.n26 VSS 0.10264f
C3538 PH270.n27 VSS 0.13472f
C3539 PH270.n28 VSS 0.13472f
C3540 PH270.n29 VSS 0.10462f
C3541 PH270.n30 VSS 0.09327f
C3542 PH270.n31 VSS 0.07274f
C3543 PH270.n32 VSS 0.10264f
C3544 PH270.n33 VSS 0.12228f
C3545 PH270.n34 VSS 0.13472f
C3546 PH270.n35 VSS 0.10462f
C3547 PH270.n36 VSS 0.09327f
C3548 PH270.n37 VSS 0.07274f
C3549 PH270.n38 VSS 0.10264f
C3550 PH270.n39 VSS 0.13472f
C3551 PH270.n40 VSS 0.13472f
C3552 PH270.n41 VSS 0.10462f
C3553 PH270.n42 VSS 0.09327f
C3554 PH270.n43 VSS 0.07274f
C3555 PH270.n44 VSS 0.10264f
C3556 PH270.n45 VSS 0.16463f
C3557 PH270.t46 VSS 0.05505f
C3558 PH270.t20 VSS 0.05633f
C3559 PH270.t83 VSS 0.04987f
C3560 PH270.t92 VSS 0.04987f
C3561 PH270.t0 VSS 0.05633f
C3562 PH270.t65 VSS 0.05505f
C3563 PH270.t50 VSS 0.05505f
C3564 PH270.t17 VSS 0.05633f
C3565 PH270.t90 VSS 0.04987f
C3566 PH270.t51 VSS 0.04987f
C3567 PH270.t10 VSS 0.05633f
C3568 PH270.t34 VSS 0.05505f
C3569 PH270.t60 VSS 0.05505f
C3570 PH270.t11 VSS 0.05633f
C3571 PH270.t63 VSS 0.04987f
C3572 PH270.t77 VSS 0.04987f
C3573 PH270.t13 VSS 0.05633f
C3574 PH270.t36 VSS 0.05505f
C3575 PH270.t38 VSS 0.05505f
C3576 PH270.t9 VSS 0.05633f
C3577 PH270.t75 VSS 0.04987f
C3578 PH270.t85 VSS 0.04987f
C3579 PH270.t21 VSS 0.05633f
C3580 PH270.t52 VSS 0.05617f
C3581 PH270.n46 VSS 0.10462f
C3582 PH270.n47 VSS 0.09327f
C3583 PH270.n48 VSS 0.07274f
C3584 PH270.n49 VSS 0.10264f
C3585 PH270.n50 VSS 0.13472f
C3586 PH270.n51 VSS 0.13472f
C3587 PH270.n52 VSS 0.10462f
C3588 PH270.n53 VSS 0.09327f
C3589 PH270.n54 VSS 0.07274f
C3590 PH270.n55 VSS 0.10264f
C3591 PH270.n56 VSS 0.12228f
C3592 PH270.n57 VSS 0.13472f
C3593 PH270.n58 VSS 0.10462f
C3594 PH270.n59 VSS 0.09327f
C3595 PH270.n60 VSS 0.07274f
C3596 PH270.n61 VSS 0.10264f
C3597 PH270.n62 VSS 0.13472f
C3598 PH270.n63 VSS 0.13472f
C3599 PH270.n64 VSS 0.10462f
C3600 PH270.n65 VSS 0.09327f
C3601 PH270.n66 VSS 0.07274f
C3602 PH270.n67 VSS 0.10264f
C3603 PH270.n68 VSS 0.16463f
C3604 PH270.n69 VSS 0.16759f
C3605 PH270.t7 VSS 0.05633f
C3606 PH270.t73 VSS 0.04987f
C3607 PH270.t84 VSS 0.04987f
C3608 PH270.t22 VSS 0.05633f
C3609 PH270.t47 VSS 0.05505f
C3610 PH270.t67 VSS 0.05505f
C3611 PH270.t5 VSS 0.05633f
C3612 PH270.t82 VSS 0.04987f
C3613 PH270.t94 VSS 0.04987f
C3614 PH270.t29 VSS 0.05633f
C3615 PH270.t59 VSS 0.05505f
C3616 PH270.t44 VSS 0.05505f
C3617 PH270.t45 VSS 0.04987f
C3618 PH270.t62 VSS 0.04987f
C3619 PH270.t2 VSS 0.05633f
C3620 PH270.t35 VSS 0.05505f
C3621 PH270.t80 VSS 0.05505f
C3622 PH270.t27 VSS 0.05633f
C3623 PH270.t58 VSS 0.04987f
C3624 PH270.t74 VSS 0.04987f
C3625 PH270.t12 VSS 0.05633f
C3626 PH270.t32 VSS 0.05617f
C3627 PH270.n70 VSS 0.10462f
C3628 PH270.n71 VSS 0.09327f
C3629 PH270.n72 VSS 0.07274f
C3630 PH270.n73 VSS 0.10264f
C3631 PH270.n74 VSS 0.13472f
C3632 PH270.n75 VSS 0.13472f
C3633 PH270.n76 VSS 0.10462f
C3634 PH270.n77 VSS 0.09327f
C3635 PH270.n78 VSS 0.07274f
C3636 PH270.t31 VSS 0.05633f
C3637 PH270.n79 VSS 0.10264f
C3638 PH270.n80 VSS 0.12228f
C3639 PH270.n81 VSS 0.13472f
C3640 PH270.n82 VSS 0.10462f
C3641 PH270.n83 VSS 0.09327f
C3642 PH270.n84 VSS 0.07274f
C3643 PH270.n85 VSS 0.10264f
C3644 PH270.n86 VSS 0.13472f
C3645 PH270.n87 VSS 0.13472f
C3646 PH270.n88 VSS 0.10462f
C3647 PH270.n89 VSS 0.09327f
C3648 PH270.n90 VSS 0.07274f
C3649 PH270.n91 VSS 0.10264f
C3650 6to4_0.buff_PI_d32_2.inv_PI_d32_0.VIN.t32 VSS 0.04054f
C3651 6to4_0.buff_PI_d32_2.inv_PI_d32_0.VIN.t68 VSS 0.30076f
C3652 6to4_0.buff_PI_d32_2.inv_PI_d32_0.VIN.n0 VSS 0.01799f
C3653 6to4_0.buff_PI_d32_2.inv_PI_d32_0.VIN.n1 VSS 0.15933f
C3654 6to4_0.buff_PI_d32_2.inv_PI_d32_0.VIN.t52 VSS 0.30076f
C3655 6to4_0.buff_PI_d32_2.inv_PI_d32_0.VIN.n2 VSS 0.01799f
C3656 6to4_0.buff_PI_d32_2.inv_PI_d32_0.VIN.n3 VSS 0.14298f
C3657 6to4_0.buff_PI_d32_2.inv_PI_d32_0.VIN.t51 VSS 0.30076f
C3658 6to4_0.buff_PI_d32_2.inv_PI_d32_0.VIN.n4 VSS 0.02453f
C3659 6to4_0.buff_PI_d32_2.inv_PI_d32_0.VIN.n5 VSS 0.1428f
C3660 6to4_0.buff_PI_d32_2.inv_PI_d32_0.VIN.t70 VSS 0.30076f
C3661 6to4_0.buff_PI_d32_2.inv_PI_d32_0.VIN.n6 VSS 0.01799f
C3662 6to4_0.buff_PI_d32_2.inv_PI_d32_0.VIN.n7 VSS 0.14298f
C3663 6to4_0.buff_PI_d32_2.inv_PI_d32_0.VIN.t72 VSS 0.30076f
C3664 6to4_0.buff_PI_d32_2.inv_PI_d32_0.VIN.n8 VSS 0.02453f
C3665 6to4_0.buff_PI_d32_2.inv_PI_d32_0.VIN.n9 VSS 0.1428f
C3666 6to4_0.buff_PI_d32_2.inv_PI_d32_0.VIN.t73 VSS 0.30076f
C3667 6to4_0.buff_PI_d32_2.inv_PI_d32_0.VIN.n10 VSS 0.01799f
C3668 6to4_0.buff_PI_d32_2.inv_PI_d32_0.VIN.n11 VSS 0.14298f
C3669 6to4_0.buff_PI_d32_2.inv_PI_d32_0.VIN.t75 VSS 0.30076f
C3670 6to4_0.buff_PI_d32_2.inv_PI_d32_0.VIN.n12 VSS 0.04037f
C3671 6to4_0.buff_PI_d32_2.inv_PI_d32_0.VIN.t71 VSS 0.30076f
C3672 6to4_0.buff_PI_d32_2.inv_PI_d32_0.VIN.n13 VSS 0.01799f
C3673 6to4_0.buff_PI_d32_2.inv_PI_d32_0.VIN.n14 VSS 0.24886f
C3674 6to4_0.buff_PI_d32_2.inv_PI_d32_0.VIN.t63 VSS 0.30076f
C3675 6to4_0.buff_PI_d32_2.inv_PI_d32_0.VIN.n15 VSS 0.02453f
C3676 6to4_0.buff_PI_d32_2.inv_PI_d32_0.VIN.n16 VSS 0.1428f
C3677 6to4_0.buff_PI_d32_2.inv_PI_d32_0.VIN.t49 VSS 0.30076f
C3678 6to4_0.buff_PI_d32_2.inv_PI_d32_0.VIN.n17 VSS 0.04037f
C3679 6to4_0.buff_PI_d32_2.inv_PI_d32_0.VIN.t74 VSS 0.30076f
C3680 6to4_0.buff_PI_d32_2.inv_PI_d32_0.VIN.n18 VSS 0.01799f
C3681 6to4_0.buff_PI_d32_2.inv_PI_d32_0.VIN.n19 VSS 0.24886f
C3682 6to4_0.buff_PI_d32_2.inv_PI_d32_0.VIN.t64 VSS 0.30076f
C3683 6to4_0.buff_PI_d32_2.inv_PI_d32_0.VIN.n20 VSS 0.02453f
C3684 6to4_0.buff_PI_d32_2.inv_PI_d32_0.VIN.n21 VSS 0.1428f
C3685 6to4_0.buff_PI_d32_2.inv_PI_d32_0.VIN.t76 VSS 0.30076f
C3686 6to4_0.buff_PI_d32_2.inv_PI_d32_0.VIN.n22 VSS 0.04037f
C3687 6to4_0.buff_PI_d32_2.inv_PI_d32_0.VIN.t58 VSS 0.30076f
C3688 6to4_0.buff_PI_d32_2.inv_PI_d32_0.VIN.n23 VSS 0.01799f
C3689 6to4_0.buff_PI_d32_2.inv_PI_d32_0.VIN.n24 VSS 0.24886f
C3690 6to4_0.buff_PI_d32_2.inv_PI_d32_0.VIN.t60 VSS 0.30076f
C3691 6to4_0.buff_PI_d32_2.inv_PI_d32_0.VIN.n25 VSS 0.04037f
C3692 6to4_0.buff_PI_d32_2.inv_PI_d32_0.VIN.t69 VSS 0.30076f
C3693 6to4_0.buff_PI_d32_2.inv_PI_d32_0.VIN.n26 VSS 0.01799f
C3694 6to4_0.buff_PI_d32_2.inv_PI_d32_0.VIN.n27 VSS 0.24886f
C3695 6to4_0.buff_PI_d32_2.inv_PI_d32_0.VIN.t56 VSS 0.30076f
C3696 6to4_0.buff_PI_d32_2.inv_PI_d32_0.VIN.n28 VSS 0.02453f
C3697 6to4_0.buff_PI_d32_2.inv_PI_d32_0.VIN.n29 VSS 0.1428f
C3698 6to4_0.buff_PI_d32_2.inv_PI_d32_0.VIN.n30 VSS 0.36966f
C3699 6to4_0.buff_PI_d32_2.inv_PI_d32_0.VIN.n31 VSS 0.64286f
C3700 6to4_0.buff_PI_d32_2.inv_PI_d32_0.VIN.n32 VSS 0.64286f
C3701 6to4_0.buff_PI_d32_2.inv_PI_d32_0.VIN.n33 VSS 0.36966f
C3702 6to4_0.buff_PI_d32_2.inv_PI_d32_0.VIN.t59 VSS 0.30076f
C3703 6to4_0.buff_PI_d32_2.inv_PI_d32_0.VIN.n34 VSS 0.02453f
C3704 6to4_0.buff_PI_d32_2.inv_PI_d32_0.VIN.n35 VSS 0.1428f
C3705 6to4_0.buff_PI_d32_2.inv_PI_d32_0.VIN.t54 VSS 0.30076f
C3706 6to4_0.buff_PI_d32_2.inv_PI_d32_0.VIN.n36 VSS 0.01799f
C3707 6to4_0.buff_PI_d32_2.inv_PI_d32_0.VIN.n37 VSS 0.14298f
C3708 6to4_0.buff_PI_d32_2.inv_PI_d32_0.VIN.t66 VSS 0.30076f
C3709 6to4_0.buff_PI_d32_2.inv_PI_d32_0.VIN.n38 VSS 0.03383f
C3710 6to4_0.buff_PI_d32_2.inv_PI_d32_0.VIN.t57 VSS 0.30076f
C3711 6to4_0.buff_PI_d32_2.inv_PI_d32_0.VIN.n39 VSS 0.02453f
C3712 6to4_0.buff_PI_d32_2.inv_PI_d32_0.VIN.n40 VSS 0.24868f
C3713 6to4_0.buff_PI_d32_2.inv_PI_d32_0.VIN.t50 VSS 0.30076f
C3714 6to4_0.buff_PI_d32_2.inv_PI_d32_0.VIN.n41 VSS 0.03383f
C3715 6to4_0.buff_PI_d32_2.inv_PI_d32_0.VIN.t61 VSS 0.30076f
C3716 6to4_0.buff_PI_d32_2.inv_PI_d32_0.VIN.n42 VSS 0.02453f
C3717 6to4_0.buff_PI_d32_2.inv_PI_d32_0.VIN.n43 VSS 0.2485f
C3718 6to4_0.buff_PI_d32_2.inv_PI_d32_0.VIN.t62 VSS 0.30076f
C3719 6to4_0.buff_PI_d32_2.inv_PI_d32_0.VIN.n44 VSS 0.01799f
C3720 6to4_0.buff_PI_d32_2.inv_PI_d32_0.VIN.n45 VSS 0.14298f
C3721 6to4_0.buff_PI_d32_2.inv_PI_d32_0.VIN.t78 VSS 0.30076f
C3722 6to4_0.buff_PI_d32_2.inv_PI_d32_0.VIN.n46 VSS 0.01799f
C3723 6to4_0.buff_PI_d32_2.inv_PI_d32_0.VIN.n47 VSS 0.14298f
C3724 6to4_0.buff_PI_d32_2.inv_PI_d32_0.VIN.t65 VSS 0.30076f
C3725 6to4_0.buff_PI_d32_2.inv_PI_d32_0.VIN.n48 VSS 0.02453f
C3726 6to4_0.buff_PI_d32_2.inv_PI_d32_0.VIN.n49 VSS 0.14262f
C3727 6to4_0.buff_PI_d32_2.inv_PI_d32_0.VIN.n50 VSS 0.13542f
C3728 6to4_0.buff_PI_d32_2.inv_PI_d32_0.VIN.n51 VSS 0.07994f
C3729 6to4_0.buff_PI_d32_2.inv_PI_d32_0.VIN.n52 VSS 0.28144f
C3730 6to4_0.buff_PI_d32_2.inv_PI_d32_0.VIN.n53 VSS 0.10804f
C3731 6to4_0.buff_PI_d32_2.inv_PI_d32_0.VIN.t77 VSS 0.30076f
C3732 6to4_0.buff_PI_d32_2.inv_PI_d32_0.VIN.n54 VSS 0.01799f
C3733 6to4_0.buff_PI_d32_2.inv_PI_d32_0.VIN.n55 VSS 0.14298f
C3734 6to4_0.buff_PI_d32_2.inv_PI_d32_0.VIN.t53 VSS 0.30076f
C3735 6to4_0.buff_PI_d32_2.inv_PI_d32_0.VIN.n56 VSS 0.02453f
C3736 6to4_0.buff_PI_d32_2.inv_PI_d32_0.VIN.n57 VSS 0.1428f
C3737 6to4_0.buff_PI_d32_2.inv_PI_d32_0.VIN.n58 VSS 0.36966f
C3738 6to4_0.buff_PI_d32_2.inv_PI_d32_0.VIN.n59 VSS 0.64286f
C3739 6to4_0.buff_PI_d32_2.inv_PI_d32_0.VIN.n60 VSS 0.64286f
C3740 6to4_0.buff_PI_d32_2.inv_PI_d32_0.VIN.n61 VSS 0.36966f
C3741 6to4_0.buff_PI_d32_2.inv_PI_d32_0.VIN.t48 VSS 0.30076f
C3742 6to4_0.buff_PI_d32_2.inv_PI_d32_0.VIN.n62 VSS 0.02453f
C3743 6to4_0.buff_PI_d32_2.inv_PI_d32_0.VIN.n63 VSS 0.1428f
C3744 6to4_0.buff_PI_d32_2.inv_PI_d32_0.VIN.t67 VSS 0.30076f
C3745 6to4_0.buff_PI_d32_2.inv_PI_d32_0.VIN.n64 VSS 0.01799f
C3746 6to4_0.buff_PI_d32_2.inv_PI_d32_0.VIN.n65 VSS 0.14298f
C3747 6to4_0.buff_PI_d32_2.inv_PI_d32_0.VIN.n66 VSS 0.10514f
C3748 6to4_0.buff_PI_d32_2.inv_PI_d32_0.VIN.t55 VSS 0.30076f
C3749 6to4_0.buff_PI_d32_2.inv_PI_d32_0.VIN.n67 VSS 0.02453f
C3750 6to4_0.buff_PI_d32_2.inv_PI_d32_0.VIN.n68 VSS 0.1428f
C3751 6to4_0.buff_PI_d32_2.inv_PI_d32_0.VIN.t79 VSS 0.30076f
C3752 6to4_0.buff_PI_d32_2.inv_PI_d32_0.VIN.n69 VSS 0.01799f
C3753 6to4_0.buff_PI_d32_2.inv_PI_d32_0.VIN.n70 VSS 0.15986f
C3754 6to4_0.buff_PI_d32_2.inv_PI_d32_0.VIN.t34 VSS 0.04054f
C3755 6to4_0.buff_PI_d32_2.inv_PI_d32_0.VIN.t33 VSS 0.04148f
C3756 6to4_0.buff_PI_d32_2.inv_PI_d32_0.VIN.t35 VSS 0.03672f
C3757 6to4_0.buff_PI_d32_2.inv_PI_d32_0.VIN.t22 VSS 0.03672f
C3758 6to4_0.buff_PI_d32_2.inv_PI_d32_0.VIN.t21 VSS 0.04148f
C3759 6to4_0.buff_PI_d32_2.inv_PI_d32_0.VIN.t23 VSS 0.04054f
C3760 6to4_0.buff_PI_d32_2.inv_PI_d32_0.VIN.t43 VSS 0.04054f
C3761 6to4_0.buff_PI_d32_2.inv_PI_d32_0.VIN.t42 VSS 0.04148f
C3762 6to4_0.buff_PI_d32_2.inv_PI_d32_0.VIN.t44 VSS 0.03672f
C3763 6to4_0.buff_PI_d32_2.inv_PI_d32_0.VIN.t28 VSS 0.03672f
C3764 6to4_0.buff_PI_d32_2.inv_PI_d32_0.VIN.t27 VSS 0.04148f
C3765 6to4_0.buff_PI_d32_2.inv_PI_d32_0.VIN.t29 VSS 0.04054f
C3766 6to4_0.buff_PI_d32_2.inv_PI_d32_0.VIN.t25 VSS 0.04054f
C3767 6to4_0.buff_PI_d32_2.inv_PI_d32_0.VIN.t24 VSS 0.04148f
C3768 6to4_0.buff_PI_d32_2.inv_PI_d32_0.VIN.t26 VSS 0.03672f
C3769 6to4_0.buff_PI_d32_2.inv_PI_d32_0.VIN.t14 VSS 0.03672f
C3770 6to4_0.buff_PI_d32_2.inv_PI_d32_0.VIN.t12 VSS 0.04148f
C3771 6to4_0.buff_PI_d32_2.inv_PI_d32_0.VIN.t13 VSS 0.04054f
C3772 6to4_0.buff_PI_d32_2.inv_PI_d32_0.VIN.t11 VSS 0.04054f
C3773 6to4_0.buff_PI_d32_2.inv_PI_d32_0.VIN.t9 VSS 0.04148f
C3774 6to4_0.buff_PI_d32_2.inv_PI_d32_0.VIN.t10 VSS 0.03672f
C3775 6to4_0.buff_PI_d32_2.inv_PI_d32_0.VIN.t41 VSS 0.03672f
C3776 6to4_0.buff_PI_d32_2.inv_PI_d32_0.VIN.t39 VSS 0.04148f
C3777 6to4_0.buff_PI_d32_2.inv_PI_d32_0.VIN.t40 VSS 0.04136f
C3778 6to4_0.buff_PI_d32_2.inv_PI_d32_0.VIN.n71 VSS 0.07704f
C3779 6to4_0.buff_PI_d32_2.inv_PI_d32_0.VIN.n72 VSS 0.06869f
C3780 6to4_0.buff_PI_d32_2.inv_PI_d32_0.VIN.n73 VSS 0.05357f
C3781 6to4_0.buff_PI_d32_2.inv_PI_d32_0.VIN.n74 VSS 0.07559f
C3782 6to4_0.buff_PI_d32_2.inv_PI_d32_0.VIN.n75 VSS 0.09921f
C3783 6to4_0.buff_PI_d32_2.inv_PI_d32_0.VIN.n76 VSS 0.09921f
C3784 6to4_0.buff_PI_d32_2.inv_PI_d32_0.VIN.n77 VSS 0.07704f
C3785 6to4_0.buff_PI_d32_2.inv_PI_d32_0.VIN.n78 VSS 0.06869f
C3786 6to4_0.buff_PI_d32_2.inv_PI_d32_0.VIN.n79 VSS 0.05357f
C3787 6to4_0.buff_PI_d32_2.inv_PI_d32_0.VIN.n80 VSS 0.07559f
C3788 6to4_0.buff_PI_d32_2.inv_PI_d32_0.VIN.n81 VSS 0.09005f
C3789 6to4_0.buff_PI_d32_2.inv_PI_d32_0.VIN.n82 VSS 0.09921f
C3790 6to4_0.buff_PI_d32_2.inv_PI_d32_0.VIN.n83 VSS 0.07704f
C3791 6to4_0.buff_PI_d32_2.inv_PI_d32_0.VIN.n84 VSS 0.06869f
C3792 6to4_0.buff_PI_d32_2.inv_PI_d32_0.VIN.n85 VSS 0.05357f
C3793 6to4_0.buff_PI_d32_2.inv_PI_d32_0.VIN.n86 VSS 0.07559f
C3794 6to4_0.buff_PI_d32_2.inv_PI_d32_0.VIN.n87 VSS 0.09921f
C3795 6to4_0.buff_PI_d32_2.inv_PI_d32_0.VIN.n88 VSS 0.09921f
C3796 6to4_0.buff_PI_d32_2.inv_PI_d32_0.VIN.n89 VSS 0.07704f
C3797 6to4_0.buff_PI_d32_2.inv_PI_d32_0.VIN.n90 VSS 0.06869f
C3798 6to4_0.buff_PI_d32_2.inv_PI_d32_0.VIN.n91 VSS 0.05357f
C3799 6to4_0.buff_PI_d32_2.inv_PI_d32_0.VIN.n92 VSS 0.07559f
C3800 6to4_0.buff_PI_d32_2.inv_PI_d32_0.VIN.n93 VSS 0.12124f
C3801 6to4_0.buff_PI_d32_2.inv_PI_d32_0.VIN.n94 VSS 0.11609f
C3802 6to4_0.buff_PI_d32_2.inv_PI_d32_0.VIN.n95 VSS 0.14848f
C3803 6to4_0.buff_PI_d32_2.inv_PI_d32_0.VIN.n96 VSS 0.12124f
C3804 6to4_0.buff_PI_d32_2.inv_PI_d32_0.VIN.t30 VSS 0.04148f
C3805 6to4_0.buff_PI_d32_2.inv_PI_d32_0.VIN.t31 VSS 0.03672f
C3806 6to4_0.buff_PI_d32_2.inv_PI_d32_0.VIN.t4 VSS 0.03672f
C3807 6to4_0.buff_PI_d32_2.inv_PI_d32_0.VIN.t3 VSS 0.04148f
C3808 6to4_0.buff_PI_d32_2.inv_PI_d32_0.VIN.t5 VSS 0.04054f
C3809 6to4_0.buff_PI_d32_2.inv_PI_d32_0.VIN.t1 VSS 0.04054f
C3810 6to4_0.buff_PI_d32_2.inv_PI_d32_0.VIN.t2 VSS 0.03672f
C3811 6to4_0.buff_PI_d32_2.inv_PI_d32_0.VIN.t47 VSS 0.03672f
C3812 6to4_0.buff_PI_d32_2.inv_PI_d32_0.VIN.t45 VSS 0.04148f
C3813 6to4_0.buff_PI_d32_2.inv_PI_d32_0.VIN.t46 VSS 0.04054f
C3814 6to4_0.buff_PI_d32_2.inv_PI_d32_0.VIN.t19 VSS 0.04054f
C3815 6to4_0.buff_PI_d32_2.inv_PI_d32_0.VIN.t18 VSS 0.04148f
C3816 6to4_0.buff_PI_d32_2.inv_PI_d32_0.VIN.t20 VSS 0.03672f
C3817 6to4_0.buff_PI_d32_2.inv_PI_d32_0.VIN.t38 VSS 0.03672f
C3818 6to4_0.buff_PI_d32_2.inv_PI_d32_0.VIN.t36 VSS 0.04148f
C3819 6to4_0.buff_PI_d32_2.inv_PI_d32_0.VIN.t37 VSS 0.04054f
C3820 6to4_0.buff_PI_d32_2.inv_PI_d32_0.VIN.t7 VSS 0.04054f
C3821 6to4_0.buff_PI_d32_2.inv_PI_d32_0.VIN.t6 VSS 0.04148f
C3822 6to4_0.buff_PI_d32_2.inv_PI_d32_0.VIN.t8 VSS 0.03672f
C3823 6to4_0.buff_PI_d32_2.inv_PI_d32_0.VIN.t17 VSS 0.03672f
C3824 6to4_0.buff_PI_d32_2.inv_PI_d32_0.VIN.t15 VSS 0.04148f
C3825 6to4_0.buff_PI_d32_2.inv_PI_d32_0.VIN.t16 VSS 0.04136f
C3826 6to4_0.buff_PI_d32_2.inv_PI_d32_0.VIN.n97 VSS 0.07704f
C3827 6to4_0.buff_PI_d32_2.inv_PI_d32_0.VIN.n98 VSS 0.06869f
C3828 6to4_0.buff_PI_d32_2.inv_PI_d32_0.VIN.n99 VSS 0.05357f
C3829 6to4_0.buff_PI_d32_2.inv_PI_d32_0.VIN.n100 VSS 0.07559f
C3830 6to4_0.buff_PI_d32_2.inv_PI_d32_0.VIN.n101 VSS 0.09921f
C3831 6to4_0.buff_PI_d32_2.inv_PI_d32_0.VIN.n102 VSS 0.09921f
C3832 6to4_0.buff_PI_d32_2.inv_PI_d32_0.VIN.n103 VSS 0.07704f
C3833 6to4_0.buff_PI_d32_2.inv_PI_d32_0.VIN.n104 VSS 0.06869f
C3834 6to4_0.buff_PI_d32_2.inv_PI_d32_0.VIN.n105 VSS 0.05357f
C3835 6to4_0.buff_PI_d32_2.inv_PI_d32_0.VIN.n106 VSS 0.07559f
C3836 6to4_0.buff_PI_d32_2.inv_PI_d32_0.VIN.n107 VSS 0.09005f
C3837 6to4_0.buff_PI_d32_2.inv_PI_d32_0.VIN.n108 VSS 0.09921f
C3838 6to4_0.buff_PI_d32_2.inv_PI_d32_0.VIN.n109 VSS 0.07704f
C3839 6to4_0.buff_PI_d32_2.inv_PI_d32_0.VIN.n110 VSS 0.06869f
C3840 6to4_0.buff_PI_d32_2.inv_PI_d32_0.VIN.n111 VSS 0.05357f
C3841 6to4_0.buff_PI_d32_2.inv_PI_d32_0.VIN.t0 VSS 0.04148f
C3842 6to4_0.buff_PI_d32_2.inv_PI_d32_0.VIN.n112 VSS 0.07559f
C3843 6to4_0.buff_PI_d32_2.inv_PI_d32_0.VIN.n113 VSS 0.09921f
C3844 6to4_0.buff_PI_d32_2.inv_PI_d32_0.VIN.n114 VSS 0.09921f
C3845 6to4_0.buff_PI_d32_2.inv_PI_d32_0.VIN.n115 VSS 0.07704f
C3846 6to4_0.buff_PI_d32_2.inv_PI_d32_0.VIN.n116 VSS 0.06869f
C3847 6to4_0.buff_PI_d32_2.inv_PI_d32_0.VIN.n117 VSS 0.05357f
C3848 6to4_0.buff_PI_d32_2.inv_PI_d32_0.VIN.n118 VSS 0.07559f
C3849 PH90.t53 VSS 0.05505f
C3850 PH90.t32 VSS 0.05505f
C3851 PH90.t24 VSS 0.05633f
C3852 PH90.t79 VSS 0.04987f
C3853 PH90.t90 VSS 0.04987f
C3854 PH90.t14 VSS 0.05633f
C3855 PH90.t54 VSS 0.05505f
C3856 PH90.t35 VSS 0.05505f
C3857 PH90.t8 VSS 0.05633f
C3858 PH90.t87 VSS 0.04987f
C3859 PH90.t37 VSS 0.04987f
C3860 PH90.t26 VSS 0.05633f
C3861 PH90.t66 VSS 0.05505f
C3862 PH90.t51 VSS 0.05505f
C3863 PH90.t30 VSS 0.05633f
C3864 PH90.t52 VSS 0.04987f
C3865 PH90.t68 VSS 0.04987f
C3866 PH90.t17 VSS 0.05633f
C3867 PH90.t41 VSS 0.05505f
C3868 PH90.t86 VSS 0.05505f
C3869 PH90.t18 VSS 0.05633f
C3870 PH90.t65 VSS 0.04987f
C3871 PH90.t80 VSS 0.04987f
C3872 PH90.t1 VSS 0.05633f
C3873 PH90.t39 VSS 0.05617f
C3874 PH90.n0 VSS 0.10462f
C3875 PH90.n1 VSS 0.09327f
C3876 PH90.n2 VSS 0.07274f
C3877 PH90.n3 VSS 0.10264f
C3878 PH90.n4 VSS 0.13472f
C3879 PH90.n5 VSS 0.13472f
C3880 PH90.n6 VSS 0.10462f
C3881 PH90.n7 VSS 0.09327f
C3882 PH90.n8 VSS 0.07274f
C3883 PH90.n9 VSS 0.10264f
C3884 PH90.n10 VSS 0.12228f
C3885 PH90.n11 VSS 0.13472f
C3886 PH90.n12 VSS 0.10462f
C3887 PH90.n13 VSS 0.09327f
C3888 PH90.n14 VSS 0.07274f
C3889 PH90.n15 VSS 0.10264f
C3890 PH90.n16 VSS 0.13472f
C3891 PH90.n17 VSS 0.13472f
C3892 PH90.n18 VSS 0.10462f
C3893 PH90.n19 VSS 0.09327f
C3894 PH90.n20 VSS 0.07274f
C3895 PH90.n21 VSS 0.10264f
C3896 PH90.n22 VSS 0.17083f
C3897 PH90.t59 VSS 0.05505f
C3898 PH90.t20 VSS 0.05633f
C3899 PH90.t61 VSS 0.04987f
C3900 PH90.t78 VSS 0.04987f
C3901 PH90.t9 VSS 0.05633f
C3902 PH90.t71 VSS 0.05505f
C3903 PH90.t55 VSS 0.05505f
C3904 PH90.t5 VSS 0.05633f
C3905 PH90.t73 VSS 0.04987f
C3906 PH90.t89 VSS 0.04987f
C3907 PH90.t23 VSS 0.05633f
C3908 PH90.t45 VSS 0.05505f
C3909 PH90.t47 VSS 0.05505f
C3910 PH90.t28 VSS 0.05633f
C3911 PH90.t95 VSS 0.04987f
C3912 PH90.t50 VSS 0.04987f
C3913 PH90.t15 VSS 0.05633f
C3914 PH90.t82 VSS 0.05505f
C3915 PH90.t69 VSS 0.05505f
C3916 PH90.t16 VSS 0.05633f
C3917 PH90.t42 VSS 0.04987f
C3918 PH90.t63 VSS 0.04987f
C3919 PH90.t25 VSS 0.05633f
C3920 PH90.t36 VSS 0.05617f
C3921 PH90.n23 VSS 0.10462f
C3922 PH90.n24 VSS 0.09327f
C3923 PH90.n25 VSS 0.07274f
C3924 PH90.n26 VSS 0.10264f
C3925 PH90.n27 VSS 0.13472f
C3926 PH90.n28 VSS 0.13472f
C3927 PH90.n29 VSS 0.10462f
C3928 PH90.n30 VSS 0.09327f
C3929 PH90.n31 VSS 0.07274f
C3930 PH90.n32 VSS 0.10264f
C3931 PH90.n33 VSS 0.12228f
C3932 PH90.n34 VSS 0.13472f
C3933 PH90.n35 VSS 0.10462f
C3934 PH90.n36 VSS 0.09327f
C3935 PH90.n37 VSS 0.07274f
C3936 PH90.n38 VSS 0.10264f
C3937 PH90.n39 VSS 0.13472f
C3938 PH90.n40 VSS 0.13472f
C3939 PH90.n41 VSS 0.10462f
C3940 PH90.n42 VSS 0.09327f
C3941 PH90.n43 VSS 0.07274f
C3942 PH90.n44 VSS 0.10264f
C3943 PH90.n45 VSS 0.16463f
C3944 PH90.t72 VSS 0.05505f
C3945 PH90.t7 VSS 0.05633f
C3946 PH90.t33 VSS 0.04987f
C3947 PH90.t56 VSS 0.04987f
C3948 PH90.t21 VSS 0.05633f
C3949 PH90.t48 VSS 0.05505f
C3950 PH90.t75 VSS 0.05505f
C3951 PH90.t29 VSS 0.05633f
C3952 PH90.t49 VSS 0.04987f
C3953 PH90.t76 VSS 0.04987f
C3954 PH90.t11 VSS 0.05633f
C3955 PH90.t62 VSS 0.05505f
C3956 PH90.t83 VSS 0.05505f
C3957 PH90.t19 VSS 0.05633f
C3958 PH90.t85 VSS 0.04987f
C3959 PH90.t93 VSS 0.04987f
C3960 PH90.t2 VSS 0.05633f
C3961 PH90.t64 VSS 0.05505f
C3962 PH90.t46 VSS 0.05505f
C3963 PH90.t4 VSS 0.05633f
C3964 PH90.t92 VSS 0.04987f
C3965 PH90.t38 VSS 0.04987f
C3966 PH90.t12 VSS 0.05633f
C3967 PH90.t77 VSS 0.05617f
C3968 PH90.n46 VSS 0.10462f
C3969 PH90.n47 VSS 0.09327f
C3970 PH90.n48 VSS 0.07274f
C3971 PH90.n49 VSS 0.10264f
C3972 PH90.n50 VSS 0.13472f
C3973 PH90.n51 VSS 0.13472f
C3974 PH90.n52 VSS 0.10462f
C3975 PH90.n53 VSS 0.09327f
C3976 PH90.n54 VSS 0.07274f
C3977 PH90.n55 VSS 0.10264f
C3978 PH90.n56 VSS 0.12228f
C3979 PH90.n57 VSS 0.13472f
C3980 PH90.n58 VSS 0.10462f
C3981 PH90.n59 VSS 0.09327f
C3982 PH90.n60 VSS 0.07274f
C3983 PH90.n61 VSS 0.10264f
C3984 PH90.n62 VSS 0.13472f
C3985 PH90.n63 VSS 0.13472f
C3986 PH90.n64 VSS 0.10462f
C3987 PH90.n65 VSS 0.09327f
C3988 PH90.n66 VSS 0.07274f
C3989 PH90.n67 VSS 0.10264f
C3990 PH90.n68 VSS 0.16463f
C3991 PH90.n69 VSS 0.16463f
C3992 PH90.t10 VSS 0.05633f
C3993 PH90.t88 VSS 0.04987f
C3994 PH90.t34 VSS 0.04987f
C3995 PH90.t22 VSS 0.05633f
C3996 PH90.t74 VSS 0.05505f
C3997 PH90.t57 VSS 0.05505f
C3998 PH90.t6 VSS 0.05633f
C3999 PH90.t94 VSS 0.04987f
C4000 PH90.t58 VSS 0.04987f
C4001 PH90.t40 VSS 0.05505f
C4002 PH90.t67 VSS 0.05505f
C4003 PH90.t0 VSS 0.05633f
C4004 PH90.t70 VSS 0.04987f
C4005 PH90.t84 VSS 0.04987f
C4006 PH90.t3 VSS 0.05633f
C4007 PH90.t43 VSS 0.05505f
C4008 PH90.t44 VSS 0.05505f
C4009 PH90.t27 VSS 0.05633f
C4010 PH90.t81 VSS 0.04987f
C4011 PH90.t91 VSS 0.04987f
C4012 PH90.t13 VSS 0.05633f
C4013 PH90.t60 VSS 0.05617f
C4014 PH90.n70 VSS 0.10462f
C4015 PH90.n71 VSS 0.09327f
C4016 PH90.n72 VSS 0.07274f
C4017 PH90.n73 VSS 0.10264f
C4018 PH90.n74 VSS 0.13472f
C4019 PH90.n75 VSS 0.13472f
C4020 PH90.n76 VSS 0.10462f
C4021 PH90.n77 VSS 0.09327f
C4022 PH90.n78 VSS 0.07274f
C4023 PH90.n79 VSS 0.10264f
C4024 PH90.n80 VSS 0.12228f
C4025 PH90.n81 VSS 0.13472f
C4026 PH90.t31 VSS 0.05633f
C4027 PH90.n82 VSS 0.10462f
C4028 PH90.n83 VSS 0.09327f
C4029 PH90.n84 VSS 0.07274f
C4030 PH90.n85 VSS 0.10264f
C4031 PH90.n86 VSS 0.13472f
C4032 PH90.n87 VSS 0.13472f
C4033 PH90.n88 VSS 0.10462f
C4034 PH90.n89 VSS 0.09327f
C4035 PH90.n90 VSS 0.07274f
C4036 PH90.n91 VSS 0.10264f
C4037 VDD.n0 VSS 0.0116f
C4038 VDD.t341 VSS 8.31842f
C4039 VDD.n1 VSS 1.69952f
C4040 VDD.t366 VSS 0.00759f
C4041 VDD.t412 VSS 0.00687f
C4042 VDD.t346 VSS 0.00687f
C4043 VDD.t392 VSS 0.00759f
C4044 VDD.n2 VSS 0.02195f
C4045 VDD.n3 VSS 0.17202f
C4046 VDD.n4 VSS 0.00779f
C4047 VDD.t414 VSS 0.00759f
C4048 VDD.t433 VSS 0.00687f
C4049 VDD.t369 VSS 0.00687f
C4050 VDD.n5 VSS 0.02515f
C4051 VDD.n6 VSS 0.03207f
C4052 VDD.n7 VSS 0.00695f
C4053 VDD.n8 VSS 0.00695f
C4054 VDD.n9 VSS 0.00695f
C4055 VDD.n10 VSS 0.00695f
C4056 VDD.n11 VSS 0.00695f
C4057 VDD.n12 VSS 0.00695f
C4058 VDD.n13 VSS 0.00695f
C4059 VDD.n14 VSS 0.00695f
C4060 VDD.n15 VSS 0.00695f
C4061 VDD.n16 VSS 0.00695f
C4062 VDD.n17 VSS 0.00695f
C4063 VDD.n18 VSS 0.00695f
C4064 VDD.n19 VSS 0.00695f
C4065 VDD.n20 VSS 0.00695f
C4066 VDD.n21 VSS 0.00695f
C4067 VDD.t915 VSS 0.00687f
C4068 VDD.n22 VSS 0.03207f
C4069 VDD.n23 VSS 0.00695f
C4070 VDD.t914 VSS 0.00759f
C4071 VDD.n24 VSS 0.03413f
C4072 VDD.n25 VSS 0.01883f
C4073 VDD.n26 VSS 0.0116f
C4074 VDD.t912 VSS 0.00759f
C4075 VDD.n27 VSS 0.02195f
C4076 VDD.t1144 VSS 0.00699f
C4077 VDD.n28 VSS 0.04124f
C4078 VDD.t1142 VSS 0.00759f
C4079 VDD.t1140 VSS 0.00687f
C4080 VDD.n29 VSS 0.03207f
C4081 VDD.n30 VSS 0.00695f
C4082 VDD.t1139 VSS 0.00759f
C4083 VDD.n31 VSS 0.03413f
C4084 VDD.n32 VSS 0.01883f
C4085 VDD.t1138 VSS 0.5199f
C4086 VDD.n33 VSS 0.09708f
C4087 VDD.n34 VSS 0.0116f
C4088 VDD.n35 VSS 0.02195f
C4089 VDD.n36 VSS 0.03129f
C4090 VDD.n37 VSS 0.00779f
C4091 VDD.t120 VSS 0.00759f
C4092 VDD.t15 VSS 0.00687f
C4093 VDD.n39 VSS 0.00879f
C4094 VDD.n40 VSS 0.01883f
C4095 VDD.t123 VSS 0.00687f
C4096 VDD.n41 VSS 0.03207f
C4097 VDD.t122 VSS 0.00759f
C4098 VDD.n42 VSS 0.03413f
C4099 VDD.n43 VSS 0.00695f
C4100 VDD.t11 VSS 0.00687f
C4101 VDD.t121 VSS 0.00687f
C4102 VDD.n44 VSS 0.02515f
C4103 VDD.n45 VSS 0.00879f
C4104 VDD.t16 VSS 0.00687f
C4105 VDD.n46 VSS 0.0172f
C4106 VDD.t668 VSS 0.00687f
C4107 VDD.t10 VSS 0.00687f
C4108 VDD.n48 VSS 0.0172f
C4109 VDD.n49 VSS 0.00879f
C4110 VDD.t667 VSS 0.00687f
C4111 VDD.n50 VSS 0.0172f
C4112 VDD.t9 VSS 1.10504f
C4113 VDD.n52 VSS 0.21731f
C4114 VDD.n53 VSS 0.0116f
C4115 VDD.n54 VSS 0.02195f
C4116 VDD.n55 VSS 0.02821f
C4117 VDD.n56 VSS 0.36535f
C4118 VDD.n57 VSS 0.03129f
C4119 VDD.t911 VSS 0.00687f
C4120 VDD.t7 VSS 0.00687f
C4121 VDD.n58 VSS 0.03207f
C4122 VDD.n59 VSS 0.02515f
C4123 VDD.n60 VSS 0.00779f
C4124 VDD.t12 VSS 0.00759f
C4125 VDD.n61 VSS 0.03413f
C4126 VDD.n62 VSS 0.01883f
C4127 VDD.n63 VSS 0.0116f
C4128 VDD.t8 VSS 0.00687f
C4129 VDD.t69 VSS 0.00687f
C4130 VDD.n64 VSS 0.03207f
C4131 VDD.n65 VSS 0.02515f
C4132 VDD.n66 VSS 0.00779f
C4133 VDD.t61 VSS 0.00759f
C4134 VDD.n67 VSS 0.03413f
C4135 VDD.n68 VSS 0.01883f
C4136 VDD.n69 VSS 0.0116f
C4137 VDD.t67 VSS 0.00687f
C4138 VDD.t63 VSS 0.00687f
C4139 VDD.n70 VSS 0.03207f
C4140 VDD.n71 VSS 0.02515f
C4141 VDD.n72 VSS 0.00779f
C4142 VDD.t60 VSS 0.00759f
C4143 VDD.n73 VSS 0.03413f
C4144 VDD.n74 VSS 0.01883f
C4145 VDD.n75 VSS 0.0116f
C4146 VDD.t64 VSS 0.00687f
C4147 VDD.t1125 VSS 0.00687f
C4148 VDD.n76 VSS 0.03207f
C4149 VDD.n77 VSS 0.02515f
C4150 VDD.n78 VSS 0.00779f
C4151 VDD.t1126 VSS 0.00759f
C4152 VDD.n79 VSS 0.03413f
C4153 VDD.n80 VSS 0.01883f
C4154 VDD.n81 VSS 0.0116f
C4155 VDD.t1104 VSS 0.00687f
C4156 VDD.t1082 VSS 0.00687f
C4157 VDD.n82 VSS 0.03207f
C4158 VDD.n83 VSS 0.02515f
C4159 VDD.n84 VSS 0.00779f
C4160 VDD.t1080 VSS 0.00759f
C4161 VDD.n85 VSS 0.03413f
C4162 VDD.n86 VSS 0.01883f
C4163 VDD.n87 VSS 0.0116f
C4164 VDD.t1109 VSS 0.00687f
C4165 VDD.t1114 VSS 0.00687f
C4166 VDD.n88 VSS 0.03207f
C4167 VDD.n89 VSS 0.02515f
C4168 VDD.n90 VSS 0.00779f
C4169 VDD.t1113 VSS 0.00759f
C4170 VDD.n91 VSS 0.03413f
C4171 VDD.n92 VSS 0.01883f
C4172 VDD.n93 VSS 0.0116f
C4173 VDD.t1092 VSS 0.00687f
C4174 VDD.t1098 VSS 0.00687f
C4175 VDD.n94 VSS 0.03207f
C4176 VDD.n95 VSS 0.02515f
C4177 VDD.n96 VSS 0.00779f
C4178 VDD.t1099 VSS 0.00759f
C4179 VDD.n97 VSS 0.03413f
C4180 VDD.n98 VSS 0.01883f
C4181 VDD.n99 VSS 0.0116f
C4182 VDD.t1120 VSS 0.00687f
C4183 VDD.t930 VSS 0.00687f
C4184 VDD.n100 VSS 0.03207f
C4185 VDD.n101 VSS 0.02515f
C4186 VDD.n102 VSS 0.00779f
C4187 VDD.t929 VSS 0.00759f
C4188 VDD.n103 VSS 0.03413f
C4189 VDD.n104 VSS 0.01883f
C4190 VDD.n105 VSS 0.0116f
C4191 VDD.t962 VSS 0.00687f
C4192 VDD.t960 VSS 0.00687f
C4193 VDD.n106 VSS 0.03207f
C4194 VDD.n107 VSS 0.02515f
C4195 VDD.n108 VSS 0.00779f
C4196 VDD.t959 VSS 0.00759f
C4197 VDD.n109 VSS 0.03413f
C4198 VDD.n110 VSS 0.01883f
C4199 VDD.n111 VSS 0.0116f
C4200 VDD.t923 VSS 0.00687f
C4201 VDD.t941 VSS 0.00687f
C4202 VDD.n112 VSS 0.03207f
C4203 VDD.n113 VSS 0.02515f
C4204 VDD.n114 VSS 0.00779f
C4205 VDD.t942 VSS 0.00759f
C4206 VDD.n115 VSS 0.03413f
C4207 VDD.n116 VSS 0.01883f
C4208 VDD.n117 VSS 0.0116f
C4209 VDD.t948 VSS 0.00687f
C4210 VDD.t932 VSS 0.00687f
C4211 VDD.n118 VSS 0.03207f
C4212 VDD.n119 VSS 0.02515f
C4213 VDD.n120 VSS 0.00779f
C4214 VDD.t933 VSS 0.00759f
C4215 VDD.n121 VSS 0.03413f
C4216 VDD.n122 VSS 0.01883f
C4217 VDD.n123 VSS 0.0116f
C4218 VDD.t946 VSS 0.00687f
C4219 VDD.t394 VSS 0.00687f
C4220 VDD.n124 VSS 0.03207f
C4221 VDD.n125 VSS 0.02515f
C4222 VDD.n126 VSS 0.00779f
C4223 VDD.t373 VSS 0.00759f
C4224 VDD.n127 VSS 0.03413f
C4225 VDD.n128 VSS 0.01883f
C4226 VDD.n129 VSS 0.0116f
C4227 VDD.t432 VSS 0.00687f
C4228 VDD.t377 VSS 0.00687f
C4229 VDD.n130 VSS 0.03207f
C4230 VDD.n131 VSS 0.02515f
C4231 VDD.n132 VSS 0.00779f
C4232 VDD.t355 VSS 0.00759f
C4233 VDD.n133 VSS 0.03413f
C4234 VDD.n134 VSS 0.01883f
C4235 VDD.n135 VSS 0.0116f
C4236 VDD.t383 VSS 0.00687f
C4237 VDD.t352 VSS 0.00687f
C4238 VDD.n136 VSS 0.03207f
C4239 VDD.n137 VSS 0.02515f
C4240 VDD.n138 VSS 0.00779f
C4241 VDD.t370 VSS 0.00759f
C4242 VDD.n139 VSS 0.03413f
C4243 VDD.n140 VSS 0.01883f
C4244 VDD.t345 VSS 0.00759f
C4245 VDD.n141 VSS 0.03413f
C4246 VDD.n142 VSS 0.01883f
C4247 VDD.n143 VSS 0.0116f
C4248 VDD.t365 VSS 0.00759f
C4249 VDD.n144 VSS 0.02195f
C4250 VDD.t396 VSS 0.00699f
C4251 VDD.n145 VSS 0.04124f
C4252 VDD.t342 VSS 0.00759f
C4253 VDD.n146 VSS 0.02195f
C4254 VDD.n147 VSS 0.02855f
C4255 VDD.n148 VSS 0.17202f
C4256 VDD.t439 VSS 0.00699f
C4257 VDD.n149 VSS 0.04124f
C4258 VDD.t344 VSS 0.00759f
C4259 VDD.n150 VSS 0.00695f
C4260 VDD.n151 VSS 0.00695f
C4261 VDD.n152 VSS 0.00695f
C4262 VDD.t416 VSS 0.00687f
C4263 VDD.n153 VSS 0.03207f
C4264 VDD.n154 VSS 0.00695f
C4265 VDD.t350 VSS 0.00759f
C4266 VDD.n155 VSS 0.03413f
C4267 VDD.n156 VSS 0.01883f
C4268 VDD.n157 VSS 0.0116f
C4269 VDD.t358 VSS 0.00687f
C4270 VDD.t399 VSS 0.00687f
C4271 VDD.n158 VSS 0.03207f
C4272 VDD.n159 VSS 0.02515f
C4273 VDD.n160 VSS 0.00779f
C4274 VDD.t378 VSS 0.00759f
C4275 VDD.n161 VSS 0.03413f
C4276 VDD.n162 VSS 0.01883f
C4277 VDD.n163 VSS 0.0116f
C4278 VDD.t409 VSS 0.00759f
C4279 VDD.n164 VSS 0.02195f
C4280 VDD.t386 VSS 0.00759f
C4281 VDD.n165 VSS 0.02195f
C4282 VDD.n166 VSS 0.02418f
C4283 VDD.n167 VSS 0.26136f
C4284 VDD.n168 VSS 0.17202f
C4285 VDD.n169 VSS 0.00779f
C4286 VDD.t359 VSS 0.00759f
C4287 VDD.n170 VSS 0.00695f
C4288 VDD.t402 VSS 0.00687f
C4289 VDD.t434 VSS 0.00687f
C4290 VDD.n171 VSS 0.02515f
C4291 VDD.n172 VSS 0.03207f
C4292 VDD.n173 VSS 0.00695f
C4293 VDD.n174 VSS 0.00695f
C4294 VDD.t348 VSS 0.00687f
C4295 VDD.n175 VSS 0.03207f
C4296 VDD.n176 VSS 0.00695f
C4297 VDD.t376 VSS 0.00759f
C4298 VDD.n177 VSS 0.03413f
C4299 VDD.n178 VSS 0.01883f
C4300 VDD.n179 VSS 0.0116f
C4301 VDD.t385 VSS 0.00687f
C4302 VDD.t427 VSS 0.00687f
C4303 VDD.n180 VSS 0.03207f
C4304 VDD.n181 VSS 0.02515f
C4305 VDD.n182 VSS 0.00779f
C4306 VDD.t362 VSS 0.00759f
C4307 VDD.n183 VSS 0.03413f
C4308 VDD.n184 VSS 0.01883f
C4309 VDD.t357 VSS 0.00759f
C4310 VDD.n185 VSS 0.03413f
C4311 VDD.n186 VSS 0.01883f
C4312 VDD.n187 VSS 0.0116f
C4313 VDD.t367 VSS 0.00759f
C4314 VDD.n188 VSS 0.02195f
C4315 VDD.n189 VSS 0.17202f
C4316 VDD.n190 VSS 0.00779f
C4317 VDD.t225 VSS 0.00759f
C4318 VDD.t265 VSS 0.00687f
C4319 VDD.t227 VSS 0.00687f
C4320 VDD.n191 VSS 0.02515f
C4321 VDD.n192 VSS 0.03207f
C4322 VDD.n193 VSS 0.00695f
C4323 VDD.n194 VSS 0.00695f
C4324 VDD.n195 VSS 0.00695f
C4325 VDD.n196 VSS 0.00695f
C4326 VDD.n197 VSS 0.00695f
C4327 VDD.n198 VSS 0.00695f
C4328 VDD.n199 VSS 0.00695f
C4329 VDD.n200 VSS 0.00695f
C4330 VDD.n201 VSS 0.00695f
C4331 VDD.n202 VSS 0.00695f
C4332 VDD.n203 VSS 0.00695f
C4333 VDD.n204 VSS 0.01223f
C4334 VDD.t795 VSS 0.00687f
C4335 VDD.n205 VSS 0.01619f
C4336 VDD.n206 VSS 0.00695f
C4337 VDD.n207 VSS 0.00695f
C4338 VDD.n208 VSS 0.00695f
C4339 VDD.t1053 VSS 0.00687f
C4340 VDD.n209 VSS 0.03207f
C4341 VDD.n210 VSS 0.00695f
C4342 VDD.t1052 VSS 0.00759f
C4343 VDD.n211 VSS 0.03413f
C4344 VDD.n212 VSS 0.01883f
C4345 VDD.n213 VSS 0.0116f
C4346 VDD.t1040 VSS 0.00759f
C4347 VDD.n214 VSS 0.03413f
C4348 VDD.t1042 VSS 0.00687f
C4349 VDD.t1045 VSS 0.00687f
C4350 VDD.n215 VSS 0.03207f
C4351 VDD.n216 VSS 0.02515f
C4352 VDD.n217 VSS 0.01387f
C4353 VDD.t1043 VSS 0.00759f
C4354 VDD.n218 VSS 0.03413f
C4355 VDD.n219 VSS 0.01883f
C4356 VDD.n220 VSS 0.0116f
C4357 VDD.t1048 VSS 0.00687f
C4358 VDD.t1063 VSS 0.00687f
C4359 VDD.n221 VSS 0.03207f
C4360 VDD.n222 VSS 0.02515f
C4361 VDD.n223 VSS 0.00779f
C4362 VDD.t1061 VSS 0.00759f
C4363 VDD.n224 VSS 0.03413f
C4364 VDD.n225 VSS 0.01883f
C4365 VDD.n226 VSS 0.0116f
C4366 VDD.t1050 VSS 0.00687f
C4367 VDD.t1055 VSS 0.00687f
C4368 VDD.n227 VSS 0.03207f
C4369 VDD.n228 VSS 0.02515f
C4370 VDD.n229 VSS 0.00779f
C4371 VDD.t1056 VSS 0.00759f
C4372 VDD.n230 VSS 0.03413f
C4373 VDD.n231 VSS 0.01883f
C4374 VDD.n232 VSS 0.0116f
C4375 VDD.t1059 VSS 0.00687f
C4376 VDD.n233 VSS 0.02515f
C4377 VDD.n234 VSS 0.00779f
C4378 VDD.t794 VSS 0.00759f
C4379 VDD.n235 VSS 0.02716f
C4380 VDD.n236 VSS 0.01883f
C4381 VDD.n237 VSS 0.0116f
C4382 VDD.t778 VSS 0.00687f
C4383 VDD.t783 VSS 0.00687f
C4384 VDD.n238 VSS 0.03207f
C4385 VDD.n239 VSS 0.02515f
C4386 VDD.n240 VSS 0.00779f
C4387 VDD.t782 VSS 0.00759f
C4388 VDD.n241 VSS 0.03413f
C4389 VDD.n242 VSS 0.01883f
C4390 VDD.n243 VSS 0.0116f
C4391 VDD.t802 VSS 0.00687f
C4392 VDD.t818 VSS 0.00687f
C4393 VDD.n244 VSS 0.03207f
C4394 VDD.n245 VSS 0.02515f
C4395 VDD.n246 VSS 0.00779f
C4396 VDD.t819 VSS 0.00759f
C4397 VDD.n247 VSS 0.03413f
C4398 VDD.n248 VSS 0.01883f
C4399 VDD.n249 VSS 0.0116f
C4400 VDD.t806 VSS 0.00687f
C4401 VDD.t805 VSS 0.00687f
C4402 VDD.n250 VSS 0.03207f
C4403 VDD.n251 VSS 0.02515f
C4404 VDD.n252 VSS 0.00779f
C4405 VDD.t803 VSS 0.00759f
C4406 VDD.n253 VSS 0.03413f
C4407 VDD.n254 VSS 0.01883f
C4408 VDD.n255 VSS 0.0116f
C4409 VDD.t799 VSS 0.00687f
C4410 VDD.t1008 VSS 0.00687f
C4411 VDD.n256 VSS 0.03207f
C4412 VDD.n257 VSS 0.02515f
C4413 VDD.n258 VSS 0.00779f
C4414 VDD.t1007 VSS 0.00759f
C4415 VDD.n259 VSS 0.03413f
C4416 VDD.n260 VSS 0.01883f
C4417 VDD.n261 VSS 0.0116f
C4418 VDD.t978 VSS 0.00687f
C4419 VDD.t980 VSS 0.00687f
C4420 VDD.n262 VSS 0.03207f
C4421 VDD.n263 VSS 0.02515f
C4422 VDD.n264 VSS 0.00779f
C4423 VDD.t981 VSS 0.00759f
C4424 VDD.n265 VSS 0.03413f
C4425 VDD.n266 VSS 0.01883f
C4426 VDD.n267 VSS 0.0116f
C4427 VDD.t992 VSS 0.00687f
C4428 VDD.t997 VSS 0.00687f
C4429 VDD.n268 VSS 0.03207f
C4430 VDD.n269 VSS 0.02515f
C4431 VDD.n270 VSS 0.00779f
C4432 VDD.t995 VSS 0.00759f
C4433 VDD.n271 VSS 0.03413f
C4434 VDD.n272 VSS 0.01883f
C4435 VDD.n273 VSS 0.0116f
C4436 VDD.t1010 VSS 0.00687f
C4437 VDD.t991 VSS 0.00687f
C4438 VDD.n274 VSS 0.03207f
C4439 VDD.n275 VSS 0.02515f
C4440 VDD.n276 VSS 0.00779f
C4441 VDD.t989 VSS 0.00759f
C4442 VDD.n277 VSS 0.03413f
C4443 VDD.n278 VSS 0.01883f
C4444 VDD.n279 VSS 0.0116f
C4445 VDD.t1002 VSS 0.00687f
C4446 VDD.t295 VSS 0.00687f
C4447 VDD.n280 VSS 0.03207f
C4448 VDD.n281 VSS 0.02515f
C4449 VDD.n282 VSS 0.00779f
C4450 VDD.t294 VSS 0.00759f
C4451 VDD.n283 VSS 0.03413f
C4452 VDD.n284 VSS 0.01883f
C4453 VDD.n285 VSS 0.0116f
C4454 VDD.t223 VSS 0.00687f
C4455 VDD.t258 VSS 0.00687f
C4456 VDD.n286 VSS 0.03207f
C4457 VDD.n287 VSS 0.02515f
C4458 VDD.n288 VSS 0.00779f
C4459 VDD.t259 VSS 0.00759f
C4460 VDD.n289 VSS 0.03413f
C4461 VDD.n290 VSS 0.01883f
C4462 VDD.n291 VSS 0.0116f
C4463 VDD.t200 VSS 0.00759f
C4464 VDD.n292 VSS 0.02195f
C4465 VDD.n293 VSS 0.02418f
C4466 VDD.t199 VSS 0.00687f
C4467 VDD.t213 VSS 0.00687f
C4468 VDD.n294 VSS 0.03207f
C4469 VDD.n295 VSS 0.02515f
C4470 VDD.n296 VSS 0.00779f
C4471 VDD.t212 VSS 0.00759f
C4472 VDD.n297 VSS 0.03413f
C4473 VDD.n298 VSS 0.01883f
C4474 VDD.t264 VSS 0.00759f
C4475 VDD.n299 VSS 0.03413f
C4476 VDD.n300 VSS 0.01883f
C4477 VDD.n301 VSS 0.0116f
C4478 VDD.t238 VSS 0.00759f
C4479 VDD.n302 VSS 0.02195f
C4480 VDD.n303 VSS 0.17202f
C4481 VDD.t286 VSS 0.00699f
C4482 VDD.n304 VSS 0.04124f
C4483 VDD.t285 VSS 0.00759f
C4484 VDD.n305 VSS 0.00695f
C4485 VDD.n306 VSS 0.00695f
C4486 VDD.n307 VSS 0.00695f
C4487 VDD.n308 VSS 0.00695f
C4488 VDD.n309 VSS 0.00695f
C4489 VDD.n310 VSS 0.00695f
C4490 VDD.n311 VSS 0.00695f
C4491 VDD.n312 VSS 0.00695f
C4492 VDD.n313 VSS 0.00695f
C4493 VDD.n314 VSS 0.00695f
C4494 VDD.n315 VSS 0.00695f
C4495 VDD.n316 VSS 0.00695f
C4496 VDD.n317 VSS 0.00695f
C4497 VDD.n318 VSS 0.00695f
C4498 VDD.n319 VSS 0.00695f
C4499 VDD.t1070 VSS 0.00687f
C4500 VDD.n320 VSS 0.03207f
C4501 VDD.n321 VSS 0.00695f
C4502 VDD.t1069 VSS 0.00759f
C4503 VDD.n322 VSS 0.03413f
C4504 VDD.n323 VSS 0.01883f
C4505 VDD.n324 VSS 0.0116f
C4506 VDD.t1065 VSS 0.00759f
C4507 VDD.n325 VSS 0.02195f
C4508 VDD.t1131 VSS 0.00699f
C4509 VDD.n326 VSS 0.04124f
C4510 VDD.t1129 VSS 0.00759f
C4511 VDD.t1134 VSS 0.00687f
C4512 VDD.n327 VSS 0.03207f
C4513 VDD.n328 VSS 0.00695f
C4514 VDD.t1132 VSS 0.00759f
C4515 VDD.n329 VSS 0.03413f
C4516 VDD.n330 VSS 0.01883f
C4517 VDD.t1128 VSS 0.5199f
C4518 VDD.n331 VSS 0.09708f
C4519 VDD.n332 VSS 0.0116f
C4520 VDD.n333 VSS 0.02195f
C4521 VDD.n334 VSS 0.03129f
C4522 VDD.t94 VSS 0.00699f
C4523 VDD.n335 VSS 0.04124f
C4524 VDD.t93 VSS 0.00759f
C4525 VDD.t96 VSS 0.00687f
C4526 VDD.n336 VSS 0.03207f
C4527 VDD.n337 VSS 0.00695f
C4528 VDD.t95 VSS 0.00759f
C4529 VDD.n338 VSS 0.03413f
C4530 VDD.n339 VSS 0.01883f
C4531 VDD.t92 VSS 0.5199f
C4532 VDD.n340 VSS 0.09708f
C4533 VDD.n341 VSS 0.0116f
C4534 VDD.n342 VSS 0.02195f
C4535 VDD.n343 VSS 0.02821f
C4536 VDD.n344 VSS 0.36535f
C4537 VDD.n345 VSS 0.03129f
C4538 VDD.t1064 VSS 0.00687f
C4539 VDD.t670 VSS 0.00687f
C4540 VDD.n346 VSS 0.03207f
C4541 VDD.n347 VSS 0.02515f
C4542 VDD.n348 VSS 0.00779f
C4543 VDD.t664 VSS 0.00759f
C4544 VDD.n349 VSS 0.03413f
C4545 VDD.n350 VSS 0.01883f
C4546 VDD.n351 VSS 0.0116f
C4547 VDD.t665 VSS 0.00759f
C4548 VDD.n352 VSS 0.02195f
C4549 VDD.t1046 VSS 0.00759f
C4550 VDD.n353 VSS 0.02195f
C4551 VDD.n354 VSS 0.11599f
C4552 VDD.n355 VSS 0.11599f
C4553 VDD.t663 VSS 0.00687f
C4554 VDD.t136 VSS 0.00687f
C4555 VDD.n356 VSS 0.03207f
C4556 VDD.n357 VSS 0.02515f
C4557 VDD.n358 VSS 0.00779f
C4558 VDD.t128 VSS 0.00759f
C4559 VDD.n359 VSS 0.03413f
C4560 VDD.n360 VSS 0.01883f
C4561 VDD.n361 VSS 0.0116f
C4562 VDD.t132 VSS 0.00759f
C4563 VDD.n362 VSS 0.02195f
C4564 VDD.t1049 VSS 0.00759f
C4565 VDD.n363 VSS 0.02195f
C4566 VDD.n364 VSS 0.11599f
C4567 VDD.n365 VSS 0.11599f
C4568 VDD.t134 VSS 0.00687f
C4569 VDD.t130 VSS 0.00687f
C4570 VDD.n366 VSS 0.03207f
C4571 VDD.n367 VSS 0.02515f
C4572 VDD.n368 VSS 0.00779f
C4573 VDD.t127 VSS 0.00759f
C4574 VDD.n369 VSS 0.03413f
C4575 VDD.n370 VSS 0.01883f
C4576 VDD.n371 VSS 0.0116f
C4577 VDD.t129 VSS 0.00759f
C4578 VDD.n372 VSS 0.02195f
C4579 VDD.t1058 VSS 0.00759f
C4580 VDD.n373 VSS 0.02195f
C4581 VDD.n374 VSS 0.11599f
C4582 VDD.n375 VSS 0.11599f
C4583 VDD.t131 VSS 0.00687f
C4584 VDD.t812 VSS 0.00687f
C4585 VDD.n376 VSS 0.03207f
C4586 VDD.n377 VSS 0.02515f
C4587 VDD.n378 VSS 0.00779f
C4588 VDD.t813 VSS 0.00759f
C4589 VDD.n379 VSS 0.03413f
C4590 VDD.n380 VSS 0.01883f
C4591 VDD.n381 VSS 0.0116f
C4592 VDD.t810 VSS 0.00759f
C4593 VDD.n382 VSS 0.02195f
C4594 VDD.t776 VSS 0.00759f
C4595 VDD.n383 VSS 0.02195f
C4596 VDD.n384 VSS 0.11789f
C4597 VDD.n385 VSS 0.11789f
C4598 VDD.t809 VSS 0.00687f
C4599 VDD.t793 VSS 0.00687f
C4600 VDD.n386 VSS 0.03207f
C4601 VDD.n387 VSS 0.02515f
C4602 VDD.n388 VSS 0.00779f
C4603 VDD.t791 VSS 0.00759f
C4604 VDD.n389 VSS 0.03413f
C4605 VDD.n390 VSS 0.01883f
C4606 VDD.n391 VSS 0.0116f
C4607 VDD.t815 VSS 0.00759f
C4608 VDD.n392 VSS 0.02195f
C4609 VDD.t800 VSS 0.00759f
C4610 VDD.n393 VSS 0.02195f
C4611 VDD.n394 VSS 0.11789f
C4612 VDD.n395 VSS 0.11789f
C4613 VDD.t817 VSS 0.00687f
C4614 VDD.t788 VSS 0.00687f
C4615 VDD.n396 VSS 0.03207f
C4616 VDD.n397 VSS 0.02515f
C4617 VDD.n398 VSS 0.00779f
C4618 VDD.t789 VSS 0.00759f
C4619 VDD.n399 VSS 0.03413f
C4620 VDD.n400 VSS 0.01883f
C4621 VDD.n401 VSS 0.0116f
C4622 VDD.t780 VSS 0.00759f
C4623 VDD.n402 VSS 0.02195f
C4624 VDD.t807 VSS 0.00759f
C4625 VDD.n403 VSS 0.02195f
C4626 VDD.n404 VSS 0.11789f
C4627 VDD.n405 VSS 0.11789f
C4628 VDD.t779 VSS 0.00687f
C4629 VDD.t785 VSS 0.00687f
C4630 VDD.n406 VSS 0.03207f
C4631 VDD.n407 VSS 0.02515f
C4632 VDD.n408 VSS 0.00779f
C4633 VDD.t786 VSS 0.00759f
C4634 VDD.n409 VSS 0.03413f
C4635 VDD.n410 VSS 0.01883f
C4636 VDD.n411 VSS 0.0116f
C4637 VDD.t821 VSS 0.00759f
C4638 VDD.n412 VSS 0.02195f
C4639 VDD.t797 VSS 0.00759f
C4640 VDD.n413 VSS 0.02195f
C4641 VDD.n414 VSS 0.11789f
C4642 VDD.n415 VSS 0.11789f
C4643 VDD.t822 VSS 0.00687f
C4644 VDD.t984 VSS 0.00687f
C4645 VDD.n416 VSS 0.03207f
C4646 VDD.n417 VSS 0.02515f
C4647 VDD.n418 VSS 0.00779f
C4648 VDD.t983 VSS 0.00759f
C4649 VDD.n419 VSS 0.03413f
C4650 VDD.n420 VSS 0.01883f
C4651 VDD.n421 VSS 0.0116f
C4652 VDD.t974 VSS 0.00759f
C4653 VDD.n422 VSS 0.02195f
C4654 VDD.t977 VSS 0.00759f
C4655 VDD.n423 VSS 0.02195f
C4656 VDD.n424 VSS 0.11789f
C4657 VDD.n425 VSS 0.11789f
C4658 VDD.t976 VSS 0.00687f
C4659 VDD.t1005 VSS 0.00687f
C4660 VDD.n426 VSS 0.03207f
C4661 VDD.n427 VSS 0.02515f
C4662 VDD.n428 VSS 0.00779f
C4663 VDD.t1004 VSS 0.00759f
C4664 VDD.n429 VSS 0.03413f
C4665 VDD.n430 VSS 0.01883f
C4666 VDD.n431 VSS 0.0116f
C4667 VDD.t987 VSS 0.00759f
C4668 VDD.n432 VSS 0.02195f
C4669 VDD.t993 VSS 0.00759f
C4670 VDD.n433 VSS 0.02195f
C4671 VDD.n434 VSS 0.11789f
C4672 VDD.n435 VSS 0.11789f
C4673 VDD.t986 VSS 0.00687f
C4674 VDD.t1013 VSS 0.00687f
C4675 VDD.n436 VSS 0.03207f
C4676 VDD.n437 VSS 0.02515f
C4677 VDD.n438 VSS 0.00779f
C4678 VDD.t1014 VSS 0.00759f
C4679 VDD.n439 VSS 0.03413f
C4680 VDD.n440 VSS 0.01883f
C4681 VDD.n441 VSS 0.0116f
C4682 VDD.t969 VSS 0.00759f
C4683 VDD.n442 VSS 0.02195f
C4684 VDD.t1011 VSS 0.00759f
C4685 VDD.n443 VSS 0.02195f
C4686 VDD.n444 VSS 0.11789f
C4687 VDD.n445 VSS 0.11789f
C4688 VDD.t968 VSS 0.00687f
C4689 VDD.t973 VSS 0.00687f
C4690 VDD.n446 VSS 0.03207f
C4691 VDD.n447 VSS 0.02515f
C4692 VDD.n448 VSS 0.00779f
C4693 VDD.t971 VSS 0.00759f
C4694 VDD.n449 VSS 0.03413f
C4695 VDD.n450 VSS 0.01883f
C4696 VDD.n451 VSS 0.0116f
C4697 VDD.t998 VSS 0.00759f
C4698 VDD.n452 VSS 0.02195f
C4699 VDD.t1001 VSS 0.00759f
C4700 VDD.n453 VSS 0.02195f
C4701 VDD.n454 VSS 0.11789f
C4702 VDD.n455 VSS 0.11789f
C4703 VDD.t1000 VSS 0.00687f
C4704 VDD.t262 VSS 0.00687f
C4705 VDD.n456 VSS 0.03207f
C4706 VDD.n457 VSS 0.02515f
C4707 VDD.n458 VSS 0.00779f
C4708 VDD.t261 VSS 0.00759f
C4709 VDD.n459 VSS 0.03413f
C4710 VDD.n460 VSS 0.01883f
C4711 VDD.n461 VSS 0.0116f
C4712 VDD.t254 VSS 0.00687f
C4713 VDD.t292 VSS 0.00687f
C4714 VDD.n462 VSS 0.03207f
C4715 VDD.n463 VSS 0.02515f
C4716 VDD.n464 VSS 0.00779f
C4717 VDD.t291 VSS 0.00759f
C4718 VDD.n465 VSS 0.03413f
C4719 VDD.n466 VSS 0.01883f
C4720 VDD.n467 VSS 0.0116f
C4721 VDD.t210 VSS 0.00759f
C4722 VDD.n468 VSS 0.02195f
C4723 VDD.n469 VSS 0.17202f
C4724 VDD.n470 VSS 0.00779f
C4725 VDD.t274 VSS 0.00759f
C4726 VDD.n471 VSS 0.00695f
C4727 VDD.t276 VSS 0.00687f
C4728 VDD.t273 VSS 0.00687f
C4729 VDD.n472 VSS 0.02515f
C4730 VDD.n473 VSS 0.03207f
C4731 VDD.n474 VSS 0.00695f
C4732 VDD.n475 VSS 0.00695f
C4733 VDD.t207 VSS 0.00687f
C4734 VDD.n476 VSS 0.03207f
C4735 VDD.n477 VSS 0.00695f
C4736 VDD.t206 VSS 0.00759f
C4737 VDD.n478 VSS 0.03413f
C4738 VDD.n479 VSS 0.01883f
C4739 VDD.n480 VSS 0.0116f
C4740 VDD.t240 VSS 0.00687f
C4741 VDD.t244 VSS 0.00687f
C4742 VDD.n481 VSS 0.03207f
C4743 VDD.n482 VSS 0.02515f
C4744 VDD.n483 VSS 0.00779f
C4745 VDD.t243 VSS 0.00759f
C4746 VDD.n484 VSS 0.03413f
C4747 VDD.n485 VSS 0.01883f
C4748 VDD.t277 VSS 0.00759f
C4749 VDD.n486 VSS 0.03413f
C4750 VDD.n487 VSS 0.01883f
C4751 VDD.n488 VSS 0.0116f
C4752 VDD.t246 VSS 0.00759f
C4753 VDD.n489 VSS 0.02195f
C4754 VDD.n490 VSS 0.17202f
C4755 VDD.n491 VSS 0.00779f
C4756 VDD.t234 VSS 0.00759f
C4757 VDD.t270 VSS 0.00687f
C4758 VDD.t236 VSS 0.00687f
C4759 VDD.n492 VSS 0.02515f
C4760 VDD.n493 VSS 0.03207f
C4761 VDD.n494 VSS 0.00695f
C4762 VDD.n495 VSS 0.00695f
C4763 VDD.n496 VSS 0.00695f
C4764 VDD.t257 VSS 0.00687f
C4765 VDD.n497 VSS 0.03207f
C4766 VDD.n498 VSS 0.00695f
C4767 VDD.t255 VSS 0.00759f
C4768 VDD.n499 VSS 0.03413f
C4769 VDD.n500 VSS 0.01883f
C4770 VDD.n501 VSS 0.0116f
C4771 VDD.t228 VSS 0.00687f
C4772 VDD.t290 VSS 0.00687f
C4773 VDD.n502 VSS 0.03207f
C4774 VDD.n503 VSS 0.02515f
C4775 VDD.n504 VSS 0.00779f
C4776 VDD.t288 VSS 0.00759f
C4777 VDD.n505 VSS 0.03413f
C4778 VDD.n506 VSS 0.01883f
C4779 VDD.n507 VSS 0.0116f
C4780 VDD.t217 VSS 0.00759f
C4781 VDD.n508 VSS 0.02195f
C4782 VDD.n509 VSS 0.02418f
C4783 VDD.t216 VSS 0.00687f
C4784 VDD.t219 VSS 0.00687f
C4785 VDD.n510 VSS 0.03207f
C4786 VDD.n511 VSS 0.02515f
C4787 VDD.n512 VSS 0.00779f
C4788 VDD.t220 VSS 0.00759f
C4789 VDD.n513 VSS 0.03413f
C4790 VDD.n514 VSS 0.01883f
C4791 VDD.t271 VSS 0.00759f
C4792 VDD.n515 VSS 0.03413f
C4793 VDD.n516 VSS 0.01883f
C4794 VDD.n517 VSS 0.0116f
C4795 VDD.t283 VSS 0.00759f
C4796 VDD.n518 VSS 0.02195f
C4797 VDD.n519 VSS 0.17202f
C4798 VDD.t587 VSS 0.00699f
C4799 VDD.n520 VSS 0.04124f
C4800 VDD.t588 VSS 0.00759f
C4801 VDD.n521 VSS 0.00695f
C4802 VDD.n522 VSS 0.00695f
C4803 VDD.n523 VSS 0.00695f
C4804 VDD.n524 VSS 0.00695f
C4805 VDD.n525 VSS 0.00695f
C4806 VDD.n526 VSS 0.00695f
C4807 VDD.n527 VSS 0.00695f
C4808 VDD.n528 VSS 0.00695f
C4809 VDD.n529 VSS 0.00695f
C4810 VDD.n530 VSS 0.00695f
C4811 VDD.n531 VSS 0.00695f
C4812 VDD.n532 VSS 0.01223f
C4813 VDD.t1184 VSS 0.00687f
C4814 VDD.n533 VSS 0.01619f
C4815 VDD.n534 VSS 0.00695f
C4816 VDD.n535 VSS 0.00695f
C4817 VDD.n536 VSS 0.00695f
C4818 VDD.t184 VSS 0.00687f
C4819 VDD.n537 VSS 0.03207f
C4820 VDD.n538 VSS 0.00695f
C4821 VDD.t183 VSS 0.00759f
C4822 VDD.n539 VSS 0.03413f
C4823 VDD.n540 VSS 0.01883f
C4824 VDD.n541 VSS 0.0116f
C4825 VDD.t186 VSS 0.00759f
C4826 VDD.n542 VSS 0.03413f
C4827 VDD.t188 VSS 0.00687f
C4828 VDD.t181 VSS 0.00687f
C4829 VDD.n543 VSS 0.03207f
C4830 VDD.n544 VSS 0.02515f
C4831 VDD.n545 VSS 0.01387f
C4832 VDD.t180 VSS 0.00759f
C4833 VDD.n546 VSS 0.03413f
C4834 VDD.n547 VSS 0.01883f
C4835 VDD.n548 VSS 0.0116f
C4836 VDD.t194 VSS 0.00687f
C4837 VDD.t190 VSS 0.00687f
C4838 VDD.n549 VSS 0.03207f
C4839 VDD.n550 VSS 0.02515f
C4840 VDD.n551 VSS 0.00779f
C4841 VDD.t189 VSS 0.00759f
C4842 VDD.n552 VSS 0.03413f
C4843 VDD.n553 VSS 0.01883f
C4844 VDD.n554 VSS 0.0116f
C4845 VDD.t196 VSS 0.00687f
C4846 VDD.t176 VSS 0.00687f
C4847 VDD.n555 VSS 0.03207f
C4848 VDD.n556 VSS 0.02515f
C4849 VDD.n557 VSS 0.00779f
C4850 VDD.t174 VSS 0.00759f
C4851 VDD.n558 VSS 0.03413f
C4852 VDD.n559 VSS 0.01883f
C4853 VDD.n560 VSS 0.0116f
C4854 VDD.t177 VSS 0.00687f
C4855 VDD.n561 VSS 0.02515f
C4856 VDD.n562 VSS 0.00779f
C4857 VDD.t1159 VSS 0.00759f
C4858 VDD.n563 VSS 0.02716f
C4859 VDD.n564 VSS 0.01883f
C4860 VDD.n565 VSS 0.0116f
C4861 VDD.t1190 VSS 0.00687f
C4862 VDD.t1175 VSS 0.00687f
C4863 VDD.n566 VSS 0.03207f
C4864 VDD.n567 VSS 0.02515f
C4865 VDD.n568 VSS 0.00779f
C4866 VDD.t1153 VSS 0.00759f
C4867 VDD.n569 VSS 0.03413f
C4868 VDD.n570 VSS 0.01883f
C4869 VDD.n571 VSS 0.0116f
C4870 VDD.t1167 VSS 0.00687f
C4871 VDD.t1151 VSS 0.00687f
C4872 VDD.n572 VSS 0.03207f
C4873 VDD.n573 VSS 0.02515f
C4874 VDD.n574 VSS 0.00779f
C4875 VDD.t1166 VSS 0.00759f
C4876 VDD.n575 VSS 0.03413f
C4877 VDD.n576 VSS 0.01883f
C4878 VDD.n577 VSS 0.0116f
C4879 VDD.t1197 VSS 0.00687f
C4880 VDD.t1181 VSS 0.00687f
C4881 VDD.n578 VSS 0.03207f
C4882 VDD.n579 VSS 0.02515f
C4883 VDD.n580 VSS 0.00779f
C4884 VDD.t1170 VSS 0.00759f
C4885 VDD.n581 VSS 0.03413f
C4886 VDD.n582 VSS 0.01883f
C4887 VDD.n583 VSS 0.0116f
C4888 VDD.t1185 VSS 0.00687f
C4889 VDD.t1263 VSS 0.00687f
C4890 VDD.n584 VSS 0.03207f
C4891 VDD.n585 VSS 0.02515f
C4892 VDD.n586 VSS 0.00779f
C4893 VDD.t1276 VSS 0.00759f
C4894 VDD.n587 VSS 0.03413f
C4895 VDD.n588 VSS 0.01883f
C4896 VDD.n589 VSS 0.0116f
C4897 VDD.t1282 VSS 0.00687f
C4898 VDD.t1265 VSS 0.00687f
C4899 VDD.n590 VSS 0.03207f
C4900 VDD.n591 VSS 0.02515f
C4901 VDD.n592 VSS 0.00779f
C4902 VDD.t1270 VSS 0.00759f
C4903 VDD.n593 VSS 0.03413f
C4904 VDD.n594 VSS 0.01883f
C4905 VDD.n595 VSS 0.0116f
C4906 VDD.t1257 VSS 0.00687f
C4907 VDD.t1289 VSS 0.00687f
C4908 VDD.n596 VSS 0.03207f
C4909 VDD.n597 VSS 0.02515f
C4910 VDD.n598 VSS 0.00779f
C4911 VDD.t1256 VSS 0.00759f
C4912 VDD.n599 VSS 0.03413f
C4913 VDD.n600 VSS 0.01883f
C4914 VDD.n601 VSS 0.0116f
C4915 VDD.t1298 VSS 0.00687f
C4916 VDD.t1283 VSS 0.00687f
C4917 VDD.n602 VSS 0.03207f
C4918 VDD.n603 VSS 0.02515f
C4919 VDD.n604 VSS 0.00779f
C4920 VDD.t1260 VSS 0.00759f
C4921 VDD.n605 VSS 0.03413f
C4922 VDD.n606 VSS 0.01883f
C4923 VDD.n607 VSS 0.0116f
C4924 VDD.t1275 VSS 0.00687f
C4925 VDD.t561 VSS 0.00687f
C4926 VDD.n608 VSS 0.03207f
C4927 VDD.n609 VSS 0.02515f
C4928 VDD.n610 VSS 0.00779f
C4929 VDD.t591 VSS 0.00759f
C4930 VDD.n611 VSS 0.03413f
C4931 VDD.n612 VSS 0.01883f
C4932 VDD.n613 VSS 0.0116f
C4933 VDD.t601 VSS 0.00687f
C4934 VDD.t636 VSS 0.00687f
C4935 VDD.n614 VSS 0.03207f
C4936 VDD.n615 VSS 0.02515f
C4937 VDD.n616 VSS 0.00779f
C4938 VDD.t575 VSS 0.00759f
C4939 VDD.n617 VSS 0.03413f
C4940 VDD.n618 VSS 0.01883f
C4941 VDD.n619 VSS 0.0116f
C4942 VDD.t549 VSS 0.00759f
C4943 VDD.n620 VSS 0.02195f
C4944 VDD.n621 VSS 0.17202f
C4945 VDD.n622 VSS 0.00779f
C4946 VDD.t576 VSS 0.00759f
C4947 VDD.n623 VSS 0.00695f
C4948 VDD.t635 VSS 0.00687f
C4949 VDD.t574 VSS 0.00687f
C4950 VDD.n624 VSS 0.02515f
C4951 VDD.n625 VSS 0.03207f
C4952 VDD.n626 VSS 0.00695f
C4953 VDD.n627 VSS 0.00695f
C4954 VDD.n628 VSS 0.00695f
C4955 VDD.n629 VSS 0.00695f
C4956 VDD.n630 VSS 0.00695f
C4957 VDD.n631 VSS 0.00695f
C4958 VDD.n632 VSS 0.00695f
C4959 VDD.n633 VSS 0.00695f
C4960 VDD.n634 VSS 0.00695f
C4961 VDD.n635 VSS 0.00695f
C4962 VDD.n636 VSS 0.00695f
C4963 VDD.n637 VSS 0.00695f
C4964 VDD.n638 VSS 0.00695f
C4965 VDD.n639 VSS 0.00695f
C4966 VDD.n640 VSS 0.00695f
C4967 VDD.t831 VSS 0.00687f
C4968 VDD.n641 VSS 0.03207f
C4969 VDD.n642 VSS 0.00695f
C4970 VDD.t830 VSS 0.00759f
C4971 VDD.n643 VSS 0.03413f
C4972 VDD.n644 VSS 0.01883f
C4973 VDD.n645 VSS 0.0116f
C4974 VDD.t826 VSS 0.00759f
C4975 VDD.n646 VSS 0.03413f
C4976 VDD.t828 VSS 0.00687f
C4977 VDD.t491 VSS 0.00687f
C4978 VDD.n647 VSS 0.03207f
C4979 VDD.n648 VSS 0.02515f
C4980 VDD.n649 VSS 0.01387f
C4981 VDD.t490 VSS 0.00759f
C4982 VDD.n650 VSS 0.03413f
C4983 VDD.n651 VSS 0.01883f
C4984 VDD.n652 VSS 0.0116f
C4985 VDD.t492 VSS 0.00759f
C4986 VDD.n653 VSS 0.03413f
C4987 VDD.t489 VSS 0.00687f
C4988 VDD.t46 VSS 0.00687f
C4989 VDD.n654 VSS 0.03207f
C4990 VDD.n655 VSS 0.02515f
C4991 VDD.n656 VSS 0.01387f
C4992 VDD.t39 VSS 0.00759f
C4993 VDD.n657 VSS 0.03413f
C4994 VDD.n658 VSS 0.01883f
C4995 VDD.n659 VSS 0.0116f
C4996 VDD.t41 VSS 0.00759f
C4997 VDD.n660 VSS 0.02195f
C4998 VDD.t192 VSS 0.00759f
C4999 VDD.n661 VSS 0.02195f
C5000 VDD.n662 VSS 0.02756f
C5001 VDD.t38 VSS 0.00687f
C5002 VDD.t43 VSS 0.00687f
C5003 VDD.n663 VSS 0.00879f
C5004 VDD.t44 VSS 0.00687f
C5005 VDD.n664 VSS 0.00879f
C5006 VDD.t40 VSS 0.00687f
C5007 VDD.n665 VSS 0.0172f
C5008 VDD.t335 VSS 0.00687f
C5009 VDD.n667 VSS 0.00879f
C5010 VDD.t334 VSS 0.00687f
C5011 VDD.n668 VSS 0.0172f
C5012 VDD.t37 VSS 0.58514f
C5013 VDD.n670 VSS 0.11049f
C5014 VDD.n672 VSS 0.0172f
C5015 VDD.n673 VSS 0.01726f
C5016 VDD.n674 VSS 0.34795f
C5017 VDD.n675 VSS 0.02323f
C5018 VDD.t47 VSS 0.00687f
C5019 VDD.t26 VSS 0.00687f
C5020 VDD.n676 VSS 0.03207f
C5021 VDD.n677 VSS 0.02515f
C5022 VDD.n678 VSS 0.00779f
C5023 VDD.t18 VSS 0.00759f
C5024 VDD.n679 VSS 0.03413f
C5025 VDD.n680 VSS 0.01883f
C5026 VDD.n681 VSS 0.0116f
C5027 VDD.t22 VSS 0.00759f
C5028 VDD.n682 VSS 0.02195f
C5029 VDD.t195 VSS 0.00759f
C5030 VDD.n683 VSS 0.02195f
C5031 VDD.n684 VSS 0.11599f
C5032 VDD.n685 VSS 0.11599f
C5033 VDD.t24 VSS 0.00687f
C5034 VDD.t20 VSS 0.00687f
C5035 VDD.n686 VSS 0.03207f
C5036 VDD.n687 VSS 0.02515f
C5037 VDD.n688 VSS 0.00779f
C5038 VDD.t23 VSS 0.00759f
C5039 VDD.n689 VSS 0.03413f
C5040 VDD.n690 VSS 0.01883f
C5041 VDD.n691 VSS 0.0116f
C5042 VDD.t19 VSS 0.00759f
C5043 VDD.n692 VSS 0.02195f
C5044 VDD.t178 VSS 0.00759f
C5045 VDD.n693 VSS 0.02195f
C5046 VDD.n694 VSS 0.11599f
C5047 VDD.n695 VSS 0.11599f
C5048 VDD.t21 VSS 0.00687f
C5049 VDD.t1193 VSS 0.00687f
C5050 VDD.n696 VSS 0.03207f
C5051 VDD.n697 VSS 0.02515f
C5052 VDD.n698 VSS 0.00779f
C5053 VDD.t1171 VSS 0.00759f
C5054 VDD.n699 VSS 0.03413f
C5055 VDD.n700 VSS 0.01883f
C5056 VDD.n701 VSS 0.0116f
C5057 VDD.t1169 VSS 0.00759f
C5058 VDD.n702 VSS 0.02195f
C5059 VDD.t1157 VSS 0.00759f
C5060 VDD.n703 VSS 0.02195f
C5061 VDD.n704 VSS 0.11789f
C5062 VDD.n705 VSS 0.11789f
C5063 VDD.t1155 VSS 0.00687f
C5064 VDD.t1187 VSS 0.00687f
C5065 VDD.n706 VSS 0.03207f
C5066 VDD.n707 VSS 0.02515f
C5067 VDD.n708 VSS 0.00779f
C5068 VDD.t1154 VSS 0.00759f
C5069 VDD.n709 VSS 0.03413f
C5070 VDD.n710 VSS 0.01883f
C5071 VDD.n711 VSS 0.0116f
C5072 VDD.t1163 VSS 0.00759f
C5073 VDD.n712 VSS 0.02195f
C5074 VDD.t1152 VSS 0.00759f
C5075 VDD.n713 VSS 0.02195f
C5076 VDD.n714 VSS 0.11789f
C5077 VDD.n715 VSS 0.11789f
C5078 VDD.t1178 VSS 0.00687f
C5079 VDD.t1161 VSS 0.00687f
C5080 VDD.n716 VSS 0.03207f
C5081 VDD.n717 VSS 0.02515f
C5082 VDD.n718 VSS 0.00779f
C5083 VDD.t1177 VSS 0.00759f
C5084 VDD.n719 VSS 0.03413f
C5085 VDD.n720 VSS 0.01883f
C5086 VDD.n721 VSS 0.0116f
C5087 VDD.t1160 VSS 0.00759f
C5088 VDD.n722 VSS 0.02195f
C5089 VDD.t1150 VSS 0.00759f
C5090 VDD.n723 VSS 0.02195f
C5091 VDD.n724 VSS 0.11789f
C5092 VDD.n725 VSS 0.11789f
C5093 VDD.t1158 VSS 0.00687f
C5094 VDD.t1192 VSS 0.00687f
C5095 VDD.n726 VSS 0.03207f
C5096 VDD.n727 VSS 0.02515f
C5097 VDD.n728 VSS 0.00779f
C5098 VDD.t1156 VSS 0.00759f
C5099 VDD.n729 VSS 0.03413f
C5100 VDD.n730 VSS 0.01883f
C5101 VDD.n731 VSS 0.0116f
C5102 VDD.t1174 VSS 0.00759f
C5103 VDD.n732 VSS 0.02195f
C5104 VDD.t1165 VSS 0.00759f
C5105 VDD.n733 VSS 0.02195f
C5106 VDD.n734 VSS 0.11789f
C5107 VDD.n735 VSS 0.11789f
C5108 VDD.t1194 VSS 0.00687f
C5109 VDD.t1274 VSS 0.00687f
C5110 VDD.n736 VSS 0.03207f
C5111 VDD.n737 VSS 0.02515f
C5112 VDD.n738 VSS 0.00779f
C5113 VDD.t1264 VSS 0.00759f
C5114 VDD.n739 VSS 0.03413f
C5115 VDD.n740 VSS 0.01883f
C5116 VDD.n741 VSS 0.0116f
C5117 VDD.t1255 VSS 0.00759f
C5118 VDD.n742 VSS 0.02195f
C5119 VDD.t1266 VSS 0.00759f
C5120 VDD.n743 VSS 0.02195f
C5121 VDD.n744 VSS 0.11789f
C5122 VDD.n745 VSS 0.11789f
C5123 VDD.t1293 VSS 0.00687f
C5124 VDD.t1277 VSS 0.00687f
C5125 VDD.n746 VSS 0.03207f
C5126 VDD.n747 VSS 0.02515f
C5127 VDD.n748 VSS 0.00779f
C5128 VDD.t1254 VSS 0.00759f
C5129 VDD.n749 VSS 0.03413f
C5130 VDD.n750 VSS 0.01883f
C5131 VDD.n751 VSS 0.0116f
C5132 VDD.t1271 VSS 0.00759f
C5133 VDD.n752 VSS 0.02195f
C5134 VDD.t1258 VSS 0.00759f
C5135 VDD.n753 VSS 0.02195f
C5136 VDD.n754 VSS 0.11789f
C5137 VDD.n755 VSS 0.11789f
C5138 VDD.t1269 VSS 0.00687f
C5139 VDD.t1301 VSS 0.00687f
C5140 VDD.n756 VSS 0.03207f
C5141 VDD.n757 VSS 0.02515f
C5142 VDD.n758 VSS 0.00779f
C5143 VDD.t1268 VSS 0.00759f
C5144 VDD.n759 VSS 0.03413f
C5145 VDD.n760 VSS 0.01883f
C5146 VDD.n761 VSS 0.0116f
C5147 VDD.t1285 VSS 0.00759f
C5148 VDD.n762 VSS 0.02195f
C5149 VDD.t1273 VSS 0.00759f
C5150 VDD.n763 VSS 0.02195f
C5151 VDD.n764 VSS 0.11789f
C5152 VDD.n765 VSS 0.11789f
C5153 VDD.t1262 VSS 0.00687f
C5154 VDD.t1294 VSS 0.00687f
C5155 VDD.n766 VSS 0.03207f
C5156 VDD.n767 VSS 0.02515f
C5157 VDD.n768 VSS 0.00779f
C5158 VDD.t1261 VSS 0.00759f
C5159 VDD.n769 VSS 0.03413f
C5160 VDD.n770 VSS 0.01883f
C5161 VDD.n771 VSS 0.0116f
C5162 VDD.t1259 VSS 0.00759f
C5163 VDD.n772 VSS 0.02195f
C5164 VDD.t1287 VSS 0.00759f
C5165 VDD.n773 VSS 0.02195f
C5166 VDD.n774 VSS 0.11789f
C5167 VDD.n775 VSS 0.11789f
C5168 VDD.t1286 VSS 0.00687f
C5169 VDD.t584 VSS 0.00687f
C5170 VDD.n776 VSS 0.03207f
C5171 VDD.n777 VSS 0.02515f
C5172 VDD.n778 VSS 0.00779f
C5173 VDD.t562 VSS 0.00759f
C5174 VDD.n779 VSS 0.03413f
C5175 VDD.n780 VSS 0.01883f
C5176 VDD.n781 VSS 0.0116f
C5177 VDD.t619 VSS 0.00687f
C5178 VDD.t564 VSS 0.00687f
C5179 VDD.n782 VSS 0.03207f
C5180 VDD.n783 VSS 0.02515f
C5181 VDD.n784 VSS 0.00779f
C5182 VDD.t597 VSS 0.00759f
C5183 VDD.n785 VSS 0.03413f
C5184 VDD.n786 VSS 0.01883f
C5185 VDD.t558 VSS 0.00759f
C5186 VDD.n787 VSS 0.03413f
C5187 VDD.n788 VSS 0.01883f
C5188 VDD.n789 VSS 0.0116f
C5189 VDD.t606 VSS 0.00759f
C5190 VDD.n790 VSS 0.02195f
C5191 VDD.n791 VSS 0.17202f
C5192 VDD.n792 VSS 0.00779f
C5193 VDD.t572 VSS 0.00759f
C5194 VDD.t581 VSS 0.00687f
C5195 VDD.t559 VSS 0.00687f
C5196 VDD.n793 VSS 0.02515f
C5197 VDD.n794 VSS 0.03207f
C5198 VDD.n795 VSS 0.00695f
C5199 VDD.n796 VSS 0.00695f
C5200 VDD.n797 VSS 0.00695f
C5201 VDD.t548 VSS 0.00687f
C5202 VDD.n798 VSS 0.03207f
C5203 VDD.n799 VSS 0.00695f
C5204 VDD.t585 VSS 0.00759f
C5205 VDD.n800 VSS 0.03413f
C5206 VDD.n801 VSS 0.01883f
C5207 VDD.n802 VSS 0.0116f
C5208 VDD.t613 VSS 0.00687f
C5209 VDD.t563 VSS 0.00687f
C5210 VDD.n803 VSS 0.03207f
C5211 VDD.n804 VSS 0.02515f
C5212 VDD.n805 VSS 0.00779f
C5213 VDD.t593 VSS 0.00759f
C5214 VDD.n806 VSS 0.03413f
C5215 VDD.n807 VSS 0.01883f
C5216 VDD.n808 VSS 0.0116f
C5217 VDD.t615 VSS 0.00759f
C5218 VDD.n809 VSS 0.02195f
C5219 VDD.n810 VSS 0.02418f
C5220 VDD.t642 VSS 0.00687f
C5221 VDD.t570 VSS 0.00687f
C5222 VDD.n811 VSS 0.03207f
C5223 VDD.n812 VSS 0.02515f
C5224 VDD.n813 VSS 0.00779f
C5225 VDD.t623 VSS 0.00759f
C5226 VDD.n814 VSS 0.03413f
C5227 VDD.n815 VSS 0.01883f
C5228 VDD.t560 VSS 0.00759f
C5229 VDD.n816 VSS 0.03413f
C5230 VDD.n817 VSS 0.01883f
C5231 VDD.n818 VSS 0.0116f
C5232 VDD.t583 VSS 0.00759f
C5233 VDD.n819 VSS 0.02195f
C5234 VDD.n820 VSS 0.17202f
C5235 VDD.t611 VSS 0.00699f
C5236 VDD.n821 VSS 0.04124f
C5237 VDD.t555 VSS 0.00759f
C5238 VDD.n822 VSS 0.00695f
C5239 VDD.n823 VSS 0.00695f
C5240 VDD.n824 VSS 0.00695f
C5241 VDD.t569 VSS 0.00687f
C5242 VDD.n825 VSS 0.03207f
C5243 VDD.n826 VSS 0.00695f
C5244 VDD.t557 VSS 0.00759f
C5245 VDD.n827 VSS 0.03413f
C5246 VDD.n828 VSS 0.01883f
C5247 VDD.n829 VSS 0.0116f
C5248 VDD.t625 VSS 0.00687f
C5249 VDD.t580 VSS 0.00687f
C5250 VDD.n830 VSS 0.03207f
C5251 VDD.n831 VSS 0.02515f
C5252 VDD.n832 VSS 0.00779f
C5253 VDD.t565 VSS 0.00759f
C5254 VDD.n833 VSS 0.03413f
C5255 VDD.n834 VSS 0.01883f
C5256 VDD.n835 VSS 0.0116f
C5257 VDD.t553 VSS 0.00759f
C5258 VDD.n836 VSS 0.02195f
C5259 VDD.n837 VSS 0.17202f
C5260 VDD.n838 VSS 0.00779f
C5261 VDD.t682 VSS 0.00759f
C5262 VDD.n839 VSS 0.00695f
C5263 VDD.t736 VSS 0.00687f
C5264 VDD.t717 VSS 0.00687f
C5265 VDD.n840 VSS 0.02515f
C5266 VDD.n841 VSS 0.03207f
C5267 VDD.n842 VSS 0.00695f
C5268 VDD.n843 VSS 0.00695f
C5269 VDD.n844 VSS 0.00695f
C5270 VDD.n845 VSS 0.00695f
C5271 VDD.n846 VSS 0.00695f
C5272 VDD.n847 VSS 0.00695f
C5273 VDD.n848 VSS 0.00695f
C5274 VDD.n849 VSS 0.00695f
C5275 VDD.n850 VSS 0.00695f
C5276 VDD.n851 VSS 0.00695f
C5277 VDD.n852 VSS 0.01223f
C5278 VDD.t1229 VSS 0.00687f
C5279 VDD.n853 VSS 0.01619f
C5280 VDD.n854 VSS 0.00695f
C5281 VDD.n855 VSS 0.00695f
C5282 VDD.n856 VSS 0.00695f
C5283 VDD.t1029 VSS 0.00687f
C5284 VDD.n857 VSS 0.03207f
C5285 VDD.n858 VSS 0.00695f
C5286 VDD.t1028 VSS 0.00759f
C5287 VDD.n859 VSS 0.03413f
C5288 VDD.n860 VSS 0.01883f
C5289 VDD.n861 VSS 0.0116f
C5290 VDD.t1020 VSS 0.00759f
C5291 VDD.n862 VSS 0.03413f
C5292 VDD.t1019 VSS 0.00687f
C5293 VDD.t1032 VSS 0.00687f
C5294 VDD.n863 VSS 0.03207f
C5295 VDD.n864 VSS 0.02515f
C5296 VDD.n865 VSS 0.01387f
C5297 VDD.t1031 VSS 0.00759f
C5298 VDD.n866 VSS 0.03413f
C5299 VDD.n867 VSS 0.01883f
C5300 VDD.n868 VSS 0.0116f
C5301 VDD.t1017 VSS 0.00687f
C5302 VDD.t1037 VSS 0.00687f
C5303 VDD.n869 VSS 0.03207f
C5304 VDD.n870 VSS 0.02515f
C5305 VDD.n871 VSS 0.00779f
C5306 VDD.t1038 VSS 0.00759f
C5307 VDD.n872 VSS 0.03413f
C5308 VDD.n873 VSS 0.01883f
C5309 VDD.n874 VSS 0.0116f
C5310 VDD.t1026 VSS 0.00687f
C5311 VDD.t1035 VSS 0.00687f
C5312 VDD.n875 VSS 0.03207f
C5313 VDD.n876 VSS 0.02515f
C5314 VDD.n877 VSS 0.00779f
C5315 VDD.t1034 VSS 0.00759f
C5316 VDD.n878 VSS 0.03413f
C5317 VDD.n879 VSS 0.01883f
C5318 VDD.n880 VSS 0.0116f
C5319 VDD.t1023 VSS 0.00687f
C5320 VDD.n881 VSS 0.02515f
C5321 VDD.n882 VSS 0.00779f
C5322 VDD.t1228 VSS 0.00759f
C5323 VDD.n883 VSS 0.02716f
C5324 VDD.n884 VSS 0.01883f
C5325 VDD.n885 VSS 0.0116f
C5326 VDD.t1209 VSS 0.00687f
C5327 VDD.t1233 VSS 0.00687f
C5328 VDD.n886 VSS 0.03207f
C5329 VDD.n887 VSS 0.02515f
C5330 VDD.n888 VSS 0.00779f
C5331 VDD.t1231 VSS 0.00759f
C5332 VDD.n889 VSS 0.03413f
C5333 VDD.n890 VSS 0.01883f
C5334 VDD.n891 VSS 0.0116f
C5335 VDD.t1212 VSS 0.00687f
C5336 VDD.t1214 VSS 0.00687f
C5337 VDD.n892 VSS 0.03207f
C5338 VDD.n893 VSS 0.02515f
C5339 VDD.n894 VSS 0.00779f
C5340 VDD.t1213 VSS 0.00759f
C5341 VDD.n895 VSS 0.03413f
C5342 VDD.n896 VSS 0.01883f
C5343 VDD.n897 VSS 0.0116f
C5344 VDD.t1243 VSS 0.00687f
C5345 VDD.t1241 VSS 0.00687f
C5346 VDD.n898 VSS 0.03207f
C5347 VDD.n899 VSS 0.02515f
C5348 VDD.n900 VSS 0.00779f
C5349 VDD.t1240 VSS 0.00759f
C5350 VDD.n901 VSS 0.03413f
C5351 VDD.n902 VSS 0.01883f
C5352 VDD.n903 VSS 0.0116f
C5353 VDD.t1237 VSS 0.00687f
C5354 VDD.t865 VSS 0.00687f
C5355 VDD.n904 VSS 0.03207f
C5356 VDD.n905 VSS 0.02515f
C5357 VDD.n906 VSS 0.00779f
C5358 VDD.t863 VSS 0.00759f
C5359 VDD.n907 VSS 0.03413f
C5360 VDD.n908 VSS 0.01883f
C5361 VDD.n909 VSS 0.0116f
C5362 VDD.t909 VSS 0.00687f
C5363 VDD.t906 VSS 0.00687f
C5364 VDD.n910 VSS 0.03207f
C5365 VDD.n911 VSS 0.02515f
C5366 VDD.n912 VSS 0.00779f
C5367 VDD.t905 VSS 0.00759f
C5368 VDD.n913 VSS 0.03413f
C5369 VDD.n914 VSS 0.01883f
C5370 VDD.n915 VSS 0.0116f
C5371 VDD.t904 VSS 0.00687f
C5372 VDD.t874 VSS 0.00687f
C5373 VDD.n916 VSS 0.03207f
C5374 VDD.n917 VSS 0.02515f
C5375 VDD.n918 VSS 0.00779f
C5376 VDD.t872 VSS 0.00759f
C5377 VDD.n919 VSS 0.03413f
C5378 VDD.n920 VSS 0.01883f
C5379 VDD.n921 VSS 0.0116f
C5380 VDD.t867 VSS 0.00687f
C5381 VDD.t878 VSS 0.00687f
C5382 VDD.n922 VSS 0.03207f
C5383 VDD.n923 VSS 0.02515f
C5384 VDD.n924 VSS 0.00779f
C5385 VDD.t879 VSS 0.00759f
C5386 VDD.n925 VSS 0.03413f
C5387 VDD.n926 VSS 0.01883f
C5388 VDD.n927 VSS 0.0116f
C5389 VDD.t887 VSS 0.00687f
C5390 VDD.t720 VSS 0.00687f
C5391 VDD.n928 VSS 0.03207f
C5392 VDD.n929 VSS 0.02515f
C5393 VDD.n930 VSS 0.00779f
C5394 VDD.t707 VSS 0.00759f
C5395 VDD.n931 VSS 0.03413f
C5396 VDD.n932 VSS 0.01883f
C5397 VDD.n933 VSS 0.0116f
C5398 VDD.t680 VSS 0.00687f
C5399 VDD.t730 VSS 0.00687f
C5400 VDD.n934 VSS 0.03207f
C5401 VDD.n935 VSS 0.02515f
C5402 VDD.n936 VSS 0.00779f
C5403 VDD.t716 VSS 0.00759f
C5404 VDD.n937 VSS 0.03413f
C5405 VDD.n938 VSS 0.01883f
C5406 VDD.t692 VSS 0.00759f
C5407 VDD.n939 VSS 0.03413f
C5408 VDD.n940 VSS 0.01883f
C5409 VDD.n941 VSS 0.0116f
C5410 VDD.t738 VSS 0.00759f
C5411 VDD.n942 VSS 0.02195f
C5412 VDD.n943 VSS 0.26136f
C5413 VDD.n944 VSS 0.00779f
C5414 VDD.t690 VSS 0.00759f
C5415 VDD.t700 VSS 0.00687f
C5416 VDD.t675 VSS 0.00687f
C5417 VDD.n945 VSS 0.02515f
C5418 VDD.n946 VSS 0.03207f
C5419 VDD.n947 VSS 0.00695f
C5420 VDD.n948 VSS 0.00695f
C5421 VDD.n949 VSS 0.00695f
C5422 VDD.n950 VSS 0.00695f
C5423 VDD.n951 VSS 0.00695f
C5424 VDD.n952 VSS 0.00695f
C5425 VDD.n953 VSS 0.00695f
C5426 VDD.n954 VSS 0.00695f
C5427 VDD.n955 VSS 0.00695f
C5428 VDD.n956 VSS 0.00695f
C5429 VDD.n957 VSS 0.00695f
C5430 VDD.n958 VSS 0.00695f
C5431 VDD.n959 VSS 0.00695f
C5432 VDD.n960 VSS 0.00695f
C5433 VDD.n961 VSS 0.00695f
C5434 VDD.n962 VSS 0.00695f
C5435 VDD.t1246 VSS 0.00687f
C5436 VDD.n963 VSS 0.03207f
C5437 VDD.n964 VSS 0.00695f
C5438 VDD.t1247 VSS 0.00759f
C5439 VDD.n965 VSS 0.03413f
C5440 VDD.n966 VSS 0.01883f
C5441 VDD.n967 VSS 0.0116f
C5442 VDD.t1250 VSS 0.00759f
C5443 VDD.n968 VSS 0.03413f
C5444 VDD.t1249 VSS 0.00687f
C5445 VDD.t326 VSS 0.00687f
C5446 VDD.n969 VSS 0.03207f
C5447 VDD.n970 VSS 0.02515f
C5448 VDD.n971 VSS 0.01387f
C5449 VDD.t324 VSS 0.00759f
C5450 VDD.n972 VSS 0.03413f
C5451 VDD.n973 VSS 0.01883f
C5452 VDD.n974 VSS 0.0116f
C5453 VDD.t325 VSS 0.00759f
C5454 VDD.n975 VSS 0.03413f
C5455 VDD.t328 VSS 0.00687f
C5456 VDD.t338 VSS 0.00687f
C5457 VDD.n976 VSS 0.03207f
C5458 VDD.n977 VSS 0.02515f
C5459 VDD.n978 VSS 0.01387f
C5460 VDD.t333 VSS 0.00759f
C5461 VDD.n979 VSS 0.03413f
C5462 VDD.n980 VSS 0.01883f
C5463 VDD.n981 VSS 0.0116f
C5464 VDD.t336 VSS 0.00759f
C5465 VDD.n982 VSS 0.02195f
C5466 VDD.t1016 VSS 0.00759f
C5467 VDD.n983 VSS 0.02195f
C5468 VDD.n984 VSS 0.11599f
C5469 VDD.n985 VSS 0.11599f
C5470 VDD.t340 VSS 0.00687f
C5471 VDD.t108 VSS 0.00687f
C5472 VDD.n986 VSS 0.03207f
C5473 VDD.n987 VSS 0.02515f
C5474 VDD.n988 VSS 0.00779f
C5475 VDD.t105 VSS 0.00759f
C5476 VDD.n989 VSS 0.03413f
C5477 VDD.n990 VSS 0.01883f
C5478 VDD.n991 VSS 0.0116f
C5479 VDD.t102 VSS 0.00759f
C5480 VDD.n992 VSS 0.02195f
C5481 VDD.t1025 VSS 0.00759f
C5482 VDD.n993 VSS 0.02195f
C5483 VDD.n994 VSS 0.02756f
C5484 VDD.n995 VSS 0.23357f
C5485 VDD.t829 VSS 0.00687f
C5486 VDD.t1253 VSS 0.00687f
C5487 VDD.t825 VSS 0.00687f
C5488 VDD.n997 VSS 0.0172f
C5489 VDD.n998 VSS 0.00879f
C5490 VDD.t1252 VSS 0.00687f
C5491 VDD.t1068 VSS 0.00687f
C5492 VDD.t919 VSS 0.00687f
C5493 VDD.t1067 VSS 0.00687f
C5494 VDD.n1000 VSS 0.0172f
C5495 VDD.n1001 VSS 0.00879f
C5496 VDD.t918 VSS 0.00687f
C5497 VDD.t1146 VSS 0.00687f
C5498 VDD.n1002 VSS 0.23552f
C5499 VDD.n1003 VSS 0.01471f
C5500 VDD.n1007 VSS 0.14943f
C5501 VDD.t89 VSS 1.07902f
C5502 VDD.t88 VSS 0.00687f
C5503 VDD.n1008 VSS 0.01656f
C5504 VDD.t86 VSS 0.00687f
C5505 VDD.n1009 VSS 0.00879f
C5506 VDD.t447 VSS 0.00687f
C5507 VDD.n1010 VSS 0.01656f
C5508 VDD.t440 VSS 1.29483f
C5509 VDD.t448 VSS 0.00687f
C5510 VDD.n1011 VSS 0.00879f
C5511 VDD.t80 VSS 1.96713f
C5512 VDD.t443 VSS 0.00687f
C5513 VDD.n1012 VSS 0.01656f
C5514 VDD.t446 VSS 0.00687f
C5515 VDD.n1013 VSS 0.00879f
C5516 VDD.n1014 VSS 0.0116f
C5517 VDD.t118 VSS 0.00687f
C5518 VDD.n1015 VSS 0.0172f
C5519 VDD.t119 VSS 0.00687f
C5520 VDD.n1017 VSS 0.00879f
C5521 VDD.t82 VSS 1.0106f
C5522 VDD.t79 VSS 0.00687f
C5523 VDD.n1019 VSS 0.00879f
C5524 VDD.t455 VSS 0.00687f
C5525 VDD.n1021 VSS 0.00879f
C5526 VDD.t330 VSS 1.65921f
C5527 VDD.t456 VSS 0.00687f
C5528 VDD.n1023 VSS 0.00879f
C5529 VDD.t463 VSS 0.00687f
C5530 VDD.n1024 VSS 0.01656f
C5531 VDD.t466 VSS 0.00687f
C5532 VDD.n1025 VSS 0.00879f
C5533 VDD.t57 VSS 1.07902f
C5534 VDD.t58 VSS 0.00687f
C5535 VDD.n1026 VSS 0.01656f
C5536 VDD.t51 VSS 1.60274f
C5537 VDD.t54 VSS 0.00687f
C5538 VDD.n1027 VSS 0.00879f
C5539 VDD.t53 VSS 0.00687f
C5540 VDD.n1028 VSS 0.01656f
C5541 VDD.t50 VSS 0.00687f
C5542 VDD.n1029 VSS 0.00879f
C5543 VDD.t56 VSS 0.00687f
C5544 VDD.n1030 VSS 0.00879f
C5545 VDD.t49 VSS 0.00687f
C5546 VDD.n1031 VSS 0.0172f
C5547 VDD.t48 VSS 0.54422f
C5548 VDD.t55 VSS 0.00687f
C5549 VDD.n1033 VSS 0.00879f
C5550 VDD.t52 VSS 0.00687f
C5551 VDD.n1034 VSS 0.0172f
C5552 VDD.t467 VSS 0.00687f
C5553 VDD.n1036 VSS 0.00879f
C5554 VDD.t465 VSS 0.00687f
C5555 VDD.n1037 VSS 0.0172f
C5556 VDD.t464 VSS 1.0106f
C5557 VDD.t332 VSS 0.00687f
C5558 VDD.n1039 VSS 0.00879f
C5559 VDD.t331 VSS 0.00687f
C5560 VDD.n1041 VSS 0.0172f
C5561 VDD.t772 VSS 0.00687f
C5562 VDD.n1042 VSS 0.0171f
C5563 VDD.n1043 VSS 0.0116f
C5564 VDD.t450 VSS 0.00687f
C5565 VDD.t453 VSS 0.00687f
C5566 VDD.n1044 VSS 0.0172f
C5567 VDD.n1045 VSS 0.00879f
C5568 VDD.t457 VSS 0.00687f
C5569 VDD.n1046 VSS 0.01656f
C5570 VDD.t454 VSS 0.00687f
C5571 VDD.t452 VSS 0.00687f
C5572 VDD.n1047 VSS 0.0172f
C5573 VDD.n1048 VSS 0.00879f
C5574 VDD.t451 VSS 1.60274f
C5575 VDD.t449 VSS 0.00687f
C5576 VDD.n1049 VSS 0.01656f
C5577 VDD.t78 VSS 1.07902f
C5578 VDD.t83 VSS 0.00687f
C5579 VDD.t84 VSS 0.00687f
C5580 VDD.n1050 VSS 0.0172f
C5581 VDD.n1051 VSS 0.00879f
C5582 VDD.t81 VSS 0.00687f
C5583 VDD.n1052 VSS 0.01656f
C5584 VDD.t445 VSS 0.00687f
C5585 VDD.t1302 VSS 0.00687f
C5586 VDD.n1053 VSS 0.0171f
C5587 VDD.n1054 VSS 0.00879f
C5588 VDD.t442 VSS 0.00687f
C5589 VDD.n1055 VSS 0.0172f
C5590 VDD.t444 VSS 0.00687f
C5591 VDD.n1057 VSS 0.00879f
C5592 VDD.t441 VSS 0.00687f
C5593 VDD.n1058 VSS 0.0172f
C5594 VDD.n1060 VSS 0.01481f
C5595 VDD.t90 VSS 0.00687f
C5596 VDD.n1061 VSS 0.00879f
C5597 VDD.t91 VSS 0.00687f
C5598 VDD.n1062 VSS 0.0172f
C5599 VDD.n1064 VSS 0.23304f
C5600 VDD.t496 VSS 0.00687f
C5601 VDD.t501 VSS 0.00687f
C5602 VDD.n1066 VSS 0.00879f
C5603 VDD.t502 VSS 0.00687f
C5604 VDD.n1067 VSS 0.0172f
C5605 VDD.t497 VSS 0.00687f
C5606 VDD.n1069 VSS 0.00879f
C5607 VDD.t300 VSS 0.00687f
C5608 VDD.n1070 VSS 0.00696f
C5609 VDD.t297 VSS 0.00687f
C5610 VDD.n1071 VSS 0.00879f
C5611 VDD.n1072 VSS 0.0116f
C5612 VDD.t158 VSS 0.00687f
C5613 VDD.t775 VSS 0.00687f
C5614 VDD.n1073 VSS 0.0171f
C5615 VDD.n1074 VSS 0.0172f
C5616 VDD.t162 VSS 0.00687f
C5617 VDD.n1076 VSS 0.00879f
C5618 VDD.t156 VSS 0.00687f
C5619 VDD.n1077 VSS 0.01199f
C5620 VDD.t159 VSS 0.00687f
C5621 VDD.n1078 VSS 0.00879f
C5622 VDD.t3 VSS 0.00687f
C5623 VDD.n1080 VSS 0.00879f
C5624 VDD.t514 VSS 0.00687f
C5625 VDD.n1082 VSS 0.00879f
C5626 VDD.t529 VSS 0.00687f
C5627 VDD.n1084 VSS 0.00879f
C5628 VDD.t533 VSS 0.00687f
C5629 VDD.n1086 VSS 0.00879f
C5630 VDD.t33 VSS 0.00687f
C5631 VDD.n1087 VSS 0.00696f
C5632 VDD.t31 VSS 0.00687f
C5633 VDD.n1088 VSS 0.00879f
C5634 VDD.t1147 VSS 0.00687f
C5635 VDD.n1089 VSS 0.0171f
C5636 VDD.n1090 VSS 0.0116f
C5637 VDD.t774 VSS 0.00687f
C5638 VDD.n1091 VSS 0.00879f
C5639 VDD.t773 VSS 0.00687f
C5640 VDD.n1092 VSS 0.0172f
C5641 VDD.t30 VSS 0.00687f
C5642 VDD.n1094 VSS 0.00879f
C5643 VDD.t32 VSS 0.00687f
C5644 VDD.n1095 VSS 0.0172f
C5645 VDD.t532 VSS 0.00687f
C5646 VDD.t530 VSS 0.00687f
C5647 VDD.n1097 VSS 0.0172f
C5648 VDD.n1098 VSS 0.00879f
C5649 VDD.t535 VSS 0.00687f
C5650 VDD.n1099 VSS 0.01199f
C5651 VDD.t531 VSS 0.00687f
C5652 VDD.t528 VSS 0.00687f
C5653 VDD.n1100 VSS 0.0172f
C5654 VDD.n1101 VSS 0.00879f
C5655 VDD.t1149 VSS 0.00687f
C5656 VDD.t534 VSS 0.00687f
C5657 VDD.n1103 VSS 0.0172f
C5658 VDD.n1104 VSS 0.0171f
C5659 VDD.n1105 VSS 0.0116f
C5660 VDD.t4 VSS 0.00687f
C5661 VDD.t515 VSS 0.00687f
C5662 VDD.n1106 VSS 0.0172f
C5663 VDD.n1107 VSS 0.00879f
C5664 VDD.t2 VSS 0.00687f
C5665 VDD.n1108 VSS 0.00696f
C5666 VDD.t163 VSS 0.00687f
C5667 VDD.t1 VSS 0.00687f
C5668 VDD.n1109 VSS 0.0172f
C5669 VDD.n1110 VSS 0.00879f
C5670 VDD.t160 VSS 0.00687f
C5671 VDD.n1111 VSS 0.0172f
C5672 VDD.t157 VSS 0.00687f
C5673 VDD.n1113 VSS 0.00879f
C5674 VDD.t161 VSS 0.00687f
C5675 VDD.n1114 VSS 0.0172f
C5676 VDD.t171 VSS 0.00687f
C5677 VDD.n1116 VSS 0.00879f
C5678 VDD.t170 VSS 0.00687f
C5679 VDD.n1117 VSS 0.0172f
C5680 VDD.t299 VSS 0.00687f
C5681 VDD.n1119 VSS 0.00879f
C5682 VDD.n1120 VSS 0.31831f
C5683 VDD.t518 VSS 0.00774f
C5684 VDD.t1318 VSS 0.00751f
C5685 VDD.n1121 VSS 0.01375f
C5686 VDD.t1325 VSS 0.00751f
C5687 VDD.n1122 VSS 0.00525f
C5688 VDD.n1123 VSS 0.02303f
C5689 VDD.t519 VSS 0.00774f
C5690 VDD.t1304 VSS 0.00751f
C5691 VDD.n1124 VSS 0.01375f
C5692 VDD.t1306 VSS 0.00751f
C5693 VDD.n1125 VSS 0.00525f
C5694 VDD.n1126 VSS 0.02333f
C5695 VDD.t521 VSS 0.00703f
C5696 VDD.t1314 VSS 0.0068f
C5697 VDD.n1127 VSS 0.01375f
C5698 VDD.t1337 VSS 0.0068f
C5699 VDD.n1128 VSS 0.00988f
C5700 VDD.n1129 VSS 0.03184f
C5701 VDD.t516 VSS 0.00774f
C5702 VDD.t1323 VSS 0.00751f
C5703 VDD.n1130 VSS 0.01375f
C5704 VDD.t1307 VSS 0.00751f
C5705 VDD.n1131 VSS 0.00525f
C5706 VDD.n1132 VSS 0.01924f
C5707 VDD.n1133 VSS 0.26628f
C5708 VDD.n1134 VSS 0.0217f
C5709 VDD.t1076 VSS 0.00687f
C5710 VDD.t861 VSS 0.00687f
C5711 VDD.n1135 VSS 0.01656f
C5712 VDD.t859 VSS 0.00687f
C5713 VDD.n1136 VSS 0.00879f
C5714 VDD.t1074 VSS 0.00687f
C5715 VDD.n1137 VSS 0.01656f
C5716 VDD.t1079 VSS 0.00687f
C5717 VDD.n1138 VSS 0.00879f
C5718 VDD.t1072 VSS 0.00687f
C5719 VDD.n1139 VSS 0.01656f
C5720 VDD.n1140 VSS 0.0116f
C5721 VDD.t117 VSS 0.00687f
C5722 VDD.n1141 VSS 0.0172f
C5723 VDD.t116 VSS 0.00687f
C5724 VDD.n1143 VSS 0.00879f
C5725 VDD.t71 VSS 0.00687f
C5726 VDD.n1145 VSS 0.00879f
C5727 VDD.t661 VSS 0.00687f
C5728 VDD.n1147 VSS 0.00879f
C5729 VDD.t662 VSS 0.00687f
C5730 VDD.n1149 VSS 0.00879f
C5731 VDD.t112 VSS 0.00687f
C5732 VDD.n1150 VSS 0.01656f
C5733 VDD.t114 VSS 0.00687f
C5734 VDD.n1151 VSS 0.00879f
C5735 VDD.t146 VSS 0.00687f
C5736 VDD.n1152 VSS 0.01656f
C5737 VDD.t142 VSS 0.00687f
C5738 VDD.n1153 VSS 0.00879f
C5739 VDD.t143 VSS 0.00687f
C5740 VDD.n1154 VSS 0.01656f
C5741 VDD.t141 VSS 0.00687f
C5742 VDD.n1155 VSS 0.00879f
C5743 VDD.t145 VSS 0.00687f
C5744 VDD.n1156 VSS 0.00879f
C5745 VDD.t140 VSS 0.00687f
C5746 VDD.n1157 VSS 0.0172f
C5747 VDD.t144 VSS 0.00687f
C5748 VDD.n1159 VSS 0.00879f
C5749 VDD.t139 VSS 0.00687f
C5750 VDD.n1160 VSS 0.0172f
C5751 VDD.t115 VSS 0.00687f
C5752 VDD.n1162 VSS 0.00879f
C5753 VDD.t113 VSS 0.00687f
C5754 VDD.n1163 VSS 0.0172f
C5755 VDD.t165 VSS 0.00687f
C5756 VDD.n1165 VSS 0.00879f
C5757 VDD.t164 VSS 0.00687f
C5758 VDD.n1167 VSS 0.0172f
C5759 VDD.t172 VSS 0.00687f
C5760 VDD.n1168 VSS 0.0171f
C5761 VDD.n1169 VSS 0.0116f
C5762 VDD.t655 VSS 0.00687f
C5763 VDD.t658 VSS 0.00687f
C5764 VDD.n1170 VSS 0.0172f
C5765 VDD.n1171 VSS 0.00879f
C5766 VDD.t660 VSS 0.00687f
C5767 VDD.n1172 VSS 0.01656f
C5768 VDD.t659 VSS 0.00687f
C5769 VDD.t657 VSS 0.00687f
C5770 VDD.n1173 VSS 0.0172f
C5771 VDD.n1174 VSS 0.00879f
C5772 VDD.t656 VSS 0.00687f
C5773 VDD.n1175 VSS 0.01656f
C5774 VDD.t73 VSS 0.00687f
C5775 VDD.t74 VSS 0.00687f
C5776 VDD.n1176 VSS 0.0172f
C5777 VDD.n1177 VSS 0.00879f
C5778 VDD.t72 VSS 0.00687f
C5779 VDD.n1178 VSS 0.01656f
C5780 VDD.t1073 VSS 0.00687f
C5781 VDD.t833 VSS 0.00687f
C5782 VDD.n1179 VSS 0.0171f
C5783 VDD.n1180 VSS 0.00879f
C5784 VDD.t1078 VSS 0.00687f
C5785 VDD.n1181 VSS 0.0172f
C5786 VDD.t1075 VSS 0.00687f
C5787 VDD.n1183 VSS 0.00879f
C5788 VDD.t1077 VSS 0.00687f
C5789 VDD.n1184 VSS 0.0172f
C5790 VDD.n1186 VSS 0.01338f
C5791 VDD.t860 VSS 0.00687f
C5792 VDD.n1187 VSS 0.00879f
C5793 VDD.t862 VSS 0.00687f
C5794 VDD.n1188 VSS 0.0172f
C5795 VDD.t316 VSS 0.00687f
C5796 VDD.t318 VSS 0.00687f
C5797 VDD.n1191 VSS 0.00879f
C5798 VDD.t319 VSS 0.00687f
C5799 VDD.n1192 VSS 0.0172f
C5800 VDD.t321 VSS 0.00687f
C5801 VDD.n1194 VSS 0.00879f
C5802 VDD.t313 VSS 0.00687f
C5803 VDD.n1196 VSS 0.00879f
C5804 VDD.n1197 VSS 0.0116f
C5805 VDD.t151 VSS 0.00687f
C5806 VDD.t462 VSS 0.00687f
C5807 VDD.n1198 VSS 0.0171f
C5808 VDD.n1199 VSS 0.0172f
C5809 VDD.t153 VSS 0.00687f
C5810 VDD.n1201 VSS 0.00879f
C5811 VDD.t152 VSS 0.00687f
C5812 VDD.n1202 VSS 0.01199f
C5813 VDD.t154 VSS 0.00687f
C5814 VDD.n1203 VSS 0.00879f
C5815 VDD.t166 VSS 0.00687f
C5816 VDD.n1205 VSS 0.00879f
C5817 VDD.t76 VSS 0.00687f
C5818 VDD.n1206 VSS 0.01564f
C5819 VDD.t77 VSS 0.00687f
C5820 VDD.n1207 VSS 0.00879f
C5821 VDD.t486 VSS 0.00687f
C5822 VDD.n1209 VSS 0.00879f
C5823 VDD.t482 VSS 0.00687f
C5824 VDD.n1211 VSS 0.00879f
C5825 VDD.t459 VSS 0.00687f
C5826 VDD.n1213 VSS 0.00879f
C5827 VDD.t147 VSS 0.00687f
C5828 VDD.n1214 VSS 0.0171f
C5829 VDD.n1215 VSS 0.0116f
C5830 VDD.t527 VSS 0.00687f
C5831 VDD.n1216 VSS 0.00879f
C5832 VDD.t526 VSS 0.00687f
C5833 VDD.n1217 VSS 0.01564f
C5834 VDD.t461 VSS 0.00687f
C5835 VDD.t458 VSS 0.00687f
C5836 VDD.n1218 VSS 0.0172f
C5837 VDD.n1219 VSS 0.00879f
C5838 VDD.t460 VSS 0.00687f
C5839 VDD.n1220 VSS 0.0172f
C5840 VDD.t485 VSS 0.00687f
C5841 VDD.t488 VSS 0.00687f
C5842 VDD.n1222 VSS 0.0172f
C5843 VDD.n1223 VSS 0.00879f
C5844 VDD.t483 VSS 0.00687f
C5845 VDD.n1224 VSS 0.01199f
C5846 VDD.t484 VSS 0.00687f
C5847 VDD.t487 VSS 0.00687f
C5848 VDD.n1225 VSS 0.0172f
C5849 VDD.n1226 VSS 0.00879f
C5850 VDD.t546 VSS 0.00687f
C5851 VDD.t481 VSS 0.00687f
C5852 VDD.n1228 VSS 0.0172f
C5853 VDD.n1229 VSS 0.0171f
C5854 VDD.n1230 VSS 0.0116f
C5855 VDD.t168 VSS 0.00687f
C5856 VDD.n1231 VSS 0.00879f
C5857 VDD.t167 VSS 0.00687f
C5858 VDD.n1232 VSS 0.0172f
C5859 VDD.t150 VSS 0.00687f
C5860 VDD.t169 VSS 0.00687f
C5861 VDD.n1234 VSS 0.0172f
C5862 VDD.n1235 VSS 0.00879f
C5863 VDD.t149 VSS 0.00687f
C5864 VDD.n1236 VSS 0.0172f
C5865 VDD.n1238 VSS 0.01338f
C5866 VDD.n1239 VSS 0.17617f
C5867 VDD.n1240 VSS 0.00825f
C5868 VDD.t541 VSS 0.00774f
C5869 VDD.t1387 VSS 0.00751f
C5870 VDD.n1241 VSS 0.01375f
C5871 VDD.t1390 VSS 0.00751f
C5872 VDD.n1242 VSS 0.00525f
C5873 VDD.t537 VSS 0.00774f
C5874 VDD.t1394 VSS 0.00751f
C5875 VDD.n1243 VSS 0.01375f
C5876 VDD.t1397 VSS 0.00751f
C5877 VDD.n1244 VSS 0.00525f
C5878 VDD.n1245 VSS 0.0303f
C5879 VDD.n1246 VSS 0.01764f
C5880 VDD.t302 VSS 0.00703f
C5881 VDD.t1410 VSS 0.0068f
C5882 VDD.n1247 VSS 0.01375f
C5883 VDD.t1395 VSS 0.0068f
C5884 VDD.n1248 VSS 0.00988f
C5885 VDD.n1249 VSS 0.03184f
C5886 VDD.t303 VSS 0.00774f
C5887 VDD.t1388 VSS 0.00751f
C5888 VDD.n1250 VSS 0.01375f
C5889 VDD.t1398 VSS 0.00751f
C5890 VDD.n1251 VSS 0.00525f
C5891 VDD.n1252 VSS 0.01924f
C5892 VDD.n1253 VSS 0.26628f
C5893 VDD.n1254 VSS 0.0217f
C5894 VDD.n1255 VSS 0.01338f
C5895 VDD.n1256 VSS 0.31831f
C5896 VDD.n1257 VSS 0.23304f
C5897 VDD.n1258 VSS 0.02345f
C5898 VDD.n1259 VSS 0.02586f
C5899 VDD.n1260 VSS 0.00695f
C5900 VDD.t306 VSS 0.00774f
C5901 VDD.t1383 VSS 0.00751f
C5902 VDD.n1261 VSS 0.01375f
C5903 VDD.t1392 VSS 0.00751f
C5904 VDD.n1262 VSS 0.00525f
C5905 VDD.n1263 VSS 0.03727f
C5906 VDD.t305 VSS 0.00774f
C5907 VDD.t1401 VSS 0.00751f
C5908 VDD.n1264 VSS 0.01375f
C5909 VDD.t1385 VSS 0.00751f
C5910 VDD.n1265 VSS 0.00525f
C5911 VDD.n1266 VSS 0.02333f
C5912 VDD.n1267 VSS 0.01387f
C5913 VDD.t307 VSS 0.00774f
C5914 VDD.t1384 VSS 0.00751f
C5915 VDD.n1268 VSS 0.01375f
C5916 VDD.t1391 VSS 0.00751f
C5917 VDD.n1269 VSS 0.00525f
C5918 VDD.n1270 VSS 0.01663f
C5919 VDD.n1271 VSS 0.02628f
C5920 VDD.n1272 VSS 0.01653f
C5921 VDD.n1273 VSS 0.01338f
C5922 VDD.n1274 VSS 0.31544f
C5923 VDD.n1275 VSS 0.00825f
C5924 VDD.t474 VSS 0.00774f
C5925 VDD.t1358 VSS 0.00751f
C5926 VDD.n1276 VSS 0.01375f
C5927 VDD.t1346 VSS 0.00751f
C5928 VDD.n1277 VSS 0.00525f
C5929 VDD.t472 VSS 0.00774f
C5930 VDD.t1351 VSS 0.00751f
C5931 VDD.n1278 VSS 0.01375f
C5932 VDD.t1362 VSS 0.00751f
C5933 VDD.n1279 VSS 0.00525f
C5934 VDD.n1280 VSS 0.0303f
C5935 VDD.n1281 VSS 0.01764f
C5936 VDD.t654 VSS 0.00703f
C5937 VDD.t1360 VSS 0.0068f
C5938 VDD.n1282 VSS 0.01375f
C5939 VDD.t1347 VSS 0.0068f
C5940 VDD.n1283 VSS 0.00988f
C5941 VDD.n1284 VSS 0.03184f
C5942 VDD.t645 VSS 0.00774f
C5943 VDD.t1353 VSS 0.00751f
C5944 VDD.n1285 VSS 0.01375f
C5945 VDD.t1354 VSS 0.00751f
C5946 VDD.n1286 VSS 0.00525f
C5947 VDD.n1287 VSS 0.01924f
C5948 VDD.n1288 VSS 0.26628f
C5949 VDD.n1289 VSS 0.01854f
C5950 VDD.n1290 VSS 0.01338f
C5951 VDD.n1291 VSS 0.31544f
C5952 VDD.n1292 VSS 0.23304f
C5953 VDD.n1293 VSS 0.02345f
C5954 VDD.n1294 VSS 0.02586f
C5955 VDD.n1295 VSS 0.00695f
C5956 VDD.t648 VSS 0.00774f
C5957 VDD.t1349 VSS 0.00751f
C5958 VDD.n1296 VSS 0.01375f
C5959 VDD.t1364 VSS 0.00751f
C5960 VDD.n1297 VSS 0.00525f
C5961 VDD.n1298 VSS 0.03727f
C5962 VDD.t646 VSS 0.00774f
C5963 VDD.t1352 VSS 0.00751f
C5964 VDD.n1299 VSS 0.01375f
C5965 VDD.t1355 VSS 0.00751f
C5966 VDD.n1300 VSS 0.00525f
C5967 VDD.n1301 VSS 0.02333f
C5968 VDD.n1302 VSS 0.01387f
C5969 VDD.t647 VSS 0.00774f
C5970 VDD.t1359 VSS 0.00751f
C5971 VDD.n1303 VSS 0.01375f
C5972 VDD.t1344 VSS 0.00751f
C5973 VDD.n1304 VSS 0.00525f
C5974 VDD.n1305 VSS 0.01481f
C5975 VDD.n1306 VSS 0.23552f
C5976 VDD.n1307 VSS 0.01338f
C5977 VDD.n1308 VSS 0.17617f
C5978 VDD.n1309 VSS 0.01653f
C5979 VDD.n1310 VSS 0.01338f
C5980 VDD.n1311 VSS 0.31544f
C5981 VDD.n1312 VSS 0.23304f
C5982 VDD.n1313 VSS 0.01539f
C5983 VDD.n1314 VSS 0.02303f
C5984 VDD.n1315 VSS 0.00695f
C5985 VDD.t475 VSS 0.00774f
C5986 VDD.t1357 VSS 0.00751f
C5987 VDD.n1316 VSS 0.01375f
C5988 VDD.t1345 VSS 0.00751f
C5989 VDD.n1317 VSS 0.00525f
C5990 VDD.n1318 VSS 0.03727f
C5991 VDD.n1319 VSS 0.01387f
C5992 VDD.t471 VSS 0.00774f
C5993 VDD.t1365 VSS 0.00751f
C5994 VDD.n1320 VSS 0.01375f
C5995 VDD.t1348 VSS 0.00751f
C5996 VDD.n1321 VSS 0.00525f
C5997 VDD.n1322 VSS 0.0303f
C5998 VDD.n1323 VSS 0.01387f
C5999 VDD.t477 VSS 0.00774f
C6000 VDD.t1356 VSS 0.00751f
C6001 VDD.n1324 VSS 0.01375f
C6002 VDD.t1343 VSS 0.00751f
C6003 VDD.n1325 VSS 0.00525f
C6004 VDD.n1326 VSS 0.0303f
C6005 VDD.t473 VSS 0.00703f
C6006 VDD.t1379 VSS 0.0068f
C6007 VDD.n1327 VSS 0.01375f
C6008 VDD.t1366 VSS 0.0068f
C6009 VDD.n1328 VSS 0.00988f
C6010 VDD.n1329 VSS 0.03896f
C6011 VDD.t470 VSS 2.39783f
C6012 VDD.n1330 VSS 0.24047f
C6013 VDD.n1331 VSS 0.01387f
C6014 VDD.n1332 VSS 0.01775f
C6015 VDD.n1333 VSS 0.02314f
C6016 VDD.n1334 VSS 0.23304f
C6017 VDD.n1335 VSS 0.01338f
C6018 VDD.n1336 VSS 0.17617f
C6019 VDD.n1337 VSS 0.01481f
C6020 VDD.n1338 VSS 0.37763f
C6021 VDD.n1339 VSS 0.07793f
C6022 VDD.n1342 VSS 0.04202f
C6023 VDD.n1344 VSS 0.04565f
C6024 VDD.n1345 VSS 0.01471f
C6025 VDD.n1346 VSS 0.03759f
C6026 VDD.n1348 VSS 0.17466f
C6027 VDD.n1349 VSS 0.13383f
C6028 VDD.n1353 VSS 0.02482f
C6029 VDD.n1355 VSS 0.01481f
C6030 VDD.n1356 VSS 0.37763f
C6031 VDD.n1357 VSS 0.06568f
C6032 VDD.n1358 VSS 0.13383f
C6033 VDD.n1359 VSS 0.17466f
C6034 VDD.n1360 VSS 0.04202f
C6035 VDD.n1361 VSS 0.05892f
C6036 VDD.n1362 VSS 0.32179f
C6037 VDD.n1363 VSS 0.01481f
C6038 VDD.n1364 VSS 0.23552f
C6039 VDD.n1365 VSS 0.01338f
C6040 VDD.n1366 VSS 0.17617f
C6041 VDD.n1367 VSS 0.01969f
C6042 VDD.n1368 VSS 0.01338f
C6043 VDD.n1369 VSS 0.31831f
C6044 VDD.n1370 VSS 0.23304f
C6045 VDD.n1371 VSS 0.01539f
C6046 VDD.n1372 VSS 0.02303f
C6047 VDD.n1373 VSS 0.00695f
C6048 VDD.t304 VSS 0.00774f
C6049 VDD.t1386 VSS 0.00751f
C6050 VDD.n1374 VSS 0.01375f
C6051 VDD.t1400 VSS 0.00751f
C6052 VDD.n1375 VSS 0.00525f
C6053 VDD.n1376 VSS 0.03727f
C6054 VDD.n1377 VSS 0.01387f
C6055 VDD.t536 VSS 0.00774f
C6056 VDD.t1393 VSS 0.00751f
C6057 VDD.n1378 VSS 0.01375f
C6058 VDD.t1396 VSS 0.00751f
C6059 VDD.n1379 VSS 0.00525f
C6060 VDD.n1380 VSS 0.0303f
C6061 VDD.n1381 VSS 0.01387f
C6062 VDD.t538 VSS 0.00774f
C6063 VDD.t1417 VSS 0.00751f
C6064 VDD.n1382 VSS 0.01375f
C6065 VDD.t1399 VSS 0.00751f
C6066 VDD.n1383 VSS 0.00525f
C6067 VDD.n1384 VSS 0.0303f
C6068 VDD.t544 VSS 0.00703f
C6069 VDD.t1403 VSS 0.0068f
C6070 VDD.n1385 VSS 0.01375f
C6071 VDD.t1389 VSS 0.0068f
C6072 VDD.n1386 VSS 0.00988f
C6073 VDD.n1387 VSS 0.03896f
C6074 VDD.t301 VSS 2.39783f
C6075 VDD.n1388 VSS 0.24047f
C6076 VDD.n1389 VSS 0.01387f
C6077 VDD.n1390 VSS 0.01775f
C6078 VDD.n1391 VSS 0.02314f
C6079 VDD.n1392 VSS 0.23304f
C6080 VDD.n1393 VSS 0.01338f
C6081 VDD.n1394 VSS 0.31831f
C6082 VDD.n1395 VSS 0.01969f
C6083 VDD.t155 VSS 0.00687f
C6084 VDD.n1396 VSS 0.00879f
C6085 VDD.t148 VSS 0.00687f
C6086 VDD.n1397 VSS 0.0172f
C6087 VDD.t468 VSS 0.00687f
C6088 VDD.n1399 VSS 0.00879f
C6089 VDD.t469 VSS 0.00687f
C6090 VDD.n1400 VSS 0.01564f
C6091 VDD.t315 VSS 0.00687f
C6092 VDD.t312 VSS 0.00687f
C6093 VDD.n1401 VSS 0.0172f
C6094 VDD.n1402 VSS 0.00879f
C6095 VDD.n1403 VSS 0.01969f
C6096 VDD.t314 VSS 0.00687f
C6097 VDD.n1404 VSS 0.0172f
C6098 VDD.t323 VSS 0.00687f
C6099 VDD.n1406 VSS 0.01199f
C6100 VDD.t322 VSS 0.00687f
C6101 VDD.t317 VSS 0.00687f
C6102 VDD.n1407 VSS 0.0172f
C6103 VDD.n1408 VSS 0.00879f
C6104 VDD.t320 VSS 0.00687f
C6105 VDD.n1409 VSS 0.0172f
C6106 VDD.t75 VSS 4.40928f
C6107 VDD.n1411 VSS 0.89627f
C6108 VDD.n1412 VSS 0.00879f
C6109 VDD.n1413 VSS 0.01969f
C6110 VDD.n1414 VSS 0.31831f
C6111 VDD.n1415 VSS 0.01338f
C6112 VDD.t35 VSS 0.00687f
C6113 VDD.n1416 VSS 0.00879f
C6114 VDD.t36 VSS 0.00687f
C6115 VDD.n1418 VSS 0.0172f
C6116 VDD.t858 VSS 0.00687f
C6117 VDD.n1419 VSS 0.0171f
C6118 VDD.n1420 VSS 0.0116f
C6119 VDD.t34 VSS 4.40928f
C6120 VDD.n1421 VSS 0.89627f
C6121 VDD.n1422 VSS 0.00879f
C6122 VDD.n1423 VSS 0.01338f
C6123 VDD.n1424 VSS 0.31831f
C6124 VDD.n1425 VSS 0.23304f
C6125 VDD.n1426 VSS 0.02345f
C6126 VDD.n1427 VSS 0.02586f
C6127 VDD.n1428 VSS 0.00695f
C6128 VDD.t517 VSS 0.00774f
C6129 VDD.t1328 VSS 0.00751f
C6130 VDD.n1429 VSS 0.01375f
C6131 VDD.t1313 VSS 0.00751f
C6132 VDD.n1430 VSS 0.00525f
C6133 VDD.n1431 VSS 0.03727f
C6134 VDD.n1432 VSS 0.01387f
C6135 VDD.n1433 VSS 0.00695f
C6136 VDD.t504 VSS 0.00774f
C6137 VDD.t1312 VSS 0.00751f
C6138 VDD.n1434 VSS 0.01375f
C6139 VDD.t1317 VSS 0.00751f
C6140 VDD.n1435 VSS 0.00525f
C6141 VDD.n1436 VSS 0.03727f
C6142 VDD.n1437 VSS 0.01387f
C6143 VDD.t508 VSS 0.00774f
C6144 VDD.t1315 VSS 0.00751f
C6145 VDD.n1438 VSS 0.01375f
C6146 VDD.t1310 VSS 0.00751f
C6147 VDD.n1439 VSS 0.00525f
C6148 VDD.n1440 VSS 0.0303f
C6149 VDD.n1441 VSS 0.01387f
C6150 VDD.t507 VSS 0.00774f
C6151 VDD.t1309 VSS 0.00751f
C6152 VDD.n1442 VSS 0.01375f
C6153 VDD.t1305 VSS 0.00751f
C6154 VDD.n1443 VSS 0.00525f
C6155 VDD.n1444 VSS 0.01775f
C6156 VDD.n1445 VSS 0.02314f
C6157 VDD.n1446 VSS 0.00825f
C6158 VDD.t505 VSS 0.00774f
C6159 VDD.t1303 VSS 0.00751f
C6160 VDD.n1447 VSS 0.01375f
C6161 VDD.t1311 VSS 0.00751f
C6162 VDD.n1448 VSS 0.00525f
C6163 VDD.n1449 VSS 0.0303f
C6164 VDD.n1450 VSS 0.01387f
C6165 VDD.t506 VSS 0.00774f
C6166 VDD.t1308 VSS 0.00751f
C6167 VDD.n1451 VSS 0.01375f
C6168 VDD.t1333 VSS 0.00751f
C6169 VDD.n1452 VSS 0.00525f
C6170 VDD.n1453 VSS 0.0303f
C6171 VDD.t513 VSS 0.00703f
C6172 VDD.t1330 VSS 0.0068f
C6173 VDD.n1454 VSS 0.01375f
C6174 VDD.t1316 VSS 0.0068f
C6175 VDD.n1455 VSS 0.00988f
C6176 VDD.n1456 VSS 0.03896f
C6177 VDD.t503 VSS 2.39783f
C6178 VDD.n1457 VSS 0.24047f
C6179 VDD.n1458 VSS 0.01764f
C6180 VDD.n1459 VSS 0.01539f
C6181 VDD.n1460 VSS 0.23304f
C6182 VDD.n1461 VSS 0.17617f
C6183 VDD.n1462 VSS 0.01338f
C6184 VDD.t298 VSS 0.00687f
C6185 VDD.n1463 VSS 0.0172f
C6186 VDD.t499 VSS 0.00687f
C6187 VDD.n1465 VSS 0.01199f
C6188 VDD.t495 VSS 0.00687f
C6189 VDD.t500 VSS 0.00687f
C6190 VDD.n1466 VSS 0.0172f
C6191 VDD.n1467 VSS 0.00879f
C6192 VDD.t498 VSS 0.00687f
C6193 VDD.n1468 VSS 0.0172f
C6194 VDD.t0 VSS 4.40928f
C6195 VDD.n1470 VSS 0.89627f
C6196 VDD.n1471 VSS 0.00879f
C6197 VDD.n1472 VSS 0.01338f
C6198 VDD.n1473 VSS 0.17617f
C6199 VDD.n1474 VSS 0.38031f
C6200 VDD.n1475 VSS 0.01481f
C6201 VDD.t672 VSS 0.00687f
C6202 VDD.n1476 VSS 0.00879f
C6203 VDD.t671 VSS 0.00687f
C6204 VDD.n1478 VSS 0.0172f
C6205 VDD.t1148 VSS 0.00687f
C6206 VDD.n1479 VSS 0.0171f
C6207 VDD.n1480 VSS 0.0116f
C6208 VDD.t87 VSS 1.11499f
C6209 VDD.n1481 VSS 0.89627f
C6210 VDD.t85 VSS 1.0106f
C6211 VDD.n1483 VSS 0.17651f
C6212 VDD.n1484 VSS 0.04202f
C6213 VDD.n1485 VSS 0.04565f
C6214 VDD.n1486 VSS 0.32179f
C6215 VDD.n1487 VSS 0.01663f
C6216 VDD.t1137 VSS 0.00687f
C6217 VDD.t1145 VSS 0.00687f
C6218 VDD.n1489 VSS 0.0172f
C6219 VDD.n1490 VSS 0.00879f
C6220 VDD.t1136 VSS 0.00687f
C6221 VDD.n1491 VSS 0.0172f
C6222 VDD.t1135 VSS 0.40722f
C6223 VDD.n1493 VSS 0.07393f
C6224 VDD.n1494 VSS 0.00879f
C6225 VDD.n1495 VSS 0.0172f
C6226 VDD.t917 VSS 0.40722f
C6227 VDD.n1497 VSS 0.07393f
C6228 VDD.n1498 VSS 0.00879f
C6229 VDD.n1499 VSS 0.0172f
C6230 VDD.t824 VSS 0.40722f
C6231 VDD.n1501 VSS 0.07393f
C6232 VDD.n1502 VSS 0.00879f
C6233 VDD.n1503 VSS 0.01226f
C6234 VDD.n1504 VSS 0.30454f
C6235 VDD.n1505 VSS 0.39315f
C6236 VDD.n1506 VSS 0.02323f
C6237 VDD.t111 VSS 0.00687f
C6238 VDD.t103 VSS 0.00687f
C6239 VDD.n1507 VSS 0.03207f
C6240 VDD.n1508 VSS 0.02515f
C6241 VDD.n1509 VSS 0.00779f
C6242 VDD.t100 VSS 0.00759f
C6243 VDD.n1510 VSS 0.03413f
C6244 VDD.n1511 VSS 0.01883f
C6245 VDD.n1512 VSS 0.0116f
C6246 VDD.t104 VSS 0.00759f
C6247 VDD.n1513 VSS 0.02195f
C6248 VDD.t1022 VSS 0.00759f
C6249 VDD.n1514 VSS 0.02195f
C6250 VDD.n1515 VSS 0.11599f
C6251 VDD.n1516 VSS 0.11599f
C6252 VDD.t101 VSS 0.00687f
C6253 VDD.t1204 VSS 0.00687f
C6254 VDD.n1517 VSS 0.03207f
C6255 VDD.n1518 VSS 0.02515f
C6256 VDD.n1519 VSS 0.00779f
C6257 VDD.t1205 VSS 0.00759f
C6258 VDD.n1520 VSS 0.03413f
C6259 VDD.n1521 VSS 0.01883f
C6260 VDD.n1522 VSS 0.0116f
C6261 VDD.t1220 VSS 0.00759f
C6262 VDD.n1523 VSS 0.02195f
C6263 VDD.t1207 VSS 0.00759f
C6264 VDD.n1524 VSS 0.02195f
C6265 VDD.n1525 VSS 0.11789f
C6266 VDD.n1526 VSS 0.11789f
C6267 VDD.t1219 VSS 0.00687f
C6268 VDD.t1217 VSS 0.00687f
C6269 VDD.n1527 VSS 0.03207f
C6270 VDD.n1528 VSS 0.02515f
C6271 VDD.n1529 VSS 0.00779f
C6272 VDD.t1216 VSS 0.00759f
C6273 VDD.n1530 VSS 0.03413f
C6274 VDD.n1531 VSS 0.01883f
C6275 VDD.n1532 VSS 0.0116f
C6276 VDD.t1199 VSS 0.00759f
C6277 VDD.n1533 VSS 0.02195f
C6278 VDD.t1210 VSS 0.00759f
C6279 VDD.n1534 VSS 0.02195f
C6280 VDD.n1535 VSS 0.11789f
C6281 VDD.n1536 VSS 0.11789f
C6282 VDD.t1198 VSS 0.00687f
C6283 VDD.t1227 VSS 0.00687f
C6284 VDD.n1537 VSS 0.03207f
C6285 VDD.n1538 VSS 0.02515f
C6286 VDD.n1539 VSS 0.00779f
C6287 VDD.t1225 VSS 0.00759f
C6288 VDD.n1540 VSS 0.03413f
C6289 VDD.n1541 VSS 0.01883f
C6290 VDD.n1542 VSS 0.0116f
C6291 VDD.t1234 VSS 0.00759f
C6292 VDD.n1543 VSS 0.02195f
C6293 VDD.t1244 VSS 0.00759f
C6294 VDD.n1544 VSS 0.02195f
C6295 VDD.n1545 VSS 0.11789f
C6296 VDD.n1546 VSS 0.11789f
C6297 VDD.t1235 VSS 0.00687f
C6298 VDD.t1203 VSS 0.00687f
C6299 VDD.n1547 VSS 0.03207f
C6300 VDD.n1548 VSS 0.02515f
C6301 VDD.n1549 VSS 0.00779f
C6302 VDD.t1201 VSS 0.00759f
C6303 VDD.n1550 VSS 0.03413f
C6304 VDD.n1551 VSS 0.01883f
C6305 VDD.n1552 VSS 0.0116f
C6306 VDD.t1222 VSS 0.00759f
C6307 VDD.n1553 VSS 0.02195f
C6308 VDD.t1238 VSS 0.00759f
C6309 VDD.n1554 VSS 0.02195f
C6310 VDD.n1555 VSS 0.11789f
C6311 VDD.n1556 VSS 0.11789f
C6312 VDD.t1224 VSS 0.00687f
C6313 VDD.t894 VSS 0.00687f
C6314 VDD.n1557 VSS 0.03207f
C6315 VDD.n1558 VSS 0.02515f
C6316 VDD.n1559 VSS 0.00779f
C6317 VDD.t893 VSS 0.00759f
C6318 VDD.n1560 VSS 0.03413f
C6319 VDD.n1561 VSS 0.01883f
C6320 VDD.n1562 VSS 0.0116f
C6321 VDD.t881 VSS 0.00759f
C6322 VDD.n1563 VSS 0.02195f
C6323 VDD.t908 VSS 0.00759f
C6324 VDD.n1564 VSS 0.02195f
C6325 VDD.n1565 VSS 0.11789f
C6326 VDD.n1566 VSS 0.11789f
C6327 VDD.t883 VSS 0.00687f
C6328 VDD.t884 VSS 0.00687f
C6329 VDD.n1567 VSS 0.03207f
C6330 VDD.n1568 VSS 0.02515f
C6331 VDD.n1569 VSS 0.00779f
C6332 VDD.t885 VSS 0.00759f
C6333 VDD.n1570 VSS 0.03413f
C6334 VDD.n1571 VSS 0.01883f
C6335 VDD.n1572 VSS 0.0116f
C6336 VDD.t899 VSS 0.00759f
C6337 VDD.n1573 VSS 0.02195f
C6338 VDD.t902 VSS 0.00759f
C6339 VDD.n1574 VSS 0.02195f
C6340 VDD.n1575 VSS 0.11789f
C6341 VDD.n1576 VSS 0.11789f
C6342 VDD.t900 VSS 0.00687f
C6343 VDD.t871 VSS 0.00687f
C6344 VDD.n1577 VSS 0.03207f
C6345 VDD.n1578 VSS 0.02515f
C6346 VDD.n1579 VSS 0.00779f
C6347 VDD.t869 VSS 0.00759f
C6348 VDD.n1580 VSS 0.03413f
C6349 VDD.n1581 VSS 0.01883f
C6350 VDD.n1582 VSS 0.0116f
C6351 VDD.t891 VSS 0.00759f
C6352 VDD.n1583 VSS 0.02195f
C6353 VDD.t866 VSS 0.00759f
C6354 VDD.n1584 VSS 0.02195f
C6355 VDD.n1585 VSS 0.11789f
C6356 VDD.n1586 VSS 0.11789f
C6357 VDD.t890 VSS 0.00687f
C6358 VDD.t898 VSS 0.00687f
C6359 VDD.n1587 VSS 0.03207f
C6360 VDD.n1588 VSS 0.02515f
C6361 VDD.n1589 VSS 0.00779f
C6362 VDD.t896 VSS 0.00759f
C6363 VDD.n1590 VSS 0.03413f
C6364 VDD.n1591 VSS 0.01883f
C6365 VDD.n1592 VSS 0.0116f
C6366 VDD.t875 VSS 0.00759f
C6367 VDD.n1593 VSS 0.02195f
C6368 VDD.t888 VSS 0.00759f
C6369 VDD.n1594 VSS 0.02195f
C6370 VDD.n1595 VSS 0.11789f
C6371 VDD.n1596 VSS 0.11789f
C6372 VDD.t877 VSS 0.00687f
C6373 VDD.t767 VSS 0.00687f
C6374 VDD.n1597 VSS 0.03207f
C6375 VDD.n1598 VSS 0.02515f
C6376 VDD.n1599 VSS 0.00779f
C6377 VDD.t702 VSS 0.00759f
C6378 VDD.n1600 VSS 0.03413f
C6379 VDD.n1601 VSS 0.01883f
C6380 VDD.n1602 VSS 0.0116f
C6381 VDD.t735 VSS 0.00687f
C6382 VDD.t681 VSS 0.00687f
C6383 VDD.n1603 VSS 0.03207f
C6384 VDD.n1604 VSS 0.02515f
C6385 VDD.n1605 VSS 0.00779f
C6386 VDD.t713 VSS 0.00759f
C6387 VDD.n1606 VSS 0.03413f
C6388 VDD.n1607 VSS 0.01883f
C6389 VDD.n1608 VSS 0.0116f
C6390 VDD.t737 VSS 0.00759f
C6391 VDD.n1609 VSS 0.02195f
C6392 VDD.n1610 VSS 0.02418f
C6393 VDD.t764 VSS 0.00687f
C6394 VDD.t689 VSS 0.00687f
C6395 VDD.n1611 VSS 0.03207f
C6396 VDD.n1612 VSS 0.02515f
C6397 VDD.n1613 VSS 0.00779f
C6398 VDD.t745 VSS 0.00759f
C6399 VDD.n1614 VSS 0.03413f
C6400 VDD.n1615 VSS 0.01883f
C6401 VDD.t676 VSS 0.00759f
C6402 VDD.n1616 VSS 0.03413f
C6403 VDD.n1617 VSS 0.01883f
C6404 VDD.n1618 VSS 0.0116f
C6405 VDD.t701 VSS 0.00759f
C6406 VDD.n1619 VSS 0.02195f
C6407 VDD.n1620 VSS 0.02855f
C6408 VDD.t733 VSS 0.00699f
C6409 VDD.n1621 VSS 0.04124f
C6410 VDD.t721 VSS 0.00759f
C6411 VDD.n1622 VSS 0.00695f
C6412 VDD.n1623 VSS 0.00695f
C6413 VDD.n1624 VSS 0.00695f
C6414 VDD.t688 VSS 0.00687f
C6415 VDD.n1625 VSS 0.03207f
C6416 VDD.n1626 VSS 0.00695f
C6417 VDD.t674 VSS 0.00759f
C6418 VDD.n1627 VSS 0.03413f
C6419 VDD.n1628 VSS 0.01883f
C6420 VDD.n1629 VSS 0.0116f
C6421 VDD.t750 VSS 0.00687f
C6422 VDD.t698 VSS 0.00687f
C6423 VDD.n1630 VSS 0.03207f
C6424 VDD.n1631 VSS 0.02515f
C6425 VDD.n1632 VSS 0.00779f
C6426 VDD.t683 VSS 0.00759f
C6427 VDD.n1633 VSS 0.03413f
C6428 VDD.n1634 VSS 0.01883f
C6429 VDD.n1635 VSS 0.0116f
C6430 VDD.t753 VSS 0.00759f
C6431 VDD.n1636 VSS 0.02195f
C6432 VDD.n1637 VSS 0.00779f
C6433 VDD.t678 VSS 0.00759f
C6434 VDD.n1638 VSS 0.00695f
C6435 VDD.t732 VSS 0.00687f
C6436 VDD.t711 VSS 0.00687f
C6437 VDD.n1639 VSS 0.02515f
C6438 VDD.n1640 VSS 0.03207f
C6439 VDD.n1641 VSS 0.00695f
C6440 VDD.n1642 VSS 0.00695f
C6441 VDD.t714 VSS 0.00687f
C6442 VDD.n1643 VSS 0.03207f
C6443 VDD.n1644 VSS 0.00695f
C6444 VDD.t699 VSS 0.00759f
C6445 VDD.n1645 VSS 0.03413f
C6446 VDD.n1646 VSS 0.01883f
C6447 VDD.n1647 VSS 0.0116f
C6448 VDD.t685 VSS 0.00759f
C6449 VDD.n1648 VSS 0.02195f
C6450 VDD.t411 VSS 0.00687f
C6451 VDD.t353 VSS 0.00687f
C6452 VDD.t384 VSS 0.00759f
C6453 VDD.t364 VSS 0.00759f
C6454 VDD.t363 VSS 0.00687f
C6455 VDD.t428 VSS 0.00687f
C6456 VDD.t349 VSS 0.00759f
C6457 VDD.n1649 VSS 0.0116f
C6458 VDD.n1650 VSS 0.01883f
C6459 VDD.n1651 VSS 0.03408f
C6460 VDD.n1652 VSS 0.00695f
C6461 VDD.n1653 VSS 0.03212f
C6462 VDD.n1654 VSS 0.02515f
C6463 VDD.n1655 VSS 0.00779f
C6464 VDD.n1656 VSS 0.02855f
C6465 VDD.n1657 VSS 0.02195f
C6466 VDD.n1658 VSS 0.0116f
C6467 VDD.n1659 VSS 0.0116f
C6468 VDD.n1660 VSS 0.03413f
C6469 VDD.n1661 VSS 0.01387f
C6470 VDD.n1662 VSS 0.02515f
C6471 VDD.n1663 VSS 0.02515f
C6472 VDD.n1664 VSS 0.00779f
C6473 VDD.t380 VSS 0.00759f
C6474 VDD.t351 VSS 0.00759f
C6475 VDD.t372 VSS 0.00687f
C6476 VDD.t936 VSS 0.00687f
C6477 VDD.t935 VSS 0.00759f
C6478 VDD.t953 VSS 0.00759f
C6479 VDD.t955 VSS 0.00687f
C6480 VDD.t950 VSS 0.00687f
C6481 VDD.t951 VSS 0.00759f
C6482 VDD.t926 VSS 0.00759f
C6483 VDD.t928 VSS 0.00687f
C6484 VDD.t956 VSS 0.00687f
C6485 VDD.t957 VSS 0.00759f
C6486 VDD.t921 VSS 0.00759f
C6487 VDD.t920 VSS 0.00687f
C6488 VDD.t940 VSS 0.00687f
C6489 VDD.t938 VSS 0.00759f
C6490 VDD.t965 VSS 0.00759f
C6491 VDD.t966 VSS 0.00687f
C6492 VDD.t1091 VSS 0.00687f
C6493 VDD.t1089 VSS 0.00759f
C6494 VDD.t1101 VSS 0.00759f
C6495 VDD.t1103 VSS 0.00687f
C6496 VDD.t1122 VSS 0.00687f
C6497 VDD.t1123 VSS 0.00759f
C6498 VDD.t1087 VSS 0.00759f
C6499 VDD.t1086 VSS 0.00687f
C6500 VDD.t1097 VSS 0.00687f
C6501 VDD.t1095 VSS 0.00759f
C6502 VDD.t1116 VSS 0.00759f
C6503 VDD.t1118 VSS 0.00687f
C6504 VDD.t1110 VSS 0.00687f
C6505 VDD.t1111 VSS 0.00759f
C6506 VDD.t1083 VSS 0.00759f
C6507 VDD.t1084 VSS 0.00687f
C6508 VDD.t853 VSS 0.00687f
C6509 VDD.t852 VSS 0.00759f
C6510 VDD.t835 VSS 0.00759f
C6511 VDD.t834 VSS 0.00687f
C6512 VDD.t847 VSS 0.00687f
C6513 VDD.t846 VSS 0.00759f
C6514 VDD.t855 VSS 0.00759f
C6515 VDD.t857 VSS 0.00687f
C6516 VDD.t845 VSS 0.00687f
C6517 VDD.t843 VSS 0.00759f
C6518 VDD.t849 VSS 0.00759f
C6519 VDD.t851 VSS 0.00687f
C6520 VDD.t840 VSS 0.00687f
C6521 VDD.t841 VSS 0.00759f
C6522 VDD.t837 VSS 0.00759f
C6523 VDD.t838 VSS 0.00687f
C6524 VDD.n1665 VSS 0.02515f
C6525 VDD.n1666 VSS 0.01387f
C6526 VDD.n1667 VSS 0.03413f
C6527 VDD.n1668 VSS 0.0116f
C6528 VDD.n1669 VSS 0.01883f
C6529 VDD.n1670 VSS 0.03413f
C6530 VDD.n1671 VSS 0.00695f
C6531 VDD.n1672 VSS 0.03207f
C6532 VDD.n1673 VSS 0.02515f
C6533 VDD.n1674 VSS 0.01387f
C6534 VDD.n1675 VSS 0.03413f
C6535 VDD.n1676 VSS 0.0116f
C6536 VDD.n1677 VSS 0.0116f
C6537 VDD.n1678 VSS 0.02195f
C6538 VDD.t6 VSS 0.00759f
C6539 VDD.n1679 VSS 0.02195f
C6540 VDD.n1680 VSS 0.11599f
C6541 VDD.n1681 VSS 0.11599f
C6542 VDD.n1682 VSS 0.00779f
C6543 VDD.n1683 VSS 0.02515f
C6544 VDD.n1684 VSS 0.03212f
C6545 VDD.n1685 VSS 0.00695f
C6546 VDD.n1686 VSS 0.03408f
C6547 VDD.n1687 VSS 0.01883f
C6548 VDD.n1688 VSS 0.0116f
C6549 VDD.n1689 VSS 0.02195f
C6550 VDD.t59 VSS 0.00759f
C6551 VDD.n1690 VSS 0.02195f
C6552 VDD.n1691 VSS 0.11599f
C6553 VDD.n1692 VSS 0.11599f
C6554 VDD.n1693 VSS 0.00779f
C6555 VDD.n1694 VSS 0.02515f
C6556 VDD.n1695 VSS 0.02515f
C6557 VDD.n1696 VSS 0.01387f
C6558 VDD.n1697 VSS 0.03413f
C6559 VDD.n1698 VSS 0.0116f
C6560 VDD.n1699 VSS 0.0116f
C6561 VDD.n1700 VSS 0.02195f
C6562 VDD.t62 VSS 0.00759f
C6563 VDD.n1701 VSS 0.02195f
C6564 VDD.n1702 VSS 0.11599f
C6565 VDD.n1703 VSS 0.11599f
C6566 VDD.n1704 VSS 0.00779f
C6567 VDD.n1705 VSS 0.02515f
C6568 VDD.n1706 VSS 0.01619f
C6569 VDD.n1707 VSS 0.01223f
C6570 VDD.n1708 VSS 0.02716f
C6571 VDD.n1709 VSS 0.01883f
C6572 VDD.n1710 VSS 0.0116f
C6573 VDD.n1711 VSS 0.02195f
C6574 VDD.t1105 VSS 0.00759f
C6575 VDD.n1712 VSS 0.02195f
C6576 VDD.n1713 VSS 0.11789f
C6577 VDD.n1714 VSS 0.11789f
C6578 VDD.n1715 VSS 0.00779f
C6579 VDD.n1716 VSS 0.02515f
C6580 VDD.n1717 VSS 0.02515f
C6581 VDD.n1718 VSS 0.01387f
C6582 VDD.n1719 VSS 0.03413f
C6583 VDD.n1720 VSS 0.0116f
C6584 VDD.n1721 VSS 0.0116f
C6585 VDD.n1722 VSS 0.02195f
C6586 VDD.t1107 VSS 0.00759f
C6587 VDD.n1723 VSS 0.02195f
C6588 VDD.n1724 VSS 0.11789f
C6589 VDD.n1725 VSS 0.11789f
C6590 VDD.n1726 VSS 0.00779f
C6591 VDD.n1727 VSS 0.02515f
C6592 VDD.n1728 VSS 0.03212f
C6593 VDD.n1729 VSS 0.00695f
C6594 VDD.n1730 VSS 0.03408f
C6595 VDD.n1731 VSS 0.01883f
C6596 VDD.n1732 VSS 0.0116f
C6597 VDD.n1733 VSS 0.02195f
C6598 VDD.t1093 VSS 0.00759f
C6599 VDD.n1734 VSS 0.02195f
C6600 VDD.n1735 VSS 0.11789f
C6601 VDD.n1736 VSS 0.11789f
C6602 VDD.n1737 VSS 0.00779f
C6603 VDD.n1738 VSS 0.02515f
C6604 VDD.n1739 VSS 0.02515f
C6605 VDD.n1740 VSS 0.01387f
C6606 VDD.n1741 VSS 0.03413f
C6607 VDD.n1742 VSS 0.0116f
C6608 VDD.n1743 VSS 0.0116f
C6609 VDD.n1744 VSS 0.02195f
C6610 VDD.t1119 VSS 0.00759f
C6611 VDD.n1745 VSS 0.02195f
C6612 VDD.n1746 VSS 0.11789f
C6613 VDD.n1747 VSS 0.11789f
C6614 VDD.n1748 VSS 0.00779f
C6615 VDD.n1749 VSS 0.02515f
C6616 VDD.n1750 VSS 0.03212f
C6617 VDD.n1751 VSS 0.00695f
C6618 VDD.n1752 VSS 0.03408f
C6619 VDD.n1753 VSS 0.01883f
C6620 VDD.n1754 VSS 0.0116f
C6621 VDD.n1755 VSS 0.02195f
C6622 VDD.t963 VSS 0.00759f
C6623 VDD.n1756 VSS 0.02195f
C6624 VDD.n1757 VSS 0.11789f
C6625 VDD.n1758 VSS 0.11789f
C6626 VDD.n1759 VSS 0.00779f
C6627 VDD.n1760 VSS 0.02515f
C6628 VDD.n1761 VSS 0.02515f
C6629 VDD.n1762 VSS 0.01387f
C6630 VDD.n1763 VSS 0.03413f
C6631 VDD.n1764 VSS 0.0116f
C6632 VDD.n1765 VSS 0.0116f
C6633 VDD.n1766 VSS 0.02195f
C6634 VDD.t924 VSS 0.00759f
C6635 VDD.n1767 VSS 0.02195f
C6636 VDD.n1768 VSS 0.11789f
C6637 VDD.n1769 VSS 0.11789f
C6638 VDD.n1770 VSS 0.00779f
C6639 VDD.n1771 VSS 0.02515f
C6640 VDD.n1772 VSS 0.03212f
C6641 VDD.n1773 VSS 0.00695f
C6642 VDD.n1774 VSS 0.03408f
C6643 VDD.n1775 VSS 0.01883f
C6644 VDD.n1776 VSS 0.0116f
C6645 VDD.n1777 VSS 0.02195f
C6646 VDD.t947 VSS 0.00759f
C6647 VDD.n1778 VSS 0.02195f
C6648 VDD.n1779 VSS 0.11789f
C6649 VDD.n1780 VSS 0.11789f
C6650 VDD.n1781 VSS 0.00779f
C6651 VDD.n1782 VSS 0.02515f
C6652 VDD.n1783 VSS 0.02515f
C6653 VDD.n1784 VSS 0.01387f
C6654 VDD.n1785 VSS 0.03413f
C6655 VDD.n1786 VSS 0.0116f
C6656 VDD.n1787 VSS 0.0116f
C6657 VDD.n1788 VSS 0.02195f
C6658 VDD.t944 VSS 0.00759f
C6659 VDD.n1789 VSS 0.02195f
C6660 VDD.n1790 VSS 0.11789f
C6661 VDD.n1791 VSS 0.11789f
C6662 VDD.n1792 VSS 0.00779f
C6663 VDD.n1793 VSS 0.02515f
C6664 VDD.n1794 VSS 0.03212f
C6665 VDD.n1795 VSS 0.00695f
C6666 VDD.n1796 VSS 0.03408f
C6667 VDD.n1797 VSS 0.01883f
C6668 VDD.n1798 VSS 0.0116f
C6669 VDD.n1799 VSS 0.02195f
C6670 VDD.n1800 VSS 0.02855f
C6671 VDD.t356 VSS 0.00759f
C6672 VDD.n1801 VSS 0.02195f
C6673 VDD.n1802 VSS 0.02418f
C6674 VDD.n1803 VSS 0.26136f
C6675 VDD.t379 VSS 0.00759f
C6676 VDD.n1804 VSS 0.02195f
C6677 VDD.n1805 VSS 0.02418f
C6678 VDD.n1806 VSS 0.17202f
C6679 VDD.t354 VSS 0.00759f
C6680 VDD.n1807 VSS 0.02195f
C6681 VDD.n1808 VSS 0.02418f
C6682 VDD.n1809 VSS 0.17202f
C6683 VDD.t222 VSS 0.00759f
C6684 VDD.n1810 VSS 0.02195f
C6685 VDD.n1811 VSS 0.02418f
C6686 VDD.n1812 VSS 0.17202f
C6687 VDD.t252 VSS 0.00759f
C6688 VDD.n1813 VSS 0.02195f
C6689 VDD.n1814 VSS 0.02418f
C6690 VDD.n1815 VSS 0.17202f
C6691 VDD.t241 VSS 0.00759f
C6692 VDD.n1816 VSS 0.02195f
C6693 VDD.n1817 VSS 0.02418f
C6694 VDD.n1818 VSS 0.17202f
C6695 VDD.t229 VSS 0.00759f
C6696 VDD.n1819 VSS 0.02195f
C6697 VDD.n1820 VSS 0.02418f
C6698 VDD.n1821 VSS 0.17202f
C6699 VDD.t568 VSS 0.00759f
C6700 VDD.n1822 VSS 0.02195f
C6701 VDD.n1823 VSS 0.02418f
C6702 VDD.n1824 VSS 0.17202f
C6703 VDD.t592 VSS 0.00759f
C6704 VDD.n1825 VSS 0.02195f
C6705 VDD.n1826 VSS 0.02418f
C6706 VDD.n1827 VSS 0.17202f
C6707 VDD.t586 VSS 0.00759f
C6708 VDD.n1828 VSS 0.02195f
C6709 VDD.n1829 VSS 0.02418f
C6710 VDD.n1830 VSS 0.17202f
C6711 VDD.t603 VSS 0.00759f
C6712 VDD.n1831 VSS 0.02195f
C6713 VDD.n1832 VSS 0.02418f
C6714 VDD.n1833 VSS 0.17202f
C6715 VDD.t691 VSS 0.00759f
C6716 VDD.n1834 VSS 0.02195f
C6717 VDD.n1835 VSS 0.02418f
C6718 VDD.n1836 VSS 0.17202f
C6719 VDD.t703 VSS 0.00759f
C6720 VDD.n1837 VSS 0.02195f
C6721 VDD.n1838 VSS 0.02418f
C6722 VDD.n1839 VSS 0.17202f
C6723 VDD.t725 VSS 0.00759f
C6724 VDD.n1840 VSS 0.02195f
C6725 VDD.n1841 VSS 0.02418f
C6726 VDD.n1842 VSS 0.26136f
C6727 VDD.n1843 VSS 0.02855f
C6728 VDD.t770 VSS 0.00687f
C6729 VDD.t727 VSS 0.00687f
C6730 VDD.n1844 VSS 0.03207f
C6731 VDD.n1845 VSS 0.02515f
C6732 VDD.n1846 VSS 0.00779f
C6733 VDD.t710 VSS 0.00759f
C6734 VDD.n1847 VSS 0.03413f
C6735 VDD.n1848 VSS 0.01883f
C6736 VDD.t687 VSS 0.00759f
C6737 VDD.n1849 VSS 0.03413f
C6738 VDD.n1850 VSS 0.01883f
C6739 VDD.n1851 VSS 0.0116f
C6740 VDD.t734 VSS 0.00759f
C6741 VDD.n1852 VSS 0.02195f
C6742 VDD.n1853 VSS 0.02855f
C6743 VDD.t722 VSS 0.00687f
C6744 VDD.t740 VSS 0.00687f
C6745 VDD.n1854 VSS 0.03207f
C6746 VDD.n1855 VSS 0.02515f
C6747 VDD.n1856 VSS 0.00779f
C6748 VDD.t696 VSS 0.00759f
C6749 VDD.n1857 VSS 0.03413f
C6750 VDD.n1858 VSS 0.01883f
C6751 VDD.t697 VSS 0.00759f
C6752 VDD.n1859 VSS 0.02195f
C6753 VDD.n1860 VSS 0.0116f
C6754 VDD.t752 VSS 0.00699f
C6755 VDD.n1861 VSS 0.04124f
C6756 VDD.t677 VSS 2.0796f
C6757 VDD.n1862 VSS 0.41757f
C6758 VDD.n1863 VSS 0.0116f
C6759 VDD.n1864 VSS 0.02195f
C6760 VDD.n1865 VSS 0.02855f
C6761 VDD.n1866 VSS 0.26136f
C6762 VDD.n1867 VSS 0.02418f
C6763 VDD.t684 VSS 0.00687f
C6764 VDD.t708 VSS 0.00687f
C6765 VDD.n1868 VSS 0.03207f
C6766 VDD.n1869 VSS 0.02515f
C6767 VDD.n1870 VSS 0.00779f
C6768 VDD.t686 VSS 0.00759f
C6769 VDD.n1871 VSS 0.03413f
C6770 VDD.n1872 VSS 0.01883f
C6771 VDD.n1873 VSS 0.0116f
C6772 VDD.t709 VSS 0.00759f
C6773 VDD.n1874 VSS 0.02195f
C6774 VDD.n1875 VSS 0.02418f
C6775 VDD.t693 VSS 0.00687f
C6776 VDD.t719 VSS 0.00687f
C6777 VDD.n1876 VSS 0.03207f
C6778 VDD.n1877 VSS 0.02515f
C6779 VDD.n1878 VSS 0.00779f
C6780 VDD.t694 VSS 0.00759f
C6781 VDD.n1879 VSS 0.03413f
C6782 VDD.n1880 VSS 0.01883f
C6783 VDD.t673 VSS 2.0796f
C6784 VDD.n1881 VSS 0.41757f
C6785 VDD.n1882 VSS 0.0116f
C6786 VDD.n1883 VSS 0.02195f
C6787 VDD.n1884 VSS 0.02418f
C6788 VDD.n1885 VSS 0.26136f
C6789 VDD.n1886 VSS 0.17202f
C6790 VDD.n1887 VSS 0.02418f
C6791 VDD.t715 VSS 0.00699f
C6792 VDD.n1888 VSS 0.04124f
C6793 VDD.t99 VSS 8.83832f
C6794 VDD.n1889 VSS 1.80634f
C6795 VDD.n1890 VSS 0.0116f
C6796 VDD.n1891 VSS 0.02195f
C6797 VDD.n1892 VSS 0.02418f
C6798 VDD.n1893 VSS 0.17202f
C6799 VDD.n1894 VSS 0.17202f
C6800 VDD.n1895 VSS 0.02418f
C6801 VDD.t728 VSS 0.00687f
C6802 VDD.t746 VSS 0.00687f
C6803 VDD.n1896 VSS 0.03207f
C6804 VDD.n1897 VSS 0.02515f
C6805 VDD.n1898 VSS 0.00779f
C6806 VDD.t705 VSS 0.00759f
C6807 VDD.n1899 VSS 0.03413f
C6808 VDD.n1900 VSS 0.01883f
C6809 VDD.n1901 VSS 0.0116f
C6810 VDD.t706 VSS 0.00759f
C6811 VDD.n1902 VSS 0.02195f
C6812 VDD.n1903 VSS 0.02418f
C6813 VDD.t759 VSS 0.00699f
C6814 VDD.n1904 VSS 0.04124f
C6815 VDD.t679 VSS 8.31842f
C6816 VDD.n1905 VSS 1.69952f
C6817 VDD.n1906 VSS 0.0116f
C6818 VDD.n1907 VSS 0.02195f
C6819 VDD.n1908 VSS 0.02418f
C6820 VDD.n1909 VSS 0.17202f
C6821 VDD.n1910 VSS 0.17202f
C6822 VDD.n1911 VSS 0.02418f
C6823 VDD.t566 VSS 0.00687f
C6824 VDD.t589 VSS 0.00687f
C6825 VDD.n1912 VSS 0.03207f
C6826 VDD.n1913 VSS 0.02515f
C6827 VDD.n1914 VSS 0.00779f
C6828 VDD.t567 VSS 0.00759f
C6829 VDD.n1915 VSS 0.03413f
C6830 VDD.n1916 VSS 0.01883f
C6831 VDD.n1917 VSS 0.0116f
C6832 VDD.t590 VSS 0.00759f
C6833 VDD.n1918 VSS 0.02195f
C6834 VDD.n1919 VSS 0.02418f
C6835 VDD.t577 VSS 0.00687f
C6836 VDD.t598 VSS 0.00687f
C6837 VDD.n1920 VSS 0.03207f
C6838 VDD.n1921 VSS 0.02515f
C6839 VDD.n1922 VSS 0.00779f
C6840 VDD.t554 VSS 0.00759f
C6841 VDD.n1923 VSS 0.03413f
C6842 VDD.n1924 VSS 0.01883f
C6843 VDD.t552 VSS 2.0796f
C6844 VDD.n1925 VSS 0.41757f
C6845 VDD.n1926 VSS 0.0116f
C6846 VDD.n1927 VSS 0.02195f
C6847 VDD.n1928 VSS 0.02418f
C6848 VDD.n1929 VSS 0.17202f
C6849 VDD.n1930 VSS 0.17202f
C6850 VDD.n1931 VSS 0.02418f
C6851 VDD.t595 VSS 0.00699f
C6852 VDD.n1932 VSS 0.04124f
C6853 VDD.t547 VSS 2.0796f
C6854 VDD.n1933 VSS 0.41757f
C6855 VDD.n1934 VSS 0.0116f
C6856 VDD.n1935 VSS 0.02195f
C6857 VDD.n1936 VSS 0.02418f
C6858 VDD.n1937 VSS 0.17202f
C6859 VDD.n1938 VSS 0.17202f
C6860 VDD.n1939 VSS 0.02418f
C6861 VDD.t556 VSS 0.00687f
C6862 VDD.t620 VSS 0.00687f
C6863 VDD.n1940 VSS 0.03207f
C6864 VDD.n1941 VSS 0.02515f
C6865 VDD.n1942 VSS 0.00779f
C6866 VDD.t579 VSS 0.00759f
C6867 VDD.n1943 VSS 0.03413f
C6868 VDD.n1944 VSS 0.01883f
C6869 VDD.n1945 VSS 0.0116f
C6870 VDD.t550 VSS 0.00759f
C6871 VDD.n1946 VSS 0.02195f
C6872 VDD.n1947 VSS 0.02418f
C6873 VDD.t607 VSS 0.00699f
C6874 VDD.n1948 VSS 0.04124f
C6875 VDD.t17 VSS 8.83832f
C6876 VDD.n1949 VSS 1.80634f
C6877 VDD.n1950 VSS 0.0116f
C6878 VDD.n1951 VSS 0.02195f
C6879 VDD.n1952 VSS 0.02418f
C6880 VDD.n1953 VSS 0.17202f
C6881 VDD.n1954 VSS 0.17202f
C6882 VDD.n1955 VSS 0.02418f
C6883 VDD.t644 VSS 0.00687f
C6884 VDD.t614 VSS 0.00687f
C6885 VDD.n1956 VSS 0.03207f
C6886 VDD.n1957 VSS 0.02515f
C6887 VDD.n1958 VSS 0.00779f
C6888 VDD.t571 VSS 0.00759f
C6889 VDD.n1959 VSS 0.03413f
C6890 VDD.n1960 VSS 0.01883f
C6891 VDD.n1961 VSS 0.0116f
C6892 VDD.t582 VSS 0.00759f
C6893 VDD.n1962 VSS 0.02195f
C6894 VDD.n1963 VSS 0.02418f
C6895 VDD.t627 VSS 0.00687f
C6896 VDD.t602 VSS 0.00687f
C6897 VDD.n1964 VSS 0.03207f
C6898 VDD.n1965 VSS 0.02515f
C6899 VDD.n1966 VSS 0.00779f
C6900 VDD.t551 VSS 0.00759f
C6901 VDD.n1967 VSS 0.03413f
C6902 VDD.n1968 VSS 0.01883f
C6903 VDD.t173 VSS 8.31842f
C6904 VDD.n1969 VSS 1.69952f
C6905 VDD.n1970 VSS 0.0116f
C6906 VDD.n1971 VSS 0.02195f
C6907 VDD.n1972 VSS 0.02418f
C6908 VDD.n1973 VSS 0.17202f
C6909 VDD.n1974 VSS 0.17202f
C6910 VDD.n1975 VSS 0.02418f
C6911 VDD.t282 VSS 0.00699f
C6912 VDD.n1976 VSS 0.04124f
C6913 VDD.t215 VSS 2.0796f
C6914 VDD.n1977 VSS 0.41757f
C6915 VDD.n1978 VSS 0.0116f
C6916 VDD.n1979 VSS 0.02195f
C6917 VDD.n1980 VSS 0.02418f
C6918 VDD.n1981 VSS 0.17202f
C6919 VDD.n1982 VSS 0.17202f
C6920 VDD.n1983 VSS 0.02418f
C6921 VDD.t247 VSS 0.00687f
C6922 VDD.t279 VSS 0.00687f
C6923 VDD.n1984 VSS 0.03207f
C6924 VDD.n1985 VSS 0.02515f
C6925 VDD.n1986 VSS 0.00779f
C6926 VDD.t280 VSS 0.00759f
C6927 VDD.n1987 VSS 0.03413f
C6928 VDD.n1988 VSS 0.01883f
C6929 VDD.n1989 VSS 0.0116f
C6930 VDD.t203 VSS 0.00759f
C6931 VDD.n1990 VSS 0.02195f
C6932 VDD.n1991 VSS 0.02418f
C6933 VDD.t204 VSS 0.00699f
C6934 VDD.n1992 VSS 0.04124f
C6935 VDD.t202 VSS 2.0796f
C6936 VDD.n1993 VSS 0.41757f
C6937 VDD.n1994 VSS 0.0116f
C6938 VDD.n1995 VSS 0.02195f
C6939 VDD.n1996 VSS 0.02418f
C6940 VDD.n1997 VSS 0.17202f
C6941 VDD.n1998 VSS 0.17202f
C6942 VDD.n1999 VSS 0.02418f
C6943 VDD.t209 VSS 0.00687f
C6944 VDD.t267 VSS 0.00687f
C6945 VDD.n2000 VSS 0.03207f
C6946 VDD.n2001 VSS 0.02515f
C6947 VDD.n2002 VSS 0.00779f
C6948 VDD.t268 VSS 0.00759f
C6949 VDD.n2003 VSS 0.03413f
C6950 VDD.n2004 VSS 0.01883f
C6951 VDD.n2005 VSS 0.0116f
C6952 VDD.t250 VSS 0.00759f
C6953 VDD.n2006 VSS 0.02195f
C6954 VDD.n2007 VSS 0.02418f
C6955 VDD.t249 VSS 0.00687f
C6956 VDD.t232 VSS 0.00687f
C6957 VDD.n2008 VSS 0.03207f
C6958 VDD.n2009 VSS 0.02515f
C6959 VDD.n2010 VSS 0.00779f
C6960 VDD.t231 VSS 0.00759f
C6961 VDD.n2011 VSS 0.03413f
C6962 VDD.n2012 VSS 0.01883f
C6963 VDD.t126 VSS 8.31842f
C6964 VDD.n2013 VSS 1.69952f
C6965 VDD.n2014 VSS 0.0116f
C6966 VDD.n2015 VSS 0.02195f
C6967 VDD.n2016 VSS 0.02418f
C6968 VDD.n2017 VSS 0.17202f
C6969 VDD.n2018 VSS 0.17202f
C6970 VDD.n2019 VSS 0.02418f
C6971 VDD.t237 VSS 0.00699f
C6972 VDD.n2020 VSS 0.04124f
C6973 VDD.t198 VSS 8.31842f
C6974 VDD.n2021 VSS 1.69952f
C6975 VDD.n2022 VSS 0.0116f
C6976 VDD.n2023 VSS 0.02195f
C6977 VDD.n2024 VSS 0.02418f
C6978 VDD.n2025 VSS 0.17202f
C6979 VDD.n2026 VSS 0.17202f
C6980 VDD.n2027 VSS 0.02418f
C6981 VDD.t418 VSS 0.00687f
C6982 VDD.t387 VSS 0.00687f
C6983 VDD.n2028 VSS 0.03207f
C6984 VDD.n2029 VSS 0.02515f
C6985 VDD.n2030 VSS 0.00779f
C6986 VDD.t397 VSS 0.00759f
C6987 VDD.n2031 VSS 0.03413f
C6988 VDD.n2032 VSS 0.01883f
C6989 VDD.n2033 VSS 0.0116f
C6990 VDD.t374 VSS 0.00759f
C6991 VDD.n2034 VSS 0.02195f
C6992 VDD.n2035 VSS 0.02418f
C6993 VDD.t371 VSS 0.00699f
C6994 VDD.n2036 VSS 0.04124f
C6995 VDD.t347 VSS 2.0796f
C6996 VDD.n2037 VSS 0.41757f
C6997 VDD.n2038 VSS 0.0116f
C6998 VDD.n2039 VSS 0.02195f
C6999 VDD.n2040 VSS 0.02418f
C7000 VDD.n2041 VSS 0.17202f
C7001 VDD.n2042 VSS 0.17202f
C7002 VDD.n2043 VSS 0.02418f
C7003 VDD.t406 VSS 0.00687f
C7004 VDD.t375 VSS 0.00687f
C7005 VDD.n2044 VSS 0.03207f
C7006 VDD.n2045 VSS 0.02515f
C7007 VDD.n2046 VSS 0.00779f
C7008 VDD.t393 VSS 0.00759f
C7009 VDD.n2047 VSS 0.03413f
C7010 VDD.n2048 VSS 0.01883f
C7011 VDD.n2049 VSS 0.0116f
C7012 VDD.t361 VSS 0.00759f
C7013 VDD.n2050 VSS 0.02195f
C7014 VDD.n2051 VSS 0.02418f
C7015 VDD.t391 VSS 0.00687f
C7016 VDD.t360 VSS 0.00687f
C7017 VDD.n2052 VSS 0.03207f
C7018 VDD.n2053 VSS 0.02515f
C7019 VDD.n2054 VSS 0.00779f
C7020 VDD.t368 VSS 0.00759f
C7021 VDD.n2055 VSS 0.03413f
C7022 VDD.n2056 VSS 0.01883f
C7023 VDD.t343 VSS 2.0796f
C7024 VDD.n2057 VSS 0.41757f
C7025 VDD.n2058 VSS 0.0116f
C7026 VDD.n2059 VSS 0.02195f
C7027 VDD.n2060 VSS 0.02418f
C7028 VDD.n2061 VSS 0.17202f
C7029 VDD.n2062 VSS 0.26136f
C7030 VDD.n2063 VSS 0.02418f
C7031 VDD.t417 VSS 0.00699f
C7032 VDD.n2064 VSS 0.04124f
C7033 VDD.t5 VSS 8.31842f
C7034 VDD.n2065 VSS 1.69952f
C7035 VDD.n2066 VSS 0.0116f
C7036 VDD.n2067 VSS 0.02195f
C7037 VDD.n2068 VSS 0.02418f
C7038 VDD.n2069 VSS 0.26136f
C7039 VDD.n2070 VSS 0.02855f
C7040 VDD.n2071 VSS 0.00779f
C7041 VDD.n2072 VSS 0.02515f
C7042 VDD.n2073 VSS 0.02515f
C7043 VDD.n2074 VSS 0.01387f
C7044 VDD.n2075 VSS 0.03413f
C7045 VDD.n2076 VSS 0.0116f
C7046 6to4_0.buff_PI_d32_1.buff_PI_d16$1_0.inv_PI_d8$1_0.VOUT.t3 VSS 0.0351f
C7047 6to4_0.buff_PI_d32_1.buff_PI_d16$1_0.inv_PI_d8$1_0.VOUT.t36 VSS 0.2604f
C7048 6to4_0.buff_PI_d32_1.buff_PI_d16$1_0.inv_PI_d16$1_0.inv_PI_d8$1_1.inv_PI_d4$1_1.inv_PI_d2$1_0.inv_PI$1_1.VIN VSS 0.00566f
C7049 6to4_0.buff_PI_d32_1.buff_PI_d16$1_0.inv_PI_d16$1_0.inv_PI_d8$1_1.inv_PI_d4$1_1.inv_PI_d2$1_0.VIN VSS 0.00708f
C7050 6to4_0.buff_PI_d32_1.buff_PI_d16$1_0.inv_PI_d8$1_0.VOUT.n0 VSS 0.01557f
C7051 6to4_0.buff_PI_d32_1.buff_PI_d16$1_0.inv_PI_d8$1_0.VOUT.n1 VSS 0.12379f
C7052 6to4_0.buff_PI_d32_1.buff_PI_d16$1_0.inv_PI_d8$1_0.VOUT.t25 VSS 0.2604f
C7053 6to4_0.buff_PI_d32_1.buff_PI_d16$1_0.inv_PI_d16$1_0.inv_PI_d8$1_0.inv_PI_d4$1_1.inv_PI_d2$1_1.inv_PI$1_1.VIN VSS 0.00472f
C7054 6to4_0.buff_PI_d32_1.buff_PI_d16$1_0.inv_PI_d16$1_0.inv_PI_d8$1_0.inv_PI_d4$1_1.VIN VSS 0.00566f
C7055 6to4_0.buff_PI_d32_1.buff_PI_d16$1_0.inv_PI_d16$1_0.inv_PI_d8$1_0.inv_PI_d4$1_1.inv_PI_d2$1_1.VIN VSS 0.00236f
C7056 6to4_0.buff_PI_d32_1.buff_PI_d16$1_0.inv_PI_d8$1_0.VOUT.n2 VSS 0.02929f
C7057 6to4_0.buff_PI_d32_1.buff_PI_d16$1_0.inv_PI_d8$1_0.VOUT.t39 VSS 0.2604f
C7058 6to4_0.buff_PI_d32_1.buff_PI_d16$1_0.inv_PI_d16$1_0.inv_PI_d8$1_0.inv_PI_d4$1_1.inv_PI_d2$1_1.inv_PI$1_0.VIN VSS 0.00708f
C7059 6to4_0.buff_PI_d32_1.buff_PI_d16$1_0.inv_PI_d8$1_0.VOUT.n3 VSS 0.02123f
C7060 6to4_0.buff_PI_d32_1.buff_PI_d16$1_0.inv_PI_d8$1_0.VOUT.n4 VSS 0.2153f
C7061 6to4_0.buff_PI_d32_1.buff_PI_d16$1_0.inv_PI_d8$1_0.VOUT.t38 VSS 0.2604f
C7062 6to4_0.buff_PI_d32_1.buff_PI_d16$1_0.inv_PI_d16$1_0.inv_PI_d8$1_0.inv_PI_d4$1_0.inv_PI_d2$1_1.inv_PI$1_1.VIN VSS 0.00472f
C7063 6to4_0.buff_PI_d32_1.buff_PI_d16$1_0.inv_PI_d16$1_0.inv_PI_d8$1_0.inv_PI_d4$1_0.VIN VSS 0.00566f
C7064 6to4_0.buff_PI_d32_1.buff_PI_d16$1_0.inv_PI_d16$1_0.inv_PI_d8$1_0.inv_PI_d4$1_0.inv_PI_d2$1_1.VIN VSS 0.00236f
C7065 6to4_0.buff_PI_d32_1.buff_PI_d16$1_0.inv_PI_d8$1_0.VOUT.n5 VSS 0.01557f
C7066 6to4_0.buff_PI_d32_1.buff_PI_d16$1_0.inv_PI_d8$1_0.VOUT.n6 VSS 0.12379f
C7067 6to4_0.buff_PI_d32_1.buff_PI_d16$1_0.inv_PI_d8$1_0.VOUT.t33 VSS 0.2604f
C7068 6to4_0.buff_PI_d32_1.buff_PI_d16$1_0.inv_PI_d16$1_0.inv_PI_d8$1_1.inv_PI_d4$1_1.inv_PI_d2$1_0.inv_PI$1_0.VIN VSS 0.00708f
C7069 6to4_0.buff_PI_d32_1.buff_PI_d16$1_0.inv_PI_d8$1_0.VOUT.n7 VSS 0.02123f
C7070 6to4_0.buff_PI_d32_1.buff_PI_d16$1_0.inv_PI_d8$1_0.VOUT.n8 VSS 0.12363f
C7071 6to4_0.buff_PI_d32_1.buff_PI_d16$1_0.inv_PI_d8$1_0.VOUT.t29 VSS 0.2604f
C7072 6to4_0.buff_PI_d32_1.buff_PI_d16$1_0.inv_PI_d16$1_0.inv_PI_d8$1_1.inv_PI_d4$1_0.inv_PI_d2$1_0.inv_PI$1_0.VIN VSS 0.00708f
C7073 6to4_0.buff_PI_d32_1.buff_PI_d16$1_0.inv_PI_d8$1_0.VOUT.n9 VSS 0.03495f
C7074 6to4_0.buff_PI_d32_1.buff_PI_d16$1_0.inv_PI_d8$1_0.VOUT.t26 VSS 0.2604f
C7075 6to4_0.buff_PI_d32_1.buff_PI_d16$1_0.inv_PI_d16$1_0.inv_PI_d8$1_1.inv_PI_d4$1_0.inv_PI_d2$1_0.inv_PI$1_1.VIN VSS 0.00566f
C7076 6to4_0.buff_PI_d32_1.buff_PI_d16$1_0.inv_PI_d16$1_0.inv_PI_d8$1_1.inv_PI_d4$1_0.inv_PI_d2$1_0.VIN VSS 0.00708f
C7077 6to4_0.buff_PI_d32_1.buff_PI_d16$1_0.inv_PI_d8$1_0.VOUT.n10 VSS 0.01557f
C7078 6to4_0.buff_PI_d32_1.buff_PI_d16$1_0.inv_PI_d8$1_0.VOUT.n11 VSS 0.21546f
C7079 6to4_0.buff_PI_d32_1.buff_PI_d16$1_0.inv_PI_d8$1_0.VOUT.t35 VSS 0.2604f
C7080 6to4_0.buff_PI_d32_1.buff_PI_d16$1_0.inv_PI_d16$1_0.inv_PI_d8$1_0.inv_PI_d4$1_0.inv_PI_d2$1_1.inv_PI$1_0.VIN VSS 0.00708f
C7081 6to4_0.buff_PI_d32_1.buff_PI_d16$1_0.inv_PI_d8$1_0.VOUT.n12 VSS 0.02123f
C7082 6to4_0.buff_PI_d32_1.buff_PI_d16$1_0.inv_PI_d8$1_0.VOUT.n13 VSS 0.12363f
C7083 6to4_0.buff_PI_d32_1.buff_PI_d16$1_0.inv_PI_d8$1_0.VOUT.t27 VSS 0.2604f
C7084 6to4_0.buff_PI_d32_1.buff_PI_d16$1_0.inv_PI_d16$1_0.inv_PI_d8$1_0.inv_PI_d4$1_0.inv_PI_d2$1_0.inv_PI$1_0.VIN VSS 0.00708f
C7085 6to4_0.buff_PI_d32_1.buff_PI_d16$1_0.inv_PI_d8$1_0.VOUT.n14 VSS 0.03495f
C7086 6to4_0.buff_PI_d32_1.buff_PI_d16$1_0.inv_PI_d8$1_0.VOUT.t30 VSS 0.2604f
C7087 6to4_0.buff_PI_d32_1.buff_PI_d16$1_0.inv_PI_d16$1_0.inv_PI_d8$1_0.inv_PI_d4$1_0.inv_PI_d2$1_0.inv_PI$1_1.VIN VSS 0.00566f
C7088 6to4_0.buff_PI_d32_1.buff_PI_d16$1_0.inv_PI_d16$1_0.inv_PI_d8$1_0.inv_PI_d4$1_0.inv_PI_d2$1_0.VIN VSS 0.00708f
C7089 6to4_0.buff_PI_d32_1.buff_PI_d16$1_0.inv_PI_d8$1_0.VOUT.n15 VSS 0.01557f
C7090 6to4_0.buff_PI_d32_1.buff_PI_d16$1_0.inv_PI_d8$1_0.VOUT.n16 VSS 0.21546f
C7091 6to4_0.buff_PI_d32_1.buff_PI_d16$1_0.inv_PI_d8$1_0.VOUT.n17 VSS 0.32005f
C7092 6to4_0.buff_PI_d32_1.buff_PI_d16$1_0.inv_PI_d8$1_0.VOUT.n18 VSS 0.32005f
C7093 6to4_0.buff_PI_d32_1.buff_PI_d16$1_0.inv_PI_d8$1_0.VOUT.t24 VSS 0.2604f
C7094 6to4_0.buff_PI_d32_1.buff_PI_d16$1_0.inv_PI_d16$1_0.inv_PI_d8$1_1.inv_PI_d4$1_0.inv_PI_d2$1_1.inv_PI$1_0.VIN VSS 0.00708f
C7095 6to4_0.buff_PI_d32_1.buff_PI_d16$1_0.inv_PI_d8$1_0.VOUT.n19 VSS 0.02123f
C7096 6to4_0.buff_PI_d32_1.buff_PI_d16$1_0.inv_PI_d8$1_0.VOUT.n20 VSS 0.12363f
C7097 6to4_0.buff_PI_d32_1.buff_PI_d16$1_0.inv_PI_d8$1_0.VOUT.t28 VSS 0.2604f
C7098 6to4_0.buff_PI_d32_1.buff_PI_d16$1_0.inv_PI_d16$1_0.inv_PI_d8$1_1.inv_PI_d4$1_0.inv_PI_d2$1_1.inv_PI$1_1.VIN VSS 0.00472f
C7099 6to4_0.buff_PI_d32_1.buff_PI_d16$1_0.inv_PI_d16$1_0.inv_PI_d8$1_1.inv_PI_d4$1_0.VIN VSS 0.00566f
C7100 6to4_0.buff_PI_d32_1.buff_PI_d16$1_0.inv_PI_d16$1_0.inv_PI_d8$1_1.inv_PI_d4$1_0.inv_PI_d2$1_1.VIN VSS 0.00236f
C7101 6to4_0.buff_PI_d32_1.buff_PI_d16$1_0.inv_PI_d8$1_0.VOUT.n21 VSS 0.01557f
C7102 6to4_0.buff_PI_d32_1.buff_PI_d16$1_0.inv_PI_d8$1_0.VOUT.n22 VSS 0.12379f
C7103 6to4_0.buff_PI_d32_1.buff_PI_d16$1_0.inv_PI_d8$1_0.VOUT.n23 VSS 0.32005f
C7104 6to4_0.buff_PI_d32_1.buff_PI_d16$1_0.inv_PI_d8$1_0.VOUT.n24 VSS 0.32005f
C7105 6to4_0.buff_PI_d32_1.buff_PI_d16$1_0.inv_PI_d8$1_0.VOUT.t32 VSS 0.2604f
C7106 6to4_0.buff_PI_d32_1.buff_PI_d16$1_0.inv_PI_d16$1_0.inv_PI_d8$1_0.inv_PI_d4$1_1.inv_PI_d2$1_0.inv_PI$1_0.VIN VSS 0.00708f
C7107 6to4_0.buff_PI_d32_1.buff_PI_d16$1_0.inv_PI_d8$1_0.VOUT.n25 VSS 0.02123f
C7108 6to4_0.buff_PI_d32_1.buff_PI_d16$1_0.inv_PI_d8$1_0.VOUT.n26 VSS 0.12363f
C7109 6to4_0.buff_PI_d32_1.buff_PI_d16$1_0.inv_PI_d8$1_0.VOUT.t31 VSS 0.2604f
C7110 6to4_0.buff_PI_d32_1.buff_PI_d16$1_0.inv_PI_d16$1_0.inv_PI_d8$1_0.inv_PI_d4$1_1.inv_PI_d2$1_0.inv_PI$1_1.VIN VSS 0.00566f
C7111 6to4_0.buff_PI_d32_1.buff_PI_d16$1_0.inv_PI_d16$1_0.inv_PI_d8$1_0.inv_PI_d4$1_1.inv_PI_d2$1_0.VIN VSS 0.00708f
C7112 6to4_0.buff_PI_d32_1.buff_PI_d16$1_0.inv_PI_d8$1_0.VOUT.n27 VSS 0.01557f
C7113 6to4_0.buff_PI_d32_1.buff_PI_d16$1_0.inv_PI_d8$1_0.VOUT.n28 VSS 0.12379f
C7114 6to4_0.buff_PI_d32_1.buff_PI_d16$1_0.inv_PI_d8$1_0.VOUT.n29 VSS 0.09354f
C7115 6to4_0.buff_PI_d32_1.buff_PI_d16$1_0.inv_PI_d16$1_0.VIN VSS 0.45552f
C7116 6to4_0.buff_PI_d32_1.buff_PI_d16$1_0.inv_PI_d8$1_0.VOUT.n30 VSS 0.09103f
C7117 6to4_0.buff_PI_d32_1.buff_PI_d16$1_0.inv_PI_d8$1_0.VOUT.t34 VSS 0.2604f
C7118 6to4_0.buff_PI_d32_1.buff_PI_d16$1_0.inv_PI_d16$1_0.inv_PI_d8$1_1.inv_PI_d4$1_1.inv_PI_d2$1_1.inv_PI$1_0.VIN VSS 0.00708f
C7119 6to4_0.buff_PI_d32_1.buff_PI_d16$1_0.inv_PI_d8$1_0.VOUT.n31 VSS 0.02123f
C7120 6to4_0.buff_PI_d32_1.buff_PI_d16$1_0.inv_PI_d8$1_0.VOUT.n32 VSS 0.2153f
C7121 6to4_0.buff_PI_d32_1.buff_PI_d16$1_0.inv_PI_d8$1_0.VOUT.t37 VSS 0.2604f
C7122 6to4_0.buff_PI_d32_1.buff_PI_d16$1_0.inv_PI_d8$1_0.VOUT.n33 VSS 0.02929f
C7123 6to4_0.buff_PI_d32_1.buff_PI_d16$1_0.inv_PI_d16$1_0.inv_PI_d8$1_1.inv_PI_d4$1_1.inv_PI_d2$1_1.VIN VSS 0.00236f
C7124 6to4_0.buff_PI_d32_1.buff_PI_d16$1_0.inv_PI_d16$1_0.inv_PI_d8$1_1.inv_PI_d4$1_1.VIN VSS 0.00566f
C7125 6to4_0.buff_PI_d32_1.buff_PI_d16$1_0.inv_PI_d16$1_0.inv_PI_d8$1_1.inv_PI_d4$1_1.inv_PI_d2$1_1.inv_PI$1_1.VIN VSS 0.06501f
C7126 6to4_0.buff_PI_d32_1.buff_PI_d16$1_0.inv_PI_d8$1_0.VOUT.n34 VSS 0.08613f
C7127 6to4_0.buff_PI_d32_1.buff_PI_d16$1_0.inv_PI_d8$1_0.VOUT.t5 VSS 0.03591f
C7128 6to4_0.buff_PI_d32_1.buff_PI_d16$1_0.inv_PI_d8$1_0.VOUT.t4 VSS 0.03179f
C7129 6to4_0.buff_PI_d32_1.buff_PI_d16$1_0.inv_PI_d8$1_0.VOUT.t1 VSS 0.03179f
C7130 6to4_0.buff_PI_d32_1.buff_PI_d16$1_0.inv_PI_d8$1_0.VOUT.t2 VSS 0.03591f
C7131 6to4_0.buff_PI_d32_1.buff_PI_d16$1_0.inv_PI_d8$1_0.VOUT.t21 VSS 0.0351f
C7132 6to4_0.buff_PI_d32_1.buff_PI_d16$1_0.inv_PI_d8$1_0.VOUT.t23 VSS 0.03591f
C7133 6to4_0.buff_PI_d32_1.buff_PI_d16$1_0.inv_PI_d8$1_0.VOUT.t22 VSS 0.03179f
C7134 6to4_0.buff_PI_d32_1.buff_PI_d16$1_0.inv_PI_d8$1_0.VOUT.t15 VSS 0.03179f
C7135 6to4_0.buff_PI_d32_1.buff_PI_d16$1_0.inv_PI_d8$1_0.VOUT.t17 VSS 0.03591f
C7136 6to4_0.buff_PI_d32_1.buff_PI_d16$1_0.inv_PI_d8$1_0.VOUT.t16 VSS 0.0351f
C7137 6to4_0.buff_PI_d32_1.buff_PI_d16$1_0.inv_PI_d8$1_0.VOUT.t18 VSS 0.0351f
C7138 6to4_0.buff_PI_d32_1.buff_PI_d16$1_0.inv_PI_d8$1_0.VOUT.t20 VSS 0.03591f
C7139 6to4_0.buff_PI_d32_1.buff_PI_d16$1_0.inv_PI_d8$1_0.VOUT.t19 VSS 0.03179f
C7140 6to4_0.buff_PI_d32_1.buff_PI_d16$1_0.inv_PI_d8$1_0.VOUT.t7 VSS 0.03179f
C7141 6to4_0.buff_PI_d32_1.buff_PI_d16$1_0.inv_PI_d8$1_0.VOUT.t8 VSS 0.03591f
C7142 6to4_0.buff_PI_d32_1.buff_PI_d16$1_0.inv_PI_d8$1_0.VOUT.t6 VSS 0.0351f
C7143 6to4_0.buff_PI_d32_1.buff_PI_d16$1_0.inv_PI_d8$1_0.VOUT.t12 VSS 0.0351f
C7144 6to4_0.buff_PI_d32_1.buff_PI_d16$1_0.inv_PI_d8$1_0.VOUT.t14 VSS 0.03591f
C7145 6to4_0.buff_PI_d32_1.buff_PI_d16$1_0.inv_PI_d8$1_0.VOUT.t13 VSS 0.03179f
C7146 6to4_0.buff_PI_d32_1.buff_PI_d16$1_0.inv_PI_d8$1_0.VOUT.t10 VSS 0.03179f
C7147 6to4_0.buff_PI_d32_1.buff_PI_d16$1_0.inv_PI_d8$1_0.VOUT.t11 VSS 0.03591f
C7148 6to4_0.buff_PI_d32_1.buff_PI_d16$1_0.inv_PI_d8$1_0.VOUT.t9 VSS 0.03581f
C7149 6to4_0.buff_PI_d32_1.buff_PI_d16$1_0.inv_PI_d8$1_0.inv_PI_d4$1_1.inv_PI_d2$1_1.inv_PI$1_1.VOUT VSS 0.0517f
C7150 6to4_0.buff_PI_d32_1.buff_PI_d16$1_0.inv_PI_d8$1_0.VOUT.n35 VSS 0.0667f
C7151 6to4_0.buff_PI_d32_1.buff_PI_d16$1_0.inv_PI_d8$1_0.VOUT.n36 VSS 0.05947f
C7152 6to4_0.buff_PI_d32_1.buff_PI_d16$1_0.inv_PI_d8$1_0.VOUT.n37 VSS 0.04638f
C7153 6to4_0.buff_PI_d32_1.buff_PI_d16$1_0.inv_PI_d8$1_0.inv_PI_d4$1_1.inv_PI_d2$1_1.VOUT VSS 0.01435f
C7154 6to4_0.buff_PI_d32_1.buff_PI_d16$1_0.inv_PI_d8$1_0.VOUT.n38 VSS 0.06544f
C7155 6to4_0.buff_PI_d32_1.buff_PI_d16$1_0.inv_PI_d8$1_0.inv_PI_d4$1_1.inv_PI_d2$1_1.inv_PI$1_0.VOUT VSS 0.01435f
C7156 6to4_0.buff_PI_d32_1.buff_PI_d16$1_0.inv_PI_d8$1_0.VOUT.n39 VSS 0.08589f
C7157 6to4_0.buff_PI_d32_1.buff_PI_d16$1_0.inv_PI_d8$1_0.VOUT.n40 VSS 0.08589f
C7158 6to4_0.buff_PI_d32_1.buff_PI_d16$1_0.inv_PI_d8$1_0.inv_PI_d4$1_1.inv_PI_d2$1_0.inv_PI$1_1.VOUT VSS 0.01435f
C7159 6to4_0.buff_PI_d32_1.buff_PI_d16$1_0.inv_PI_d8$1_0.VOUT.n41 VSS 0.0667f
C7160 6to4_0.buff_PI_d32_1.buff_PI_d16$1_0.inv_PI_d8$1_0.VOUT.n42 VSS 0.05947f
C7161 6to4_0.buff_PI_d32_1.buff_PI_d16$1_0.inv_PI_d8$1_0.VOUT.n43 VSS 0.04638f
C7162 6to4_0.buff_PI_d32_1.buff_PI_d16$1_0.inv_PI_d8$1_0.inv_PI_d4$1_1.inv_PI_d2$1_0.VOUT VSS 0.01435f
C7163 6to4_0.buff_PI_d32_1.buff_PI_d16$1_0.inv_PI_d8$1_0.VOUT.n44 VSS 0.06544f
C7164 6to4_0.buff_PI_d32_1.buff_PI_d16$1_0.inv_PI_d8$1_0.inv_PI_d4$1_1.inv_PI_d2$1_0.inv_PI$1_0.VOUT VSS 0.01019f
C7165 6to4_0.buff_PI_d32_1.buff_PI_d16$1_0.inv_PI_d8$1_0.inv_PI_d4$1_1.VOUT VSS 0.01208f
C7166 6to4_0.buff_PI_d32_1.buff_PI_d16$1_0.inv_PI_d8$1_0.VOUT.n45 VSS 0.07796f
C7167 6to4_0.buff_PI_d32_1.buff_PI_d16$1_0.inv_PI_d8$1_0.VOUT.n46 VSS 0.08589f
C7168 6to4_0.buff_PI_d32_1.buff_PI_d16$1_0.inv_PI_d8$1_0.inv_PI_d4$1_0.inv_PI_d2$1_1.inv_PI$1_1.VOUT VSS 0.01435f
C7169 6to4_0.buff_PI_d32_1.buff_PI_d16$1_0.inv_PI_d8$1_0.VOUT.n47 VSS 0.0667f
C7170 6to4_0.buff_PI_d32_1.buff_PI_d16$1_0.inv_PI_d8$1_0.VOUT.n48 VSS 0.05947f
C7171 6to4_0.buff_PI_d32_1.buff_PI_d16$1_0.inv_PI_d8$1_0.VOUT.n49 VSS 0.04638f
C7172 6to4_0.buff_PI_d32_1.buff_PI_d16$1_0.inv_PI_d8$1_0.inv_PI_d4$1_0.inv_PI_d2$1_1.VOUT VSS 0.01435f
C7173 6to4_0.buff_PI_d32_1.buff_PI_d16$1_0.inv_PI_d8$1_0.VOUT.n50 VSS 0.06544f
C7174 6to4_0.buff_PI_d32_1.buff_PI_d16$1_0.inv_PI_d8$1_0.inv_PI_d4$1_0.inv_PI_d2$1_1.inv_PI$1_0.VOUT VSS 0.01435f
C7175 6to4_0.buff_PI_d32_1.buff_PI_d16$1_0.inv_PI_d8$1_0.VOUT.n51 VSS 0.08589f
C7176 6to4_0.buff_PI_d32_1.buff_PI_d16$1_0.inv_PI_d8$1_0.VOUT.t0 VSS 0.0351f
C7177 6to4_0.buff_PI_d32_1.buff_PI_d16$1_0.inv_PI_d8$1_0.VOUT.n52 VSS 0.08589f
C7178 6to4_0.buff_PI_d32_1.buff_PI_d16$1_0.inv_PI_d8$1_0.inv_PI_d4$1_0.inv_PI_d2$1_0.inv_PI$1_1.VOUT VSS 0.01435f
C7179 6to4_0.buff_PI_d32_1.buff_PI_d16$1_0.inv_PI_d8$1_0.VOUT.n53 VSS 0.0667f
C7180 6to4_0.buff_PI_d32_1.buff_PI_d16$1_0.inv_PI_d8$1_0.VOUT.n54 VSS 0.05947f
C7181 6to4_0.buff_PI_d32_1.buff_PI_d16$1_0.inv_PI_d8$1_0.VOUT.n55 VSS 0.04638f
C7182 6to4_0.buff_PI_d32_1.buff_PI_d16$1_0.inv_PI_d8$1_0.inv_PI_d4$1_0.inv_PI_d2$1_0.VOUT VSS 0.01435f
C7183 6to4_0.buff_PI_d32_1.buff_PI_d16$1_0.inv_PI_d8$1_0.VOUT.n56 VSS 0.06544f
C7184 6to4_0.buff_PI_d32_1.buff_PI_d16$1_0.inv_PI_d8$1_0.inv_PI_d4$1_0.inv_PI_d2$1_0.inv_PI$1_0.VOUT VSS 0.01019f
C7185 6to4_0.buff_PI_d32_1.buff_PI_d16$1_0.inv_PI_d8$1_0.inv_PI_d4$1_0.VOUT VSS 0.01208f
.ends
